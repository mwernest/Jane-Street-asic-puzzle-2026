* Extracted by KLayout with SKY130 LVS runset on : 21/08/2026 11:39

* cell INTERNAL_3
.SUBCKT INTERNAL_3
.ENDS INTERNAL_3

* cell INTERNAL_7
.SUBCKT INTERNAL_7
.ENDS INTERNAL_7

* cell puzzle
.SUBCKT puzzle
* cell instance $1 r0 *1 181.7,16.32
X$1 VPWR VGND VPWR \$148 \$16 \$1 \$31 VGND sky130_fd_sc_hd__o21a_2
* cell instance $2 r0 *1 184.23,17.51
X$2 \$1 VIA_M1M2_PR
* cell instance $3 r0 *1 167.21,11.39
X$3 \$1 VIA_M1M2_PR
* cell instance $4 r0 *1 184.23,9.35
X$4 \$1 VIA_M1M2_PR
* cell instance $5 r0 *1 167.21,9.35
X$5 \$1 VIA_M1M2_PR
* cell instance $6 r0 *1 167.21,11.39
X$6 \$1 VIA_L1M1_PR_MR
* cell instance $7 r0 *1 165.14,10.88
X$7 VPWR VPWR \$89 \$23 \$1 VGND VGND sky130_fd_sc_hd__and2_2
* cell instance $8 r0 *1 184.23,17.51
X$8 \$1 VIA_L1M1_PR_MR
* cell instance $9 r180 *1 176.64,255.68
X$9 VGND \$1363 \$3588 \$3994 VPWR VPWR VGND sky130_fd_sc_hd__dfxtp_2
* cell instance $10 r180 *1 175.72,250.24
X$10 VGND \$1412 \$3588 \$3918 VPWR VPWR VGND sky130_fd_sc_hd__dfxtp_2
* cell instance $11 r0 *1 169.74,250.24
X$11 VGND \$1362 \$3066 \$4002 VPWR VPWR VGND sky130_fd_sc_hd__dfxtp_2
* cell instance $12 m0 *1 172.96,201.28
X$12 VGND rst_n \$2651 \$3066 \$3070 VPWR VPWR VGND sky130_fd_sc_hd__dfstp_2
* cell instance $13 m0 *1 166.98,190.4
X$13 VGND rst_n \$2906 \$2728 \$2988 VPWR VPWR VGND sky130_fd_sc_hd__dfstp_2
* cell instance $14 r0 *1 167.9,190.4
X$14 VGND rst_n \$2752 \$2728 \$2920 VPWR VPWR VGND sky130_fd_sc_hd__dfstp_2
* cell instance $15 m90 *1 182.16,250.24
X$15 VGND \$3813 \$3994 \$3942 \$3868 VPWR VPWR VGND sky130_fd_sc_hd__a21boi_2
* cell instance $16 m90 *1 175.26,239.36
X$16 VGND \$3813 \$3882 \$3861 \$3886 VPWR VPWR VGND sky130_fd_sc_hd__a21boi_2
* cell instance $17 m90 *1 175.26,255.68
X$17 VGND \$3813 \$3918 \$3868 \$1412 VPWR \$I14138 VGND
+ sky130_fd_sc_hd__a21boi_2
* cell instance $18 m90 *1 172.5,217.6
X$18 VGND \$3548 \$3439 \$3492 \$3401 VPWR VPWR VGND sky130_fd_sc_hd__nor3b_2
* cell instance $19 m90 *1 177.56,168.64
X$19 VGND \$2587 \$933 \$2660 \$2569 VPWR VPWR VGND sky130_fd_sc_hd__nor3b_2
* cell instance $20 r180 *1 172.5,217.6
X$20 VGND \$3311 \$3439 \$3401 \$3492 VPWR VPWR VGND sky130_fd_sc_hd__nor3b_2
* cell instance $21 r0 *1 168.82,212.16
X$21 VGND \$3301 \$3401 \$3492 \$3439 VPWR VPWR VGND sky130_fd_sc_hd__nor3b_2
* cell instance $22 r0 *1 164.22,244.8
X$22 VGND \$3439 \$737 \$1103 \$3955 \$3981 VPWR VPWR VGND
+ sky130_fd_sc_hd__a211oi_2
* cell instance $23 r0 *1 34.04,152.32
X$23 VGND \$2324 \$2174 \$2406 \$933 \$1558 VPWR VPWR VGND
+ sky130_fd_sc_hd__a211oi_2
* cell instance $24 r180 *1 129.26,255.68
X$24 VGND \$425 \$340 \$4032 \$864 \$27 VPWR VPWR VGND sky130_fd_sc_hd__and4b_2
* cell instance $25 r0 *1 168.82,277.44
X$25 VGND \$3159 \$375 \$4252 \$3813 \$2455 VPWR VPWR VGND
+ sky130_fd_sc_hd__and4b_2
* cell instance $26 r0 *1 115,125.12
X$26 VGND \$984 \$760 \$1961 \$1050 \$899 VPWR VPWR VGND
+ sky130_fd_sc_hd__and4b_2
* cell instance $27 r180 *1 168.82,255.68
X$27 VGND \$3861 \$1362 \$1363 \$1412 VPWR VPWR VGND sky130_fd_sc_hd__nand3_2
* cell instance $28 m0 *1 166.52,136
X$28 VPWR VPWR \$2029 VGND \$1362 \$1527 \$2112 VGND sky130_fd_sc_hd__and3b_2
* cell instance $29 r180 *1 173.88,136
X$29 VPWR VPWR \$1362 VGND \$1363 \$1527 \$2083 VGND sky130_fd_sc_hd__and3b_2
* cell instance $30 r0 *1 161,174.08
X$30 VPWR VPWR \$2569 VGND \$2670 \$933 \$2702 VGND sky130_fd_sc_hd__and3b_2
* cell instance $31 m90 *1 175.26,223.04
X$31 VGND \$3621 \$3467 \$3742 \$3435 \$3546 VPWR VPWR VGND
+ sky130_fd_sc_hd__o31a_2
* cell instance $32 m90 *1 171.58,223.04
X$32 VGND \$3874 \$3467 \$3658 \$3353 \$3310 VPWR VPWR VGND
+ sky130_fd_sc_hd__o31a_2
* cell instance $33 m0 *1 172.5,223.04
X$33 VGND \$3623 \$3467 \$3736 \$3426 \$3607 VPWR VPWR VGND
+ sky130_fd_sc_hd__o31a_2
* cell instance $34 m0 *1 176.18,217.6
X$34 VGND \$3515 \$3467 \$3516 \$3328 \$3418 VPWR VPWR VGND
+ sky130_fd_sc_hd__o31a_2
* cell instance $35 r180 *1 168.82,179.52
X$35 VGND \$2768 \$1362 \$2640 \$2648 \$2705 VPWR VPWR VGND
+ sky130_fd_sc_hd__o31a_2
* cell instance $36 r180 *1 177.56,228.48
X$36 VGND \$3734 \$3467 \$3732 \$3445 \$3369 VPWR VPWR VGND
+ sky130_fd_sc_hd__o31a_2
* cell instance $37 r180 *1 172.5,223.04
X$37 VGND \$3627 \$3467 \$3637 \$3540 \$3491 VPWR VPWR VGND
+ sky130_fd_sc_hd__o31a_2
* cell instance $38 r0 *1 172.5,217.6
X$38 VGND \$3497 \$3467 \$3500 \$3331 \$3428 VPWR VPWR VGND
+ sky130_fd_sc_hd__o31a_2
* cell instance $39 r0 *1 178.02,217.6
X$39 VGND \$3504 \$3467 \$3506 \$3339 \$3508 VPWR VPWR VGND
+ sky130_fd_sc_hd__o31a_2
* cell instance $40 r180 *1 174.8,146.88
X$40 VGND \$2251 \$2237 \$2325 \$2404 \$2235 VPWR \$I13963 VGND
+ sky130_fd_sc_hd__o31a_2
* cell instance $41 m0 *1 168.36,157.76
X$41 VPWR VPWR VGND sky130_fd_sc_hd__conb_1
* cell instance $42 m0 *1 168.82,108.8
X$42 \$I13928 VPWR VGND sky130_fd_sc_hd__conb_1
* cell instance $43 r0 *1 170.66,141.44
X$43 \$I13963 VPWR VGND sky130_fd_sc_hd__conb_1
* cell instance $44 r0 *1 77.28,97.92
X$44 VPWR VPWR VGND sky130_fd_sc_hd__conb_1
* cell instance $45 r0 *1 170.2,125.12
X$45 VPWR VPWR VGND sky130_fd_sc_hd__conb_1
* cell instance $46 m90 *1 93.84,108.8
X$46 VGND \$1271 \$1875 VPWR VPWR VGND sky130_fd_sc_hd__clkbuf_8
* cell instance $47 m90 *1 122.36,250.24
X$47 VGND \$1271 \$3889 VPWR VPWR VGND sky130_fd_sc_hd__clkbuf_8
* cell instance $48 m90 *1 91.08,76.16
X$48 VGND \$1271 \$785 VPWR VPWR VGND sky130_fd_sc_hd__clkbuf_8
* cell instance $49 m90 *1 65.32,146.88
X$49 VGND \$1271 \$2217 VPWR VPWR VGND sky130_fd_sc_hd__clkbuf_8
* cell instance $50 m0 *1 119.6,250.24
X$50 VGND \$1271 \$3828 VPWR VPWR VGND sky130_fd_sc_hd__clkbuf_8
* cell instance $51 m0 *1 72.68,152.32
X$51 VGND \$1271 \$2288 VPWR VPWR VGND sky130_fd_sc_hd__clkbuf_8
* cell instance $52 m0 *1 108.1,206.72
X$52 VGND \$1271 \$3250 VPWR VPWR VGND sky130_fd_sc_hd__clkbuf_8
* cell instance $53 m0 *1 100.74,201.28
X$53 VGND \$1271 \$2294 VPWR VPWR VGND sky130_fd_sc_hd__clkbuf_8
* cell instance $54 m0 *1 118.68,87.04
X$54 VGND \$1271 \$983 VPWR VPWR VGND sky130_fd_sc_hd__clkbuf_8
* cell instance $55 m0 *1 73.14,108.8
X$55 VGND \$1271 \$1649 VPWR VPWR VGND sky130_fd_sc_hd__clkbuf_8
* cell instance $56 r180 *1 126.04,92.48
X$56 VGND \$1271 \$1459 VPWR VPWR VGND sky130_fd_sc_hd__clkbuf_8
* cell instance $57 r0 *1 156.86,179.52
X$57 VGND \$1271 \$2728 VPWR VPWR VGND sky130_fd_sc_hd__clkbuf_8
* cell instance $58 m90 *1 156.86,179.52
X$58 VPWR \$2773 \$1362 \$1412 VGND VPWR \$1363 VGND sky130_fd_sc_hd__or3b_2
* cell instance $59 m0 *1 156.86,228.48
X$59 VGND \$1271 \$3588 VPWR \$I13875 VGND sky130_fd_sc_hd__clkbuf_8
* cell instance $60 r180 *1 151.34,179.52
X$60 VGND \$1271 \$2156 VPWR \$I13868 VGND sky130_fd_sc_hd__clkbuf_8
* cell instance $61 r0 *1 146.28,223.04
X$61 VGND \$1271 \$3066 VPWR \$I13866 VGND sky130_fd_sc_hd__clkbuf_8
* cell instance $62 m90 *1 77.74,141.44
X$62 VPWR VGND VPWR \$2288 VGND sky130_fd_sc_hd__clkbuf_4
* cell instance $63 m90 *1 159.62,223.04
X$63 \$I13875 VGND VPWR \$3588 VGND sky130_fd_sc_hd__clkbuf_4
* cell instance $64 m90 *1 112.24,206.72
X$64 VPWR VGND VPWR \$3250 VGND sky130_fd_sc_hd__clkbuf_4
* cell instance $65 m0 *1 84.64,114.24
X$65 VPWR VGND VPWR \$1875 VGND sky130_fd_sc_hd__clkbuf_4
* cell instance $66 m0 *1 126.04,92.48
X$66 VPWR VGND VPWR \$1459 VGND sky130_fd_sc_hd__clkbuf_4
* cell instance $67 m0 *1 127.88,250.24
X$67 VPWR VGND VPWR \$3828 VGND sky130_fd_sc_hd__clkbuf_4
* cell instance $68 m0 *1 123.74,87.04
X$68 VPWR VGND VPWR \$983 VGND sky130_fd_sc_hd__clkbuf_4
* cell instance $69 m0 *1 70.38,108.8
X$69 VPWR VGND VPWR \$1649 VGND sky130_fd_sc_hd__clkbuf_4
* cell instance $70 r180 *1 158.24,179.52
X$70 VPWR VGND VPWR \$2728 VGND sky130_fd_sc_hd__clkbuf_4
* cell instance $71 r0 *1 83.26,76.16
X$71 VPWR VGND VPWR \$785 VGND sky130_fd_sc_hd__clkbuf_4
* cell instance $72 r0 *1 146.28,174.08
X$72 \$I13868 VGND VPWR \$2156 VGND sky130_fd_sc_hd__clkbuf_4
* cell instance $73 r0 *1 114.54,250.24
X$73 VPWR VGND VPWR \$3889 VGND sky130_fd_sc_hd__clkbuf_4
* cell instance $74 r0 *1 57.5,146.88
X$74 VPWR VGND VPWR \$2217 VGND sky130_fd_sc_hd__clkbuf_4
* cell instance $75 r0 *1 100.74,195.84
X$75 VPWR VGND VPWR \$2294 VGND sky130_fd_sc_hd__clkbuf_4
* cell instance $76 m0 *1 168.82,288.32
X$76 VPWR \$375 VPWR VGND sky130_fd_sc_hd__diode_2
* cell instance $77 m0 *1 168.82,272
X$77 \$I13629 \$375 VPWR VGND sky130_fd_sc_hd__diode_2
* cell instance $78 m0 *1 168.82,277.44
X$78 VPWR \$375 VPWR VGND sky130_fd_sc_hd__diode_2
* cell instance $79 m0 *1 171.12,266.56
X$79 \$I13627 \$692 VPWR VGND sky130_fd_sc_hd__diode_2
* cell instance $80 m0 *1 170.2,272
X$80 \$I13626 \$692 VPWR VGND sky130_fd_sc_hd__diode_2
* cell instance $81 r0 *1 170.2,233.92
X$81 \$I13625 VGND VPWR VGND sky130_fd_sc_hd__diode_2
* cell instance $82 r0 *1 167.9,277.44
X$82 VPWR \$375 VPWR VGND sky130_fd_sc_hd__diode_2
* cell instance $83 r0 *1 171.12,266.56
X$83 \$I13626 \$692 VPWR VGND sky130_fd_sc_hd__diode_2
* cell instance $84 r0 *1 29.9,195.84
X$84 \$I13622 enable VPWR VGND sky130_fd_sc_hd__diode_2
* cell instance $85 m90 *1 167.9,250.24
X$85 VPWR \$I13772 VGND \$1103 success \$737 VPWR \$3913 \$I13780 \$3981
+ \$I13705 \$I13721 \$I13742 VGND sky130_fd_sc_hd__or4b_2
* cell instance $86 m90 *1 124.2,141.44
X$86 VPWR \$I13773 VGND \$984 \$760 \$899 VPWR \$2068 \$I13781 \$1050 \$I13704
+ \$I13720 \$I13743 VGND sky130_fd_sc_hd__or4b_2
* cell instance $87 m90 *1 115.92,206.72
X$87 VPWR \$I13771 VGND \$425 \$864 \$340 VPWR \$3292 \$I13782 \$27 \$I13703
+ \$I13719 \$I13741 VGND sky130_fd_sc_hd__or4b_2
* cell instance $88 m0 *1 113.62,272
X$88 VPWR \$I14185 VGND \$425 \$340 \$27 VPWR \$4142 \$I14176 \$864 \$I13844
+ \$I13718 \$I14188 VGND sky130_fd_sc_hd__or4b_2
* cell instance $89 m0 *1 113.62,201.28
X$89 VPWR \$I13847 VGND \$425 \$864 \$27 VPWR \$3175 \$I13849 \$340 \$I13845
+ \$I13717 \$I13725 VGND sky130_fd_sc_hd__or4b_2
* cell instance $90 r180 *1 118.68,87.04
X$90 VPWR \$I13692 VGND \$1050 \$760 \$899 VPWR \$1404 \$I13708 \$984 \$I13700
+ \$I13716 \$I13724 VGND sky130_fd_sc_hd__or4b_2
* cell instance $91 r180 *1 120.52,228.48
X$91 VPWR \$I13981 VGND \$864 \$340 \$27 VPWR \$3706 \$I13984 \$425 \$I13699
+ \$I13715 \$I13972 VGND sky130_fd_sc_hd__or4b_2
* cell instance $92 r0 *1 111.32,70.72
X$92 VPWR \$I13690 VGND \$984 \$1050 \$760 VPWR \$1273 \$I13706 \$899 \$I13698
+ \$I13714 \$I13722 VGND sky130_fd_sc_hd__or4b_2
* cell instance $93 m0 *1 115.92,195.84
X$93 VGND \$3116 \$27 \$340 \$864 \$425 VPWR \$I13591 VGND
+ sky130_fd_sc_hd__nor4_2
* cell instance $94 r0 *1 56.44,27.53
X$94 VPWR VIA_via5_6_2000_2000_1_1_1600_1600
* cell instance $95 r0 *1 56.44,87.53
X$95 VPWR VIA_via5_6_2000_2000_1_1_1600_1600
* cell instance $96 r0 *1 26.44,207.53
X$96 VPWR VIA_via5_6_2000_2000_1_1_1600_1600
* cell instance $97 r0 *1 56.44,57.53
X$97 VPWR VIA_via5_6_2000_2000_1_1_1600_1600
* cell instance $98 r0 *1 86.44,117.53
X$98 VPWR VIA_via5_6_2000_2000_1_1_1600_1600
* cell instance $99 r0 *1 146.44,207.53
X$99 VPWR VIA_via5_6_2000_2000_1_1_1600_1600
* cell instance $100 r0 *1 146.44,57.53
X$100 VPWR VIA_via5_6_2000_2000_1_1_1600_1600
* cell instance $101 r0 *1 146.44,147.53
X$101 VPWR VIA_via5_6_2000_2000_1_1_1600_1600
* cell instance $102 r0 *1 176.44,87.53
X$102 VPWR VIA_via5_6_2000_2000_1_1_1600_1600
* cell instance $103 r0 *1 146.44,267.53
X$103 VPWR VIA_via5_6_2000_2000_1_1_1600_1600
* cell instance $104 r0 *1 56.44,117.53
X$104 VPWR VIA_via5_6_2000_2000_1_1_1600_1600
* cell instance $105 r0 *1 116.44,27.53
X$105 VPWR VIA_via5_6_2000_2000_1_1_1600_1600
* cell instance $106 r0 *1 56.44,237.53
X$106 VPWR VIA_via5_6_2000_2000_1_1_1600_1600
* cell instance $107 r0 *1 56.44,207.53
X$107 VPWR VIA_via5_6_2000_2000_1_1_1600_1600
* cell instance $108 r0 *1 146.44,27.53
X$108 VPWR VIA_via5_6_2000_2000_1_1_1600_1600
* cell instance $109 r0 *1 86.44,237.53
X$109 VPWR VIA_via5_6_2000_2000_1_1_1600_1600
* cell instance $110 r0 *1 176.44,27.53
X$110 VPWR VIA_via5_6_2000_2000_1_1_1600_1600
* cell instance $111 r0 *1 146.44,237.53
X$111 VPWR VIA_via5_6_2000_2000_1_1_1600_1600
* cell instance $112 r0 *1 56.44,267.53
X$112 VPWR VIA_via5_6_2000_2000_1_1_1600_1600
* cell instance $113 r0 *1 26.44,177.53
X$113 VPWR VIA_via5_6_2000_2000_1_1_1600_1600
* cell instance $114 r0 *1 26.44,147.53
X$114 VPWR VIA_via5_6_2000_2000_1_1_1600_1600
* cell instance $115 r0 *1 176.44,117.53
X$115 VPWR VIA_via5_6_2000_2000_1_1_1600_1600
* cell instance $116 r0 *1 176.44,207.53
X$116 VPWR VIA_via5_6_2000_2000_1_1_1600_1600
* cell instance $117 r0 *1 116.44,207.53
X$117 VPWR VIA_via5_6_2000_2000_1_1_1600_1600
* cell instance $118 r0 *1 86.44,267.53
X$118 VPWR VIA_via5_6_2000_2000_1_1_1600_1600
* cell instance $119 r0 *1 116.44,267.53
X$119 VPWR VIA_via5_6_2000_2000_1_1_1600_1600
* cell instance $120 r0 *1 26.44,117.53
X$120 VPWR VIA_via5_6_2000_2000_1_1_1600_1600
* cell instance $121 r0 *1 86.44,27.53
X$121 VPWR VIA_via5_6_2000_2000_1_1_1600_1600
* cell instance $122 r0 *1 146.44,177.53
X$122 VPWR VIA_via5_6_2000_2000_1_1_1600_1600
* cell instance $123 r0 *1 86.44,207.53
X$123 VPWR VIA_via5_6_2000_2000_1_1_1600_1600
* cell instance $124 r0 *1 146.44,117.53
X$124 VPWR VIA_via5_6_2000_2000_1_1_1600_1600
* cell instance $125 r0 *1 26.44,237.53
X$125 VPWR VIA_via5_6_2000_2000_1_1_1600_1600
* cell instance $126 r0 *1 146.44,87.53
X$126 VPWR VIA_via5_6_2000_2000_1_1_1600_1600
* cell instance $127 r0 *1 26.44,27.53
X$127 VPWR VIA_via5_6_2000_2000_1_1_1600_1600
* cell instance $128 r0 *1 26.44,267.53
X$128 VPWR VIA_via5_6_2000_2000_1_1_1600_1600
* cell instance $129 r0 *1 176.44,147.53
X$129 VPWR VIA_via5_6_2000_2000_1_1_1600_1600
* cell instance $130 r0 *1 116.44,117.53
X$130 VPWR VIA_via5_6_2000_2000_1_1_1600_1600
* cell instance $131 r0 *1 116.44,237.53
X$131 VPWR VIA_via5_6_2000_2000_1_1_1600_1600
* cell instance $132 r0 *1 86.44,87.53
X$132 VPWR VIA_via5_6_2000_2000_1_1_1600_1600
* cell instance $133 r0 *1 116.44,57.53
X$133 VPWR VIA_via5_6_2000_2000_1_1_1600_1600
* cell instance $134 r0 *1 176.44,177.53
X$134 VPWR VIA_via5_6_2000_2000_1_1_1600_1600
* cell instance $135 r0 *1 56.44,147.53
X$135 VPWR VIA_via5_6_2000_2000_1_1_1600_1600
* cell instance $136 r0 *1 176.44,57.53
X$136 VPWR VIA_via5_6_2000_2000_1_1_1600_1600
* cell instance $137 r0 *1 116.44,87.53
X$137 VPWR VIA_via5_6_2000_2000_1_1_1600_1600
* cell instance $138 r0 *1 86.44,177.53
X$138 VPWR VIA_via5_6_2000_2000_1_1_1600_1600
* cell instance $139 r0 *1 56.44,177.53
X$139 VPWR VIA_via5_6_2000_2000_1_1_1600_1600
* cell instance $140 r0 *1 26.44,87.53
X$140 VPWR VIA_via5_6_2000_2000_1_1_1600_1600
* cell instance $141 r0 *1 86.44,57.53
X$141 VPWR VIA_via5_6_2000_2000_1_1_1600_1600
* cell instance $142 r0 *1 86.44,147.53
X$142 VPWR VIA_via5_6_2000_2000_1_1_1600_1600
* cell instance $143 r0 *1 176.44,267.53
X$143 VPWR VIA_via5_6_2000_2000_1_1_1600_1600
* cell instance $144 r0 *1 176.44,237.53
X$144 VPWR VIA_via5_6_2000_2000_1_1_1600_1600
* cell instance $145 r0 *1 116.44,147.53
X$145 VPWR VIA_via5_6_2000_2000_1_1_1600_1600
* cell instance $146 r0 *1 116.44,177.53
X$146 VPWR VIA_via5_6_2000_2000_1_1_1600_1600
* cell instance $147 m90 *1 115.92,76.16
X$147 VGND \$1287 \$1288 \$933 I VPWR \$1261 VPWR VGND sky130_fd_sc_hd__nand4_2
* cell instance $148 m90 *1 116.84,233.92
X$148 VGND \$3793 \$3791 \$933 I VPWR \$3824 VPWR VGND sky130_fd_sc_hd__nand4_2
* cell instance $149 m90 *1 115.92,255.68
X$149 VGND \$4032 \$4031 \$933 I VPWR \$4123 VPWR VGND sky130_fd_sc_hd__nand4_2
* cell instance $150 m90 *1 116.38,277.44
X$150 VGND \$4242 \$4197 \$933 I VPWR \$4238 VPWR VGND sky130_fd_sc_hd__nand4_2
* cell instance $151 m0 *1 115,92.48
X$151 VGND \$1438 \$1453 \$933 I VPWR \$1582 VPWR VGND sky130_fd_sc_hd__nand4_2
* cell instance $152 m0 *1 113.62,136
X$152 VGND \$2019 \$2017 \$933 I VPWR \$2076 VPWR VGND sky130_fd_sc_hd__nand4_2
* cell instance $153 r180 *1 118.22,146.88
X$153 VGND \$2146 \$2212 \$933 I VPWR \$2293 VPWR VGND sky130_fd_sc_hd__nand4_2
* cell instance $154 r180 *1 118.22,108.8
X$154 VGND \$1740 \$1742 \$933 I VPWR \$1743 VPWR VGND sky130_fd_sc_hd__nand4_2
* cell instance $155 r180 *1 120.52,223.04
X$155 VGND \$3575 \$3482 \$933 I VPWR \$3532 VPWR VGND sky130_fd_sc_hd__nand4_2
* cell instance $156 r180 *1 120.52,255.68
X$156 VGND \$4020 \$3906 \$933 I VPWR \$3907 VPWR VGND sky130_fd_sc_hd__nand4_2
* cell instance $157 r180 *1 113.16,288.32
X$157 VGND \$4294 \$4285 \$933 I VPWR \$4352 VPWR VGND sky130_fd_sc_hd__nand4_2
* cell instance $158 r180 *1 180.32,250.24
X$158 VGND \$1412 \$1363 \$1362 \$1527 VPWR \$3868 VPWR VGND
+ sky130_fd_sc_hd__nand4_2
* cell instance $159 m90 *1 119.6,119.68
X$159 VGND \$1961 \$1960 \$933 I VPWR \$1958 \$I13390 VGND
+ sky130_fd_sc_hd__nand4_2
* cell instance $160 m90 *1 120.52,190.4
X$160 VGND \$3116 \$2895 \$933 I VPWR \$2889 \$I13591 VGND
+ sky130_fd_sc_hd__nand4_2
* cell instance $161 m90 *1 177.1,54.4
X$161 \$I13345 VPWR \$31 VGND \$37 \$150 \$49 VGND sky130_fd_sc_hd__o21ai_2
* cell instance $162 m90 *1 181.24,168.64
X$162 VPWR VPWR I VGND \$2569 \$2568 \$2588 VGND sky130_fd_sc_hd__o21ai_2
* cell instance $163 m90 *1 176.18,136
X$163 \$I13343 VPWR \$1363 VGND \$1362 \$2168 \$1527 VGND
+ sky130_fd_sc_hd__o21ai_2
* cell instance $164 m0 *1 178.94,174.08
X$164 VPWR VPWR \$2654 VGND \$2567 \$2754 \$2662 VGND sky130_fd_sc_hd__o21ai_2
* cell instance $165 r180 *1 179.86,54.4
X$165 VPWR VPWR \$572 VGND \$676 \$1073 \$205 VGND sky130_fd_sc_hd__o21ai_2
* cell instance $166 m0 *1 165.14,223.04
X$166 VPWR \$3492 \$3592 VGND \$3439 VPWR \$3401 VGND sky130_fd_sc_hd__nor3_2
* cell instance $167 r180 *1 171.12,114.24
X$167 VPWR \$1362 \$1842 VGND \$1412 VPWR \$1363 VGND sky130_fd_sc_hd__nor3_2
* cell instance $168 r180 *1 178.02,97.92
X$168 VPWR \$1427 \$1424 VGND \$1362 VPWR \$1467 VGND sky130_fd_sc_hd__nor3_2
* cell instance $169 r180 *1 72.68,152.32
X$169 VGND \$2285 \$2224 VPWR \$1733 \$2135 \$2420 VPWR VPWR VGND
+ sky130_fd_sc_hd__a221o_2
* cell instance $170 m0 *1 184.46,184.96
X$170 VGND \$2834 \$2660 \$2579 \$933 \$2752 \$3084 VPWR VPWR VGND
+ sky130_fd_sc_hd__a221o_2
* cell instance $171 r180 *1 164.68,195.84
X$171 VGND \$3060 \$2834 \$3056 \$933 \$2651 \$3052 VPWR VPWR VGND
+ sky130_fd_sc_hd__a221o_2
* cell instance $172 r0 *1 184,190.4
X$172 VGND \$3080 \$2813 \$2834 \$933 \$2657 \$2827 VPWR VPWR VGND
+ sky130_fd_sc_hd__a221o_2
* cell instance $173 r0 *1 184,179.52
X$173 VGND \$2667 \$2834 \$2815 \$933 \$2732 \$2743 VPWR VPWR VGND
+ sky130_fd_sc_hd__a221o_2
* cell instance $174 m0 *1 171.12,114.24
X$174 VGND \$1832 \$1412 \$1363 \$1362 \$1527 VPWR VPWR VGND
+ sky130_fd_sc_hd__nor4b_2
* cell instance $175 m90 *1 172.96,168.64
X$175 VGND \$2681 \$2654 \$2596 \$2689 \$2567 \$2600 VPWR VPWR VGND
+ sky130_fd_sc_hd__o32a_2
* cell instance $176 r180 *1 164.68,190.4
X$176 VGND \$2920 \$2748 \$2702 \$3145 \$2752 \$2910 VPWR VPWR VGND
+ sky130_fd_sc_hd__o32a_2
* cell instance $177 r180 *1 181.24,43.52
X$177 VGND \$811 \$49 \$519 \$65 \$380 \$389 VPWR VPWR VGND
+ sky130_fd_sc_hd__o32a_2
* cell instance $178 m90 *1 90.62,54.4
X$178 VGND rst_n \$1126 \$729 \$1026 VPWR VPWR VGND sky130_fd_sc_hd__dfrtp_2
* cell instance $179 m90 *1 126.04,244.8
X$179 VGND rst_n \$3906 \$3828 \$3951 VPWR VPWR VGND sky130_fd_sc_hd__dfrtp_2
* cell instance $180 m90 *1 122.82,212.16
X$180 VGND rst_n \$3381 \$3066 \$3385 VPWR VPWR VGND sky130_fd_sc_hd__dfrtp_2
* cell instance $181 m90 *1 90.62,38.08
X$181 VGND rst_n \$689 \$729 \$686 VPWR VPWR VGND sky130_fd_sc_hd__dfrtp_2
* cell instance $182 r180 *1 93.38,43.52
X$182 VGND \$737 \$689 \$688 \$609 \$730 VPWR VPWR VGND sky130_fd_sc_hd__nor4b_2
* cell instance $183 m90 *1 124.66,108.8
X$183 VGND rst_n \$1742 \$1459 \$1768 VPWR \$I12730 VGND
+ sky130_fd_sc_hd__dfrtp_2
* cell instance $184 m90 *1 85.1,146.88
X$184 VGND rst_n \$2222 \$2288 \$2266 VPWR VPWR VGND sky130_fd_sc_hd__dfrtp_2
* cell instance $185 m90 *1 91.54,157.76
X$185 VGND rst_n \$2462 \$2294 \$2530 VPWR VPWR VGND sky130_fd_sc_hd__dfrtp_2
* cell instance $186 m90 *1 41.86,92.48
X$186 VGND rst_n \$348 \$785 \$1537 VPWR VPWR VGND sky130_fd_sc_hd__dfrtp_2
* cell instance $187 m90 *1 39.56,201.28
X$187 VGND rst_n \$3159 \$2294 \$3217 VPWR VPWR VGND sky130_fd_sc_hd__dfrtp_2
* cell instance $188 m90 *1 123.74,136
X$188 VGND rst_n \$2020 \$2156 \$2141 VPWR VPWR VGND sky130_fd_sc_hd__dfrtp_2
* cell instance $189 m90 *1 42.78,103.36
X$189 VGND rst_n \$416 \$1649 \$1765 VPWR VPWR VGND sky130_fd_sc_hd__dfrtp_2
* cell instance $190 m90 *1 91.54,136
X$190 VGND rst_n \$2186 \$1875 \$2136 VPWR VPWR VGND sky130_fd_sc_hd__dfrtp_2
* cell instance $191 m90 *1 124.66,70.72
X$191 VGND rst_n \$1220 \$983 \$1244 VPWR VPWR VGND sky130_fd_sc_hd__dfrtp_2
* cell instance $192 m0 *1 114.08,184.96
X$192 VGND rst_n \$2851 \$2294 \$2793 VPWR \$I12721 VGND
+ sky130_fd_sc_hd__dfrtp_2
* cell instance $193 m0 *1 74.98,146.88
X$193 VGND rst_n \$2264 \$2217 \$2423 VPWR VPWR VGND sky130_fd_sc_hd__dfrtp_2
* cell instance $194 m0 *1 87.86,152.32
X$194 VGND rst_n \$2265 \$2288 \$2438 VPWR VPWR VGND sky130_fd_sc_hd__dfrtp_2
* cell instance $195 m0 *1 123.28,97.92
X$195 VGND rst_n \$1618 \$1459 \$1764 VPWR VPWR VGND sky130_fd_sc_hd__dfrtp_2
* cell instance $196 m0 *1 168.82,179.52
X$196 VGND rst_n \$2732 \$2156 \$2762 VPWR VPWR VGND sky130_fd_sc_hd__dfrtp_2
* cell instance $197 m0 *1 174.8,184.96
X$197 VGND rst_n \$2813 \$2728 \$2827 VPWR VPWR VGND sky130_fd_sc_hd__dfrtp_2
* cell instance $198 m0 *1 114.08,125.12
X$198 VGND rst_n \$1960 \$1875 \$2002 VPWR \$I13390 VGND
+ sky130_fd_sc_hd__dfrtp_2
* cell instance $199 m0 *1 114.08,65.28
X$199 VGND rst_n \$1140 \$729 \$1224 VPWR VPWR VGND sky130_fd_sc_hd__dfrtp_2
* cell instance $200 m0 *1 75.9,48.96
X$200 VGND rst_n \$929 \$785 \$975 VPWR VPWR VGND sky130_fd_sc_hd__dfrtp_2
* cell instance $201 m0 *1 113.62,261.12
X$201 VGND rst_n \$4090 \$3889 \$4127 VPWR VPWR VGND sky130_fd_sc_hd__dfrtp_2
* cell instance $202 m0 *1 115.92,212.16
X$202 VGND rst_n \$3388 \$3250 \$3441 VPWR VPWR VGND sky130_fd_sc_hd__dfrtp_2
* cell instance $203 m0 *1 118.22,48.96
X$203 VGND rst_n \$879 \$983 \$882 VPWR VPWR VGND sky130_fd_sc_hd__dfrtp_2
* cell instance $204 m0 *1 114.08,244.8
X$204 VGND rst_n \$3902 \$3889 \$3848 VPWR VPWR VGND sky130_fd_sc_hd__dfrtp_2
* cell instance $205 m0 *1 26.22,152.32
X$205 VGND rst_n \$340 \$2217 \$2492 VPWR VPWR VGND sky130_fd_sc_hd__dfrtp_2
* cell instance $206 m0 *1 115,76.16
X$206 VGND rst_n \$1288 \$729 \$1302 VPWR VPWR VGND sky130_fd_sc_hd__dfrtp_2
* cell instance $207 m0 *1 113.62,233.92
X$207 VGND rst_n \$3692 \$3250 \$3749 VPWR VPWR VGND sky130_fd_sc_hd__dfrtp_2
* cell instance $208 m0 *1 115.92,282.88
X$208 VGND rst_n \$4168 \$3889 \$4171 VPWR VPWR VGND sky130_fd_sc_hd__dfrtp_2
* cell instance $209 m0 *1 172.04,282.88
X$209 VGND rst_n success \$3588 \$4257 VPWR VPWR VGND sky130_fd_sc_hd__dfrtp_2
* cell instance $210 m0 *1 114.08,217.6
X$210 VGND rst_n \$3476 \$3250 \$3535 VPWR VPWR VGND sky130_fd_sc_hd__dfrtp_2
* cell instance $211 m0 *1 77.74,157.76
X$211 VGND rst_n \$2458 \$2217 \$2523 VPWR VPWR VGND sky130_fd_sc_hd__dfrtp_2
* cell instance $212 r180 *1 123.28,206.72
X$212 VGND rst_n \$3178 \$3066 \$3264 VPWR VPWR VGND sky130_fd_sc_hd__dfrtp_2
* cell instance $213 r180 *1 123.28,97.92
X$213 VGND rst_n \$1555 \$1459 \$1557 VPWR VPWR VGND sky130_fd_sc_hd__dfrtp_2
* cell instance $214 r180 *1 127.88,108.8
X$214 VGND rst_n \$1782 \$1459 \$1937 VPWR VPWR VGND sky130_fd_sc_hd__dfrtp_2
* cell instance $215 r180 *1 124.66,141.44
X$215 VGND rst_n \$2017 \$2156 \$2125 VPWR VPWR VGND sky130_fd_sc_hd__dfrtp_2
* cell instance $216 r180 *1 183.54,195.84
X$216 VGND rst_n \$2657 \$2728 \$3100 VPWR VPWR VGND sky130_fd_sc_hd__dfrtp_2
* cell instance $217 r180 *1 123.28,239.36
X$217 VGND rst_n \$3785 \$3828 \$3788 VPWR VPWR VGND sky130_fd_sc_hd__dfrtp_2
* cell instance $218 r180 *1 35.88,146.88
X$218 VGND rst_n \$425 \$2217 \$2246 VPWR VPWR VGND sky130_fd_sc_hd__dfrtp_2
* cell instance $219 r180 *1 123.28,81.6
X$219 VGND rst_n \$1272 \$983 \$1299 VPWR VPWR VGND sky130_fd_sc_hd__dfrtp_2
* cell instance $220 r180 *1 87.4,152.32
X$220 VGND rst_n \$2376 \$2288 \$2437 VPWR VPWR VGND sky130_fd_sc_hd__dfrtp_2
* cell instance $221 r180 *1 124.66,130.56
X$221 VGND rst_n \$2021 \$2156 \$2053 VPWR VPWR VGND sky130_fd_sc_hd__dfrtp_2
* cell instance $222 r180 *1 86.48,43.52
X$222 VGND rst_n \$782 \$785 \$734 VPWR VPWR VGND sky130_fd_sc_hd__dfrtp_2
* cell instance $223 r180 *1 87.4,59.84
X$223 VGND rst_n \$979 \$729 \$1092 VPWR VPWR VGND sky130_fd_sc_hd__dfrtp_2
* cell instance $224 r180 *1 123.28,288.32
X$224 VGND rst_n \$4318 \$3828 \$4287 VPWR VPWR VGND sky130_fd_sc_hd__dfrtp_2
* cell instance $225 r180 *1 123.28,277.44
X$225 VGND rst_n \$4189 \$3828 \$4188 VPWR VPWR VGND sky130_fd_sc_hd__dfrtp_2
* cell instance $226 r180 *1 87.4,136
X$226 VGND rst_n \$2104 \$1875 \$2108 VPWR VPWR VGND sky130_fd_sc_hd__dfrtp_2
* cell instance $227 r180 *1 127.88,136
X$227 VGND rst_n \$2052 \$2156 \$2195 VPWR VPWR VGND sky130_fd_sc_hd__dfrtp_2
* cell instance $228 r180 *1 127.88,146.88
X$228 VGND rst_n \$2229 \$2156 \$2253 VPWR VPWR VGND sky130_fd_sc_hd__dfrtp_2
* cell instance $229 r180 *1 86.48,141.44
X$229 VGND rst_n \$2223 \$1875 \$2190 VPWR VPWR VGND sky130_fd_sc_hd__dfrtp_2
* cell instance $230 r0 *1 116.38,217.6
X$230 VGND rst_n \$3482 \$3250 \$3635 VPWR VPWR VGND sky130_fd_sc_hd__dfrtp_2
* cell instance $231 r0 *1 79.12,108.8
X$231 VGND rst_n \$1729 \$1649 \$1774 VPWR VPWR VGND sky130_fd_sc_hd__dfrtp_2
* cell instance $232 r0 *1 80.96,92.48
X$232 VGND rst_n \$1512 \$1649 \$1620 VPWR VPWR VGND sky130_fd_sc_hd__dfrtp_2
* cell instance $233 r0 *1 115,81.6
X$233 VGND rst_n \$1281 \$729 \$1386 VPWR VPWR VGND sky130_fd_sc_hd__dfrtp_2
* cell instance $234 r0 *1 28.98,157.76
X$234 VGND rst_n \$864 \$2217 \$2542 VPWR VPWR VGND sky130_fd_sc_hd__dfrtp_2
* cell instance $235 m0 *1 28.98,163.2
X$235 VGND \$2578 \$2542 \$864 \$2321 \$1558 \$933 VPWR VPWR VGND
+ sky130_fd_sc_hd__a221oi_2
* cell instance $236 r0 *1 115.92,76.16
X$236 VGND rst_n \$1221 \$983 \$1256 VPWR VPWR VGND sky130_fd_sc_hd__dfrtp_2
* cell instance $237 r0 *1 115.92,114.24
X$237 VGND rst_n \$1879 \$1875 \$1878 VPWR VPWR VGND sky130_fd_sc_hd__dfrtp_2
* cell instance $238 r0 *1 30.82,146.88
X$238 VGND rst_n \$27 \$2217 \$2324 VPWR VPWR VGND sky130_fd_sc_hd__dfrtp_2
* cell instance $239 r0 *1 81.88,97.92
X$239 VGND rst_n \$1652 \$1649 \$1571 VPWR VPWR VGND sky130_fd_sc_hd__dfrtp_2
* cell instance $240 r0 *1 115.92,282.88
X$240 VGND rst_n \$4285 \$3889 \$4290 VPWR VPWR VGND sky130_fd_sc_hd__dfrtp_2
* cell instance $241 r0 *1 115.92,255.68
X$241 VGND rst_n \$4031 \$3828 \$4030 VPWR VPWR VGND sky130_fd_sc_hd__dfrtp_2
* cell instance $242 r0 *1 115.92,206.72
X$242 VGND rst_n \$3168 \$3066 \$3176 VPWR VPWR VGND sky130_fd_sc_hd__dfrtp_2
* cell instance $243 r0 *1 85.1,146.88
X$243 VGND rst_n \$2224 \$2288 \$2352 VPWR VPWR VGND sky130_fd_sc_hd__dfrtp_2
* cell instance $244 r0 *1 84.18,152.32
X$244 VGND rst_n \$2377 \$2288 \$2379 VPWR VPWR VGND sky130_fd_sc_hd__dfrtp_2
* cell instance $245 r0 *1 167.9,195.84
X$245 VGND rst_n \$3056 \$2728 \$3052 VPWR VPWR VGND sky130_fd_sc_hd__dfrtp_2
* cell instance $246 r0 *1 82.8,141.44
X$246 VGND rst_n \$2135 \$1875 \$2138 VPWR VPWR VGND sky130_fd_sc_hd__dfrtp_2
* cell instance $247 r0 *1 76.82,163.2
X$247 VGND rst_n \$2548 \$2294 \$2602 VPWR \$I12667 VGND
+ sky130_fd_sc_hd__dfrtp_2
* cell instance $248 r0 *1 115,97.92
X$248 VGND rst_n \$1453 \$1459 \$1709 VPWR VPWR VGND sky130_fd_sc_hd__dfrtp_2
* cell instance $249 r0 *1 115.92,239.36
X$249 VGND rst_n \$3791 \$3250 \$3892 VPWR VPWR VGND sky130_fd_sc_hd__dfrtp_2
* cell instance $250 r0 *1 115.92,228.48
X$250 VGND rst_n \$3691 \$3250 \$3700 VPWR VPWR VGND sky130_fd_sc_hd__dfrtp_2
* cell instance $251 r0 *1 116.38,277.44
X$251 VGND rst_n \$4197 \$3889 \$4245 VPWR VPWR VGND sky130_fd_sc_hd__dfrtp_2
* cell instance $252 r0 *1 115,48.96
X$252 VGND rst_n \$1048 \$983 \$966 VPWR \$I12662 VGND sky130_fd_sc_hd__dfrtp_2
* cell instance $253 r180 *1 120.52,54.4
X$253 VGND \$1046 \$1048 \$933 I VPWR \$895 \$I12662 VGND
+ sky130_fd_sc_hd__nand4_2
* cell instance $254 r0 *1 115.92,92.48
X$254 VGND rst_n \$1502 \$983 \$1554 VPWR VPWR VGND sky130_fd_sc_hd__dfrtp_2
* cell instance $255 r0 *1 115,146.88
X$255 VGND rst_n \$2212 \$2294 \$2295 VPWR VPWR VGND sky130_fd_sc_hd__dfrtp_2
* cell instance $256 r0 *1 116.38,184.96
X$256 VGND rst_n \$2895 \$2294 \$2974 VPWR VPWR VGND sky130_fd_sc_hd__dfrtp_2
* cell instance $257 r0 *1 82.8,43.52
X$257 VGND rst_n \$688 \$785 \$827 VPWR VPWR VGND sky130_fd_sc_hd__dfrtp_2
* cell instance $258 r0 *1 81.88,48.96
X$258 VGND rst_n \$837 \$785 \$920 VPWR VPWR VGND sky130_fd_sc_hd__dfrtp_2
* cell instance $259 r0 *1 114.08,272
X$259 VGND rst_n \$4196 \$3889 \$4192 VPWR VPWR VGND sky130_fd_sc_hd__dfrtp_2
* cell instance $260 r0 *1 28.98,97.92
X$260 VGND rst_n \$418 \$1649 \$1563 VPWR VPWR VGND sky130_fd_sc_hd__dfrtp_2
* cell instance $261 r0 *1 167.9,272
X$261 VGND rst_n \$3981 \$3588 \$4214 VPWR VPWR VGND sky130_fd_sc_hd__dfrtp_2
* cell instance $262 r0 *1 167.9,282.88
X$262 VGND rst_n \$3813 \$3588 \$4316 VPWR VPWR VGND sky130_fd_sc_hd__dfrtp_2
* cell instance $263 r0 *1 28.98,108.8
X$263 VGND rst_n \$417 \$1649 \$1791 VPWR VPWR VGND sky130_fd_sc_hd__dfrtp_2
* cell instance $264 r0 *1 160.54,38.08
X$264 VGND \$653 \$684 \$601 \$556 \$416 VPWR VPWR VGND sky130_fd_sc_hd__o22ai_2
* cell instance $265 r180 *1 34.96,97.92
X$265 VGND \$1563 \$348 \$1532 \$1566 \$1835 \$1562 VPWR VPWR VGND
+ sky130_fd_sc_hd__o311a_2
* cell instance $266 m0 *1 174.8,119.68
X$266 VPWR VPWR VGND \$1984 \$1976 \$1910 \$1363 \$1832 VGND
+ sky130_fd_sc_hd__a211o_2
* cell instance $267 m0 *1 161,38.08
X$267 VPWR VPWR VGND \$681 \$61 \$147 \$49 \$558 VGND sky130_fd_sc_hd__a211o_2
* cell instance $268 r180 *1 179.86,48.96
X$268 VPWR VPWR VGND \$907 \$956 \$857 \$572 \$180 VGND sky130_fd_sc_hd__a211o_2
* cell instance $269 r180 *1 174.8,184.96
X$269 VPWR VPWR VGND \$2662 \$1362 \$2648 \$1412 \$2639 VGND
+ sky130_fd_sc_hd__a211o_2
* cell instance $270 m90 *1 113.16,212.16
X$270 VPWR VPWR VGND \$3441 \$3388 \$3381 \$3284 VGND sky130_fd_sc_hd__a21o_2
* cell instance $271 m90 *1 120.52,201.28
X$271 VPWR VPWR VGND \$3264 \$3178 \$3168 \$3173 VGND sky130_fd_sc_hd__a21o_2
* cell instance $272 m90 *1 115.92,130.56
X$272 VPWR VPWR VGND \$2053 \$2021 \$2020 \$2072 VGND sky130_fd_sc_hd__a21o_2
* cell instance $273 m90 *1 115.92,92.48
X$273 VPWR VPWR VGND \$1554 \$1502 \$1555 \$1516 VGND sky130_fd_sc_hd__a21o_2
* cell instance $274 m0 *1 26.68,108.8
X$274 VPWR VPWR VGND \$1562 \$418 \$417 \$1754 VGND sky130_fd_sc_hd__a21o_2
* cell instance $275 r180 *1 33.58,108.8
X$275 VGND \$1835 \$417 \$418 \$1754 VPWR VPWR VGND sky130_fd_sc_hd__nand3_2
* cell instance $276 m0 *1 161.46,201.28
X$276 VPWR VPWR VGND \$3145 \$2834 \$933 \$3056 VGND sky130_fd_sc_hd__a21o_2
* cell instance $277 m0 *1 109.94,76.16
X$277 VPWR VPWR VGND \$1299 \$1272 \$1221 \$1223 VGND sky130_fd_sc_hd__a21o_2
* cell instance $278 m0 *1 157.32,195.84
X$278 VPWR VPWR VGND \$2988 \$3139 \$2907 \$3148 VGND sky130_fd_sc_hd__a21o_2
* cell instance $279 m0 *1 166.06,92.48
X$279 VPWR VPWR VGND \$1496 \$1363 \$1465 \$1428 VGND sky130_fd_sc_hd__a21o_2
* cell instance $280 r180 *1 172.96,92.48
X$280 VPWR VPWR \$1465 VGND \$1468 \$1467 \$1489 VGND sky130_fd_sc_hd__and3b_2
* cell instance $281 r180 *1 177.56,92.48
X$281 VGND \$1419 \$1474 \$1472 \$1427 \$1468 VPWR VPWR VGND
+ sky130_fd_sc_hd__a31oi_2
* cell instance $282 m0 *1 109.94,277.44
X$282 VPWR VPWR VGND \$4188 \$4189 \$4168 \$4173 VGND sky130_fd_sc_hd__a21o_2
* cell instance $283 m0 *1 109.94,233.92
X$283 VPWR VPWR VGND \$3700 \$3691 \$3692 \$3694 VGND sky130_fd_sc_hd__a21o_2
* cell instance $284 r180 *1 164.68,43.52
X$284 VPWR VPWR VGND \$792 \$702 \$654 \$606 VGND sky130_fd_sc_hd__a21o_2
* cell instance $285 r180 *1 174.34,108.8
X$285 \$I12478 VPWR VGND \$1826 \$1832 \$1412 \$1823 VGND
+ sky130_fd_sc_hd__a21o_2
* cell instance $286 r180 *1 188.14,43.52
X$286 VPWR VPWR VGND \$804 \$805 \$572 \$711 VGND sky130_fd_sc_hd__a21o_2
* cell instance $287 r180 *1 95.22,48.96
X$287 VPWR VPWR VGND \$549 \$688 \$689 \$836 VGND sky130_fd_sc_hd__a21o_2
* cell instance $288 r180 *1 172.96,54.4
X$288 VPWR VPWR VGND \$589 \$1008 \$423 \$563 VGND sky130_fd_sc_hd__a21o_2
* cell instance $289 r0 *1 111.78,65.28
X$289 VPWR VPWR VGND \$1224 \$1140 \$1220 \$1227 VGND sky130_fd_sc_hd__a21o_2
* cell instance $290 r0 *1 167.9,255.68
X$290 \$I14138 VPWR VGND \$3860 \$1362 \$1363 \$1412 VGND
+ sky130_fd_sc_hd__a21o_2
* cell instance $291 r0 *1 160.54,250.24
X$291 VPWR VPWR \$1103 VGND \$4041 \$3981 success VGND sky130_fd_sc_hd__o21ba_2
* cell instance $292 m90 *1 81.88,48.96
X$292 VGND \$1038 \$929 \$837 \$979 \$688 VPWR VPWR VGND
+ sky130_fd_sc_hd__and4bb_2
* cell instance $293 m90 *1 120.52,223.04
X$293 VGND \$3575 \$340 \$27 \$425 \$864 VPWR VPWR VGND
+ sky130_fd_sc_hd__and4bb_2
* cell instance $294 m90 *1 173.42,114.24
X$294 VGND \$1933 \$1412 \$1363 \$1527 \$1362 VPWR VPWR VGND
+ sky130_fd_sc_hd__and4bb_2
* cell instance $295 r0 *1 173.42,114.24
X$295 VGND \$1362 \$1363 \$1910 \$1527 \$1412 VPWR VPWR VGND
+ sky130_fd_sc_hd__and4b_2
* cell instance $296 m0 *1 170.2,119.68
X$296 VGND \$1976 \$1527 \$1362 \$1412 \$1363 VPWR VPWR VGND
+ sky130_fd_sc_hd__a211oi_2
* cell instance $297 m90 *1 115.92,282.88
X$297 VGND \$4242 \$864 \$340 \$425 \$27 VPWR VPWR VGND
+ sky130_fd_sc_hd__and4bb_2
* cell instance $298 m0 *1 115.92,103.36
X$298 VGND \$1740 \$984 \$899 \$1050 \$760 VPWR VPWR VGND
+ sky130_fd_sc_hd__and4bb_2
* cell instance $299 m0 *1 120.52,255.68
X$299 VGND \$4020 \$425 \$27 \$864 \$340 VPWR VPWR VGND
+ sky130_fd_sc_hd__and4bb_2
* cell instance $300 r180 *1 122.82,70.72
X$300 VGND \$1287 \$760 \$899 \$984 \$1050 VPWR VPWR VGND
+ sky130_fd_sc_hd__and4bb_2
* cell instance $301 r0 *1 23.46,152.32
X$301 VGND \$1558 \$864 \$27 \$425 \$340 VPWR VPWR VGND
+ sky130_fd_sc_hd__and4bb_2
* cell instance $302 m0 *1 28.06,157.76
X$302 VGND \$2578 \$933 \$864 \$27 \$340 \$425 VPWR VPWR VGND
+ sky130_fd_sc_hd__a41oi_2
* cell instance $303 r0 *1 115.92,130.56
X$303 VGND \$2019 \$1050 \$760 \$984 \$899 VPWR VPWR VGND
+ sky130_fd_sc_hd__and4bb_2
* cell instance $304 r0 *1 115.92,87.04
X$304 VGND \$1438 \$984 \$760 \$1050 \$899 VPWR VPWR VGND
+ sky130_fd_sc_hd__and4bb_2
* cell instance $305 r0 *1 115.92,141.44
X$305 VGND \$2146 \$1050 \$899 \$984 \$760 VPWR VPWR VGND
+ sky130_fd_sc_hd__and4bb_2
* cell instance $306 r0 *1 116.84,233.92
X$306 VGND \$3793 \$425 \$340 \$864 \$27 VPWR VPWR VGND
+ sky130_fd_sc_hd__and4bb_2
* cell instance $307 r0 *1 126.5,282.88
X$307 VGND \$4294 \$864 \$27 \$425 \$340 VPWR VPWR VGND
+ sky130_fd_sc_hd__and4bb_2
* cell instance $308 m90 *1 74.52,152.32
X$308 VPWR \$2419 VPWR \$2425 \$2421 VGND \$2511 \$3812 VGND
+ sky130_fd_sc_hd__and4_2
* cell instance $309 m0 *1 26.22,103.36
X$309 VPWR \$933 VPWR \$416 \$348 VGND \$1754 \$1558 VGND
+ sky130_fd_sc_hd__and4_2
* cell instance $310 m0 *1 29.9,103.36
X$310 VGND \$417 \$416 \$418 \$1532 VPWR VPWR VGND sky130_fd_sc_hd__nand3b_2
* cell instance $311 r180 *1 77.74,157.76
X$311 VPWR \$2454 VPWR \$2517 \$2518 VGND \$2519 \$3333 VGND
+ sky130_fd_sc_hd__and4_2
* cell instance $312 r180 *1 83.72,21.76
X$312 \$I12292 \$315 VPWR \$195 \$194 VGND \$314 \$233 VGND
+ sky130_fd_sc_hd__and4_2
* cell instance $313 r180 *1 78.2,54.4
X$313 VPWR \$880 VPWR \$836 \$969 VGND \$1037 \$929 VGND sky130_fd_sc_hd__and4_2
* cell instance $314 r0 *1 77.28,38.08
X$314 VPWR \$688 VPWR \$609 \$730 VGND \$692 \$689 VGND sky130_fd_sc_hd__and4_2
* cell instance $315 r0 *1 27.14,146.88
X$315 VPWR \$340 VPWR \$425 \$933 VGND \$2321 \$27 VGND sky130_fd_sc_hd__and4_2
* cell instance $316 m90 *1 113.16,217.6
X$316 VPWR \$3532 VPWR VGND \$3535 \$3476 VGND sky130_fd_sc_hd__nand2b_2
* cell instance $317 m90 *1 111.78,277.44
X$317 VPWR \$4238 VPWR VGND \$4192 \$4196 VGND sky130_fd_sc_hd__nand2b_2
* cell instance $318 m90 *1 116.38,244.8
X$318 VPWR \$3907 VPWR VGND \$3848 \$3902 VGND sky130_fd_sc_hd__nand2b_2
* cell instance $319 m90 *1 123.28,103.36
X$319 VPWR \$1582 VPWR VGND \$1764 \$1618 VGND sky130_fd_sc_hd__nand2b_2
* cell instance $320 m90 *1 115.92,114.24
X$320 VPWR \$1958 VPWR VGND \$1878 \$1879 VGND sky130_fd_sc_hd__nand2b_2
* cell instance $321 m90 *1 177.1,92.48
X$321 VPWR \$1362 VPWR VGND \$1465 \$1412 VGND sky130_fd_sc_hd__nand2b_2
* cell instance $322 m90 *1 116.38,184.96
X$322 VPWR \$2889 VPWR VGND \$2793 \$2851 VGND sky130_fd_sc_hd__nand2b_2
* cell instance $323 m90 *1 120.06,43.52
X$323 VPWR \$895 VPWR VGND \$882 \$879 VGND sky130_fd_sc_hd__nand2b_2
* cell instance $324 m90 *1 117.3,261.12
X$324 \$I12015 \$4123 VPWR VGND \$4127 \$4090 VGND sky130_fd_sc_hd__nand2b_2
* cell instance $325 m0 *1 124.66,141.44
X$325 VPWR \$2076 VPWR VGND \$2195 \$2052 VGND sky130_fd_sc_hd__nand2b_2
* cell instance $326 m0 *1 109.94,81.6
X$326 VPWR \$1261 VPWR VGND \$1386 \$1281 VGND sky130_fd_sc_hd__nand2b_2
* cell instance $327 m0 *1 167.9,206.72
X$327 VPWR \$3048 VPWR VGND \$2666 \$933 VGND sky130_fd_sc_hd__nand2b_2
* cell instance $328 m0 *1 119.14,114.24
X$328 \$I12730 \$1743 VPWR VGND \$1937 \$1782 VGND sky130_fd_sc_hd__nand2b_2
* cell instance $329 m0 *1 119.14,152.32
X$329 VPWR \$2293 VPWR VGND \$2253 \$2229 VGND sky130_fd_sc_hd__nand2b_2
* cell instance $330 r180 *1 177.1,136
X$330 VPWR \$1363 VPWR VGND \$2037 \$1412 VGND sky130_fd_sc_hd__nand2b_2
* cell instance $331 r180 *1 172.04,282.88
X$331 VPWR \$3159 VPWR VGND \$4255 \$3813 VGND sky130_fd_sc_hd__nand2b_2
* cell instance $332 r180 *1 172.96,87.04
X$332 \$I12007 \$1412 VPWR VGND \$1428 \$1362 VGND sky130_fd_sc_hd__nand2b_2
* cell instance $333 m0 *1 172.96,87.04
X$333 VGND \$1425 \$1418 \$1419 \$1424 \$1421 VPWR \$I12007 VGND
+ sky130_fd_sc_hd__o31a_2
* cell instance $334 r180 *1 181.24,97.92
X$334 VPWR \$1527 VPWR VGND \$1472 \$1362 VGND sky130_fd_sc_hd__nand2b_2
* cell instance $335 r0 *1 109.02,233.92
X$335 VPWR \$3824 VPWR VGND \$3788 \$3785 VGND sky130_fd_sc_hd__nand2b_2
* cell instance $336 r0 *1 108.1,282.88
X$336 VPWR \$4352 VPWR VGND \$4287 \$4318 VGND sky130_fd_sc_hd__nand2b_2
* cell instance $337 r0 *1 181.24,92.48
X$337 VPWR \$1362 VPWR VGND \$1474 \$1527 VGND sky130_fd_sc_hd__nand2b_2
* cell instance $338 r0 *1 163.76,43.52
X$338 VPWR \$645 VPWR VGND \$866 \$654 VGND sky130_fd_sc_hd__nand2b_2
* cell instance $339 r0 *1 155.02,190.4
X$339 VPWR \$1412 VPWR VGND \$2904 \$1363 VGND sky130_fd_sc_hd__nand2b_2
* cell instance $340 r180 *1 184.46,27.2
X$340 VGND \$35 \$151 \$37 \$380 \$49 VPWR VPWR VGND sky130_fd_sc_hd__o31ai_2
* cell instance $341 m90 *1 161.92,190.4
X$341 VGND \$2834 \$2906 \$933 \$2813 \$3139 VPWR VPWR VGND
+ sky130_fd_sc_hd__a22o_2
* cell instance $342 m90 *1 156.86,184.96
X$342 VGND \$2732 \$2834 \$933 \$2906 \$2877 VPWR VPWR VGND
+ sky130_fd_sc_hd__a22o_2
* cell instance $343 m90 *1 167.9,223.04
X$343 VGND \$2038 \$3592 \$2323 \$3548 \$3500 VPWR VPWR VGND
+ sky130_fd_sc_hd__a22o_2
* cell instance $344 m90 *1 170.2,201.28
X$344 VGND \$1362 \$2904 \$1412 \$3042 \$3062 VPWR VPWR VGND
+ sky130_fd_sc_hd__a22o_2
* cell instance $345 m90 *1 168.82,212.16
X$345 VGND \$1611 \$3311 \$2687 \$3301 \$3445 VPWR VPWR VGND
+ sky130_fd_sc_hd__a22o_2
* cell instance $346 m0 *1 172.5,217.6
X$346 VGND \$1543 \$3311 \$2736 \$3301 \$3435 VPWR VPWR VGND
+ sky130_fd_sc_hd__a22o_2
* cell instance $347 m0 *1 170.2,233.92
X$347 VGND \$2110 \$3592 \$2475 \$3548 \$3742 VPWR VPWR VGND
+ sky130_fd_sc_hd__a22o_2
* cell instance $348 m0 *1 176.18,223.04
X$348 VGND VGND \$3592 VGND \$3548 \$3516 VPWR VPWR VGND sky130_fd_sc_hd__a22o_2
* cell instance $349 m0 *1 174.34,212.16
X$349 VGND \$1660 \$3311 \$2741 \$3301 \$3331 VPWR VPWR VGND
+ sky130_fd_sc_hd__a22o_2
* cell instance $350 r180 *1 173.88,228.48
X$350 VGND \$2161 \$3592 VGND \$3548 \$3637 VPWR VPWR VGND
+ sky130_fd_sc_hd__a22o_2
* cell instance $351 r180 *1 170.66,212.16
X$351 VGND \$1425 \$3311 \$2860 \$3301 \$3353 VPWR VPWR VGND
+ sky130_fd_sc_hd__a22o_2
* cell instance $352 r180 *1 170.2,228.48
X$352 VGND \$2083 \$3592 \$2331 \$3548 \$3658 VPWR VPWR VGND
+ sky130_fd_sc_hd__a22o_2
* cell instance $353 r180 *1 174.34,212.16
X$353 VGND \$1460 \$3311 \$2816 \$3301 \$3540 VPWR VPWR VGND
+ sky130_fd_sc_hd__a22o_2
* cell instance $354 r180 *1 86.94,163.2
X$354 VGND \$2377 \$1787 \$1705 \$2462 \$2285 VPWR VPWR VGND
+ sky130_fd_sc_hd__a22o_2
* cell instance $355 r180 *1 161.92,179.52
X$355 VGND \$2773 \$2596 \$2640 \$2592 \$2775 VPWR VPWR VGND
+ sky130_fd_sc_hd__a22o_2
* cell instance $356 r0 *1 173.42,212.16
X$356 VGND \$1757 \$3311 \$3227 \$3301 \$3426 VPWR VPWR VGND
+ sky130_fd_sc_hd__a22o_2
* cell instance $357 r0 *1 173.88,228.48
X$357 VGND \$2049 \$3592 \$2251 \$3548 \$3732 VPWR VPWR VGND
+ sky130_fd_sc_hd__a22o_2
* cell instance $358 r0 *1 172.5,206.72
X$358 VGND VGND \$3311 \$2655 \$3301 \$3328 VPWR VPWR VGND
+ sky130_fd_sc_hd__a22o_2
* cell instance $359 r0 *1 77.28,103.36
X$359 VGND \$1614 \$1728 \$1699 \$1729 \$1774 VPWR VPWR VGND
+ sky130_fd_sc_hd__a22o_2
* cell instance $360 m90 *1 85.56,103.36
X$360 VGND \$1733 \$864 \$27 \$340 VPWR \$425 VPWR VGND sky130_fd_sc_hd__or4bb_2
* cell instance $361 r0 *1 170.2,228.48
X$361 VGND \$2112 \$3592 \$2318 \$3548 \$3736 VPWR VPWR VGND
+ sky130_fd_sc_hd__a22o_2
* cell instance $362 r0 *1 168.82,206.72
X$362 VGND \$1682 \$3311 \$3354 \$3301 \$3339 VPWR VPWR VGND
+ sky130_fd_sc_hd__a22o_2
* cell instance $363 r0 *1 178.02,223.04
X$363 VGND \$2236 \$3592 \$2500 \$3548 \$3506 VPWR VPWR VGND
+ sky130_fd_sc_hd__a22o_2
* cell instance $364 m90 *1 116.38,217.6
X$364 VPWR \$3482 VPWR \$3476 VGND \$2517 VGND sky130_fd_sc_hd__and2b_2
* cell instance $365 m90 *1 122.82,119.68
X$365 \$I13390 \$1960 VPWR \$1879 VGND \$195 VGND sky130_fd_sc_hd__and2b_2
* cell instance $366 m90 *1 112.7,239.36
X$366 VPWR \$3791 VPWR \$3785 VGND \$3812 VGND sky130_fd_sc_hd__and2b_2
* cell instance $367 m90 *1 108.1,282.88
X$367 VPWR \$4285 VPWR \$4318 VGND \$2416 VGND sky130_fd_sc_hd__and2b_2
* cell instance $368 m90 *1 111.32,76.16
X$368 VPWR \$1288 VPWR \$1281 VGND \$441 VGND sky130_fd_sc_hd__and2b_2
* cell instance $369 m90 *1 161.92,195.84
X$369 VPWR \$933 VPWR \$3048 VGND \$2907 VGND sky130_fd_sc_hd__and2b_2
* cell instance $370 m0 *1 74.52,59.84
X$370 VPWR \$1037 VPWR \$1173 VGND \$975 VGND sky130_fd_sc_hd__and2b_2
* cell instance $371 m0 *1 169.74,168.64
X$371 \$I11849 \$2594 VPWR \$2566 VGND \$2600 VGND sky130_fd_sc_hd__and2b_2
* cell instance $372 m0 *1 172.96,168.64
X$372 VGND \$933 \$2588 \$2569 I VPWR \$I11849 VGND sky130_fd_sc_hd__a21boi_2
* cell instance $373 m0 *1 167.9,152.32
X$373 VPWR \$1363 VPWR \$1412 VGND \$2325 VGND sky130_fd_sc_hd__and2b_2
* cell instance $374 m0 *1 153.18,190.4
X$374 VPWR \$1412 VPWR \$1363 VGND \$2648 VGND sky130_fd_sc_hd__and2b_2
* cell instance $375 m0 *1 84.18,54.4
X$375 VPWR \$689 VPWR \$1126 VGND \$1095 VGND sky130_fd_sc_hd__and2b_2
* cell instance $376 m0 *1 184.46,179.52
X$376 VPWR \$2670 VPWR \$2579 VGND \$2748 VGND sky130_fd_sc_hd__and2b_2
* cell instance $377 r180 *1 119.14,190.4
X$377 VPWR \$2895 VPWR \$2851 VGND \$2454 VGND sky130_fd_sc_hd__and2b_2
* cell instance $378 r180 *1 119.14,250.24
X$378 VPWR \$3906 VPWR \$3902 VGND \$2421 VGND sky130_fd_sc_hd__and2b_2
* cell instance $379 r180 *1 126.5,277.44
X$379 VPWR \$4197 VPWR \$4196 VGND \$2450 VGND sky130_fd_sc_hd__and2b_2
* cell instance $380 r180 *1 113.16,141.44
X$380 VPWR \$2017 VPWR \$2052 VGND \$1128 VGND sky130_fd_sc_hd__and2b_2
* cell instance $381 r180 *1 119.14,114.24
X$381 \$I12730 \$1742 VPWR \$1782 VGND \$194 VGND sky130_fd_sc_hd__and2b_2
* cell instance $382 r180 *1 113.16,261.12
X$382 VPWR \$4031 VPWR \$4090 VGND \$2425 VGND sky130_fd_sc_hd__and2b_2
* cell instance $383 r180 *1 123.74,103.36
X$383 VPWR \$1453 VPWR \$1618 VGND \$233 VGND sky130_fd_sc_hd__and2b_2
* cell instance $384 r180 *1 174.34,130.56
X$384 VPWR \$1363 VPWR \$1412 VGND \$2029 VGND sky130_fd_sc_hd__and2b_2
* cell instance $385 r180 *1 178.94,152.32
X$385 VPWR \$1362 VPWR \$1363 VGND \$2313 VGND sky130_fd_sc_hd__and2b_2
* cell instance $386 r180 *1 33.12,201.28
X$386 \$I13622 \$3159 VPWR enable VGND \$933 VGND sky130_fd_sc_hd__and2b_2
* cell instance $387 r180 *1 123.74,54.4
X$387 \$I12662 \$1048 VPWR \$879 VGND \$378 VGND sky130_fd_sc_hd__and2b_2
* cell instance $388 r180 *1 119.14,152.32
X$388 VPWR \$2212 VPWR \$2229 VGND \$591 VGND sky130_fd_sc_hd__and2b_2
* cell instance $389 r180 *1 157.78,38.08
X$389 VPWR \$427 VPWR \$653 VGND \$554 VGND sky130_fd_sc_hd__and2b_2
* cell instance $390 r180 *1 177.56,130.56
X$390 VPWR \$2043 VPWR \$2037 VGND \$2038 VGND sky130_fd_sc_hd__and2b_2
* cell instance $391 r0 *1 81.88,32.64
X$391 VPWR \$593 VPWR \$549 VGND \$827 VGND sky130_fd_sc_hd__and2b_2
* cell instance $392 m0 *1 77.74,38.08
X$392 VGND rst_n \$609 \$785 \$643 VPWR VPWR VGND sky130_fd_sc_hd__dfrtp_2
* cell instance $393 r0 *1 168.36,87.04
X$393 VPWR \$1362 VPWR \$1412 VGND \$1482 VGND sky130_fd_sc_hd__and2b_2
* cell instance $394 r0 *1 171.58,87.04
X$394 VGND \$1417 \$1460 \$1412 \$1472 \$1419 \$1418 VPWR VPWR VGND
+ sky130_fd_sc_hd__o32ai_2
* cell instance $395 r0 *1 172.04,81.6
X$395 \$I12007 \$1363 VPWR \$1362 VGND \$1418 VGND sky130_fd_sc_hd__and2b_2
* cell instance $396 m90 *1 177.1,277.44
X$396 VGND \$4257 \$4255 \$2269 \$4203 success \$4252 VPWR VPWR VGND
+ sky130_fd_sc_hd__a32o_2
* cell instance $397 m0 *1 170.2,277.44
X$397 VGND \$4214 \$4255 \$4210 \$4203 \$3981 \$4252 VPWR VPWR VGND
+ sky130_fd_sc_hd__a32o_2
* cell instance $398 r180 *1 92,48.96
X$398 VGND \$686 \$689 I \$933 \$888 \$1095 VPWR VPWR VGND
+ sky130_fd_sc_hd__a32o_2
* cell instance $399 r0 *1 163.76,21.76
X$399 VGND \$291 \$143 \$27 \$78 \$98 \$330 VPWR VPWR VGND
+ sky130_fd_sc_hd__a32o_2
* cell instance $400 m90 *1 174.8,184.96
X$400 VGND \$2596 \$2972 \$1527 VPWR VPWR VGND sky130_fd_sc_hd__xnor2_2
* cell instance $401 m90 *1 184,184.96
X$401 VGND \$2900 \$2679 \$2732 VPWR VPWR VGND sky130_fd_sc_hd__xnor2_2
* cell instance $402 r0 *1 184,184.96
X$402 VGND \$2566 \$2592 \$2646 \$1412 \$2639 VPWR VPWR VGND
+ sky130_fd_sc_hd__a22oi_2
* cell instance $403 m90 *1 167.9,179.52
X$403 VGND \$2863 \$2924 \$2732 VPWR VPWR VGND sky130_fd_sc_hd__xnor2_2
* cell instance $404 m90 *1 177.56,179.52
X$404 VGND rst_n \$2815 \$2728 \$2743 VPWR VPWR VGND sky130_fd_sc_hd__dfstp_2
* cell instance $405 m90 *1 167.9,195.84
X$405 VGND \$3148 \$3065 \$2924 VPWR VPWR VGND sky130_fd_sc_hd__xnor2_2
* cell instance $406 m90 *1 171.12,38.08
X$406 VGND \$665 \$418 \$416 VPWR VPWR VGND sky130_fd_sc_hd__xnor2_2
* cell instance $407 m90 *1 184,179.52
X$407 VGND \$3229 \$2955 \$2732 VPWR VPWR VGND sky130_fd_sc_hd__xnor2_2
* cell instance $408 m90 *1 34.04,152.32
X$408 VGND \$2441 \$933 \$340 VPWR VPWR VGND sky130_fd_sc_hd__xnor2_2
* cell instance $409 m0 *1 177.1,32.64
X$409 VGND \$35 \$504 \$291 VPWR VPWR VGND sky130_fd_sc_hd__xnor2_2
* cell instance $410 r180 *1 186.76,32.64
X$410 VPWR VPWR VGND \$710 \$80 \$49 \$35 \$209 VGND sky130_fd_sc_hd__a211o_2
* cell instance $411 m0 *1 172.04,21.76
X$411 VGND \$46 \$143 \$98 VPWR VPWR VGND sky130_fd_sc_hd__xnor2_2
* cell instance $412 m0 *1 178.02,21.76
X$412 VGND \$956 \$169 \$49 \$57 \$38 \$16 VPWR VPWR VGND
+ sky130_fd_sc_hd__a32o_2
* cell instance $413 m0 *1 165.14,43.52
X$413 VGND \$861 \$645 \$654 VPWR VPWR VGND sky130_fd_sc_hd__xnor2_2
* cell instance $414 m0 *1 165.14,195.84
X$414 VGND \$3354 \$3062 \$2732 VPWR VPWR VGND sky130_fd_sc_hd__xnor2_2
* cell instance $415 m0 *1 166.98,174.08
X$415 VGND \$2655 \$2691 \$2815 VPWR VPWR VGND sky130_fd_sc_hd__xnor2_2
* cell instance $416 m0 *1 158.7,184.96
X$416 VGND \$2860 \$2862 \$2861 VPWR VPWR VGND sky130_fd_sc_hd__xnor2_2
* cell instance $417 m0 *1 170.2,48.96
X$417 VGND \$857 \$792 \$791 VPWR VPWR VGND sky130_fd_sc_hd__xnor2_2
* cell instance $418 r180 *1 184.46,179.52
X$418 VGND \$2741 \$2754 \$2752 VPWR VPWR VGND sky130_fd_sc_hd__xnor2_2
* cell instance $419 r0 *1 162.84,184.96
X$419 VGND \$2981 \$2815 \$2906 VPWR VPWR VGND sky130_fd_sc_hd__xnor2_2
* cell instance $420 r0 *1 166.98,43.52
X$420 VGND \$668 \$861 \$864 VPWR VPWR VGND sky130_fd_sc_hd__xnor2_2
* cell instance $421 r0 *1 171.12,38.08
X$421 VGND \$504 \$521 \$668 VPWR VPWR VGND sky130_fd_sc_hd__xnor2_2
* cell instance $422 r0 *1 178.02,195.84
X$422 VGND \$2660 \$3065 \$2651 VPWR VPWR VGND sky130_fd_sc_hd__xnor2_2
* cell instance $423 r0 *1 167.9,92.48
X$423 VGND \$1543 \$1496 \$1489 VPWR VPWR VGND sky130_fd_sc_hd__xnor2_2
* cell instance $424 m0 *1 170.2,97.92
X$424 VGND \$1489 \$1611 \$1472 \$1467 VPWR VPWR VGND sky130_fd_sc_hd__o21bai_2
* cell instance $425 r0 *1 161.92,190.4
X$425 VGND \$2924 \$2906 \$2752 VPWR VPWR VGND sky130_fd_sc_hd__xnor2_2
* cell instance $426 r0 *1 167.9,21.76
X$426 VGND \$98 \$330 \$28 VPWR VPWR VGND sky130_fd_sc_hd__xnor2_2
* cell instance $427 r0 *1 173.88,21.76
X$427 VGND \$35 \$17 \$15 \$30 \$317 VPWR VPWR VGND sky130_fd_sc_hd__a22o_2
* cell instance $428 r0 *1 170.2,32.64
X$428 VGND \$147 \$554 \$589 VPWR VPWR VGND sky130_fd_sc_hd__xnor2_2
* cell instance $429 r0 *1 171.12,174.08
X$429 VGND \$2569 \$2981 \$2679 VPWR VPWR VGND sky130_fd_sc_hd__xnor2_2
* cell instance $430 r0 *1 76.82,43.52
X$430 VGND \$643 \$781 \$609 VPWR VPWR VGND sky130_fd_sc_hd__xnor2_2
* cell instance $431 r0 *1 165.14,174.08
X$431 VGND \$2687 \$2694 \$2651 VPWR VPWR VGND sky130_fd_sc_hd__xnor2_2
* cell instance $432 r0 *1 168.82,244.8
X$432 VGND \$3942 \$1412 \$1363 VPWR VPWR VGND sky130_fd_sc_hd__xnor2_2
* cell instance $433 r0 *1 156.86,184.96
X$433 VGND \$2679 \$2657 \$2813 VPWR VPWR VGND sky130_fd_sc_hd__xnor2_2
* cell instance $434 m90 *1 114.08,272
X$434 VPWR VGND \$4142 \$4187 \$4189 VPWR \$4148 \$4180 VGND
+ sky130_fd_sc_hd__or4_2
* cell instance $435 m0 *1 123.28,233.92
X$435 VPWR VGND \$3706 \$3705 \$3691 VPWR \$3698 \$3797 VGND
+ sky130_fd_sc_hd__or4_2
* cell instance $436 m0 *1 78.66,108.8
X$436 VPWR VGND \$425 \$27 \$340 VPWR \$1705 \$864 VGND sky130_fd_sc_hd__or4_2
* cell instance $437 r180 *1 113.16,136
X$437 VPWR VGND \$2068 \$2018 \$2021 VPWR \$2202 \$2079 VGND
+ sky130_fd_sc_hd__or4_2
* cell instance $438 r180 *1 109.94,76.16
X$438 VPWR VGND \$1273 \$1274 \$1272 VPWR \$1213 \$1275 VGND
+ sky130_fd_sc_hd__or4_2
* cell instance $439 r0 *1 122.82,212.16
X$439 VPWR VGND \$3292 \$3384 \$3388 VPWR \$3285 \$3387 VGND
+ sky130_fd_sc_hd__or4_2
* cell instance $440 r0 *1 120.52,87.04
X$440 VPWR VGND \$1404 \$1499 \$1502 VPWR \$1500 \$1402 VGND
+ sky130_fd_sc_hd__or4_2
* cell instance $441 r0 *1 114.08,201.28
X$441 VPWR VGND \$3175 \$3248 \$3178 VPWR \$3172 \$3174 VGND
+ sky130_fd_sc_hd__or4_2
* cell instance $442 r0 *1 115,59.84
X$442 VPWR VGND \$1143 \$1203 \$1140 VPWR \$1205 \$1201 VGND
+ sky130_fd_sc_hd__or4_2
* cell instance $443 m90 *1 121.9,59.84
X$443 VPWR \$I87 VGND \$984 \$1050 \$899 VPWR \$1143 \$I93 \$760 \$I43 \$I52
+ \$I18 VGND sky130_fd_sc_hd__or4b_2
* cell instance $444 m90 *1 122.82,59.84
X$444 VPWR \$760 VPWR VGND sky130_fd_sc_hd__diode_2
* cell instance $445 m90 *1 186.3,38.08
X$445 VPWR VPWR VGND \$711 \$710 \$49 \$345 VGND sky130_fd_sc_hd__a21bo_2
* cell instance $446 m90 *1 180.78,206.72
X$446 VPWR \$3303 VPWR VGND \$3310 \$1826 \$3301 VGND sky130_fd_sc_hd__or3_2
* cell instance $447 m90 *1 77.74,54.4
X$447 VPWR \$979 VPWR VGND \$1170 \$1126 \$837 VGND sky130_fd_sc_hd__or3_2
* cell instance $448 m0 *1 171.12,195.84
X$448 VPWR \$3042 VPWR VGND \$2861 \$2640 \$2594 VGND sky130_fd_sc_hd__or3_2
* cell instance $449 m0 *1 179.86,217.6
X$449 VPWR \$3303 VPWR VGND \$3508 \$1914 \$3301 VGND sky130_fd_sc_hd__or3_2
* cell instance $450 m0 *1 165.14,217.6
X$450 VPWR \$3303 VPWR VGND \$3546 \$1984 \$3301 VGND sky130_fd_sc_hd__or3_2
* cell instance $451 r180 *1 164.68,27.2
X$451 VPWR \$115 VPWR VGND \$386 \$49 \$392 VGND sky130_fd_sc_hd__or3_2
* cell instance $452 r180 *1 180.78,212.16
X$452 VPWR \$3303 VPWR VGND \$3428 \$1935 \$3301 VGND sky130_fd_sc_hd__or3_2
* cell instance $453 r180 *1 164.68,212.16
X$453 VPWR \$3303 VPWR VGND \$3491 \$1976 \$3301 VGND sky130_fd_sc_hd__or3_2
* cell instance $454 r0 *1 180.78,212.16
X$454 VPWR \$3303 VPWR VGND \$3607 \$1933 \$3301 VGND sky130_fd_sc_hd__or3_2
* cell instance $455 r0 *1 184.92,16.32
X$455 VPWR \$17 VPWR VGND \$227 \$56 \$31 VGND sky130_fd_sc_hd__or3_2
* cell instance $456 r0 *1 166.06,206.72
X$456 VPWR \$3303 VPWR VGND \$3369 \$1822 \$3301 VGND sky130_fd_sc_hd__or3_2
* cell instance $457 r0 *1 178.02,212.16
X$457 VPWR \$3303 VPWR VGND \$3418 VGND \$3301 VGND sky130_fd_sc_hd__or3_2
* cell instance $458 r0 *1 161,43.52
X$458 VPWR \$703 VPWR VGND \$865 \$874 \$606 VGND sky130_fd_sc_hd__or3_2
* cell instance $459 r0 *1 178.02,114.24
X$459 VPWR \$1832 VPWR VGND \$1914 \$1901 \$1910 VGND sky130_fd_sc_hd__or3_2
* cell instance $460 r0 *1 174.8,48.96
X$460 VPWR \$635 VPWR VGND \$997 \$857 \$532 VGND sky130_fd_sc_hd__or3_2
* cell instance $461 r0 *1 157.78,21.76
X$461 VPWR \$14 VPWR VGND \$58 \$56 \$46 VGND sky130_fd_sc_hd__or3_2
* cell instance $462 m90 *1 163.76,21.76
X$462 VPWR \$143 VPWR \$288 VGND \$29 VGND sky130_fd_sc_hd__and2b_2
* cell instance $463 r0 *1 185.84,21.76
X$463 VPWR \$151 VPWR VGND \$306 \$56 \$14 VGND sky130_fd_sc_hd__or3_2
* cell instance $464 m90 *1 184,190.4
X$464 VGND \$3056 \$2592 \$2862 VPWR VPWR VGND sky130_fd_sc_hd__xor2_2
* cell instance $465 m90 *1 172.04,27.2
X$465 VGND \$348 \$416 \$78 VPWR VPWR VGND sky130_fd_sc_hd__xor2_2
* cell instance $466 m90 *1 176.64,27.2
X$466 VGND \$427 \$417 \$418 \$416 \$348 VPWR VPWR VGND
+ sky130_fd_sc_hd__and4bb_2
* cell instance $467 m0 *1 176.64,190.4
X$467 VGND \$2651 \$2900 \$2670 VPWR VPWR VGND sky130_fd_sc_hd__xor2_2
* cell instance $468 m0 *1 167.9,27.2
X$468 VGND \$425 \$383 \$330 VPWR VPWR VGND sky130_fd_sc_hd__xor2_2
* cell instance $469 m0 *1 78.2,54.4
X$469 VGND \$979 \$1037 \$1092 VPWR VPWR VGND sky130_fd_sc_hd__xor2_2
* cell instance $470 m0 *1 171.12,43.52
X$470 VGND \$791 \$792 \$717 VPWR VPWR VGND sky130_fd_sc_hd__xor2_2
* cell instance $471 m0 *1 165.14,184.96
X$471 VGND \$2813 \$2768 \$2816 VPWR VPWR VGND sky130_fd_sc_hd__xor2_2
* cell instance $472 m0 *1 166.98,201.28
X$472 VGND \$2752 \$3056 \$3101 VPWR VPWR VGND sky130_fd_sc_hd__xor2_2
* cell instance $473 m0 *1 171.12,32.64
X$473 VGND \$423 \$563 \$49 VPWR VPWR VGND sky130_fd_sc_hd__xor2_2
* cell instance $474 m0 *1 171.12,38.08
X$474 VGND \$589 \$554 \$572 VPWR VPWR VGND sky130_fd_sc_hd__xor2_2
* cell instance $475 r180 *1 178.94,174.08
X$475 VGND \$2657 \$2681 \$2736 VPWR VPWR VGND sky130_fd_sc_hd__xor2_2
* cell instance $476 r180 *1 188.6,190.4
X$476 VGND \$2657 \$2815 \$2955 VPWR VPWR VGND sky130_fd_sc_hd__xor2_2
* cell instance $477 r180 *1 179.86,27.2
X$477 VGND \$291 \$504 \$31 VPWR VPWR VGND sky130_fd_sc_hd__xor2_2
* cell instance $478 r180 *1 171.12,38.08
X$478 VGND \$418 \$486 \$645 VPWR VPWR VGND sky130_fd_sc_hd__xor2_2
* cell instance $479 r180 *1 171.12,32.64
X$479 VGND \$348 \$417 \$486 VPWR VPWR VGND sky130_fd_sc_hd__xor2_2
* cell instance $480 r180 *1 177.1,206.72
X$480 VGND \$2657 \$3056 \$3065 VPWR VPWR VGND sky130_fd_sc_hd__xor2_2
* cell instance $481 r0 *1 28.98,141.44
X$481 VGND \$425 \$2174 \$2246 VPWR VPWR VGND sky130_fd_sc_hd__xor2_2
* cell instance $482 r0 *1 27.14,103.36
X$482 VGND \$417 \$1754 \$1791 VPWR VPWR VGND sky130_fd_sc_hd__xor2_2
* cell instance $483 r0 *1 178.02,174.08
X$483 VGND \$2651 \$2813 \$3079 VPWR VPWR VGND sky130_fd_sc_hd__xor2_2
* cell instance $484 r0 *1 170.2,201.28
X$484 VGND \$2906 \$3046 \$3227 VPWR VPWR VGND sky130_fd_sc_hd__xor2_2
* cell instance $485 m90 *1 175.26,130.56
X$485 VGND \$2110 \$2037 \$2033 \$2084 \$2029 \$2043 VPWR VPWR VGND
+ sky130_fd_sc_hd__o221a_2
* cell instance $486 r180 *1 160.54,190.4
X$486 VGND \$3070 \$2568 \$2666 \$2863 \$2910 \$2651 VPWR VPWR VGND
+ sky130_fd_sc_hd__o221a_2
* cell instance $487 m90 *1 125.58,250.24
X$487 VPWR \$4022 VPWR \$4020 \$933 I VGND \$3906 VGND sky130_fd_sc_hd__a31o_2
* cell instance $488 m90 *1 172.04,108.8
X$488 VPWR \$1935 VPWR \$1823 \$1362 \$1412 VGND \$1842 VGND
+ sky130_fd_sc_hd__a31o_2
* cell instance $489 m90 *1 112.7,130.56
X$489 VPWR \$2127 VPWR \$2019 \$933 I VGND \$2017 VGND sky130_fd_sc_hd__a31o_2
* cell instance $490 m90 *1 116.84,103.36
X$490 VPWR \$1775 VPWR \$1740 \$933 I VGND \$1742 VGND sky130_fd_sc_hd__a31o_2
* cell instance $491 m90 *1 74.52,48.96
X$491 VPWR \$1021 VPWR \$969 \$836 \$609 VGND \$782 VGND sky130_fd_sc_hd__a31o_2
* cell instance $492 m90 *1 161.92,32.64
X$492 VPWR \$601 VPWR \$418 \$417 \$416 VGND \$606 VGND sky130_fd_sc_hd__a31o_2
* cell instance $493 r0 *1 161.92,32.64
X$493 VGND \$492 \$407 \$49 \$519 \$147 \$439 VPWR VPWR VGND
+ sky130_fd_sc_hd__o311a_2
* cell instance $494 m90 *1 170.2,32.64
X$494 VGND \$521 \$383 \$425 \$417 \$476 VPWR VPWR VGND
+ sky130_fd_sc_hd__o2bb2a_2
* cell instance $495 m90 *1 28.98,97.92
X$495 VPWR \$1642 VPWR \$348 \$933 \$1558 VGND \$416 VGND
+ sky130_fd_sc_hd__a31o_2
* cell instance $496 m0 *1 70.84,157.76
X$496 VPWR \$2438 VPWR \$2420 \$933 I VGND \$2265 VGND sky130_fd_sc_hd__a31o_2
* cell instance $497 m0 *1 126.5,288.32
X$497 VPWR \$4346 VPWR \$4294 \$933 I VGND \$4285 VGND sky130_fd_sc_hd__a31o_2
* cell instance $498 m0 *1 125.58,282.88
X$498 VPWR \$4240 VPWR \$4242 \$933 I VGND \$4197 VGND sky130_fd_sc_hd__a31o_2
* cell instance $499 m0 *1 30.82,206.72
X$499 VPWR \$3217 VPWR \$933 \$1506 \$1558 VGND \$3159 VGND
+ sky130_fd_sc_hd__a31o_2
* cell instance $500 m0 *1 120.52,223.04
X$500 VPWR \$3541 VPWR \$3575 \$933 I VGND \$3482 VGND sky130_fd_sc_hd__a31o_2
* cell instance $501 m0 *1 123.28,239.36
X$501 VPWR \$3790 VPWR \$3793 \$933 I VGND \$3791 VGND sky130_fd_sc_hd__a31o_2
* cell instance $502 m0 *1 124.66,76.16
X$502 VPWR \$1283 VPWR \$1287 \$933 I VGND \$1288 VGND sky130_fd_sc_hd__a31o_2
* cell instance $503 m0 *1 71.3,54.4
X$503 VPWR \$1173 VPWR \$969 \$836 \$880 VGND \$929 VGND sky130_fd_sc_hd__a31o_2
* cell instance $504 r180 *1 113.16,97.92
X$504 VPWR \$1627 VPWR \$1438 \$933 I VGND \$1453 VGND sky130_fd_sc_hd__a31o_2
* cell instance $505 r180 *1 83.26,97.92
X$505 VPWR \$1620 VPWR \$1702 \$933 \$1558 VGND \$1512 VGND
+ sky130_fd_sc_hd__a31o_2
* cell instance $506 r180 *1 164.68,174.08
X$506 VPWR \$2691 VPWR \$2566 \$2639 \$1362 VGND \$2646 VGND
+ sky130_fd_sc_hd__a31o_2
* cell instance $507 r180 *1 183.08,48.96
X$507 VPWR \$954 VPWR \$368 \$166 \$572 VGND \$717 VGND sky130_fd_sc_hd__a31o_2
* cell instance $508 r180 *1 119.14,119.68
X$508 VPWR \$2005 VPWR \$1961 \$933 I VGND \$1960 VGND sky130_fd_sc_hd__a31o_2
* cell instance $509 r180 *1 158.7,184.96
X$509 VPWR \$2762 VPWR \$2810 \$2872 \$2907 VGND \$2877 VGND
+ sky130_fd_sc_hd__a31o_2
* cell instance $510 r0 *1 117.3,261.12
X$510 \$I12015 \$4119 VPWR \$4032 \$933 I VGND \$4031 VGND
+ sky130_fd_sc_hd__a31o_2
* cell instance $511 r0 *1 115,54.4
X$511 \$I10490 \$967 VPWR \$1046 \$933 I VGND \$1048 VGND
+ sky130_fd_sc_hd__a31o_2
* cell instance $512 r180 *1 120.52,59.84
X$512 VGND \$1046 \$899 \$760 \$1050 \$984 VPWR \$I10490 VGND
+ sky130_fd_sc_hd__nor4_2
* cell instance $513 r0 *1 112.7,141.44
X$513 VPWR \$2270 VPWR \$2146 \$933 I VGND \$2212 VGND sky130_fd_sc_hd__a31o_2
* cell instance $514 r0 *1 120.52,190.4
X$514 \$I13591 \$2896 VPWR \$3116 \$933 I VGND \$2895 VGND
+ sky130_fd_sc_hd__a31o_2
* cell instance $515 m90 *1 169.28,48.96
X$515 VPWR VPWR \$866 \$1008 \$986 VGND \$865 VGND sky130_fd_sc_hd__a21oi_2
* cell instance $516 m90 *1 80.96,54.4
X$516 VPWR VPWR I \$1083 \$933 VGND \$1126 VGND sky130_fd_sc_hd__a21oi_2
* cell instance $517 m90 *1 81.88,97.92
X$517 VPWR VPWR \$1773 \$1571 \$1650 VGND \$1695 VGND sky130_fd_sc_hd__a21oi_2
* cell instance $518 m90 *1 167.9,217.6
X$518 VPWR VPWR \$3401 \$3303 \$3492 VGND \$3439 VGND sky130_fd_sc_hd__a21oi_2
* cell instance $519 m90 *1 181.24,201.28
X$519 VPWR VPWR \$3101 \$3212 \$3079 VGND \$2666 VGND sky130_fd_sc_hd__a21oi_2
* cell instance $520 m0 *1 157.78,38.08
X$520 VPWR VPWR \$416 \$684 \$418 VGND \$417 VGND sky130_fd_sc_hd__a21oi_2
* cell instance $521 m0 *1 172.04,157.76
X$521 VPWR VPWR \$1412 \$2500 \$2313 VGND \$1527 VGND sky130_fd_sc_hd__a21oi_2
* cell instance $522 m0 *1 176.64,114.24
X$522 VPWR VPWR \$1412 \$1901 \$1363 VGND \$1527 VGND sky130_fd_sc_hd__a21oi_2
* cell instance $523 r180 *1 39.56,152.32
X$523 VPWR VPWR \$340 \$2406 \$933 VGND \$27 VGND sky130_fd_sc_hd__a21oi_2
* cell instance $524 r180 *1 188.6,38.08
X$524 VPWR VPWR \$413 \$635 \$157 VGND \$147 VGND sky130_fd_sc_hd__a21oi_2
* cell instance $525 r180 *1 161.46,43.52
X$525 VPWR VPWR \$589 \$791 \$653 VGND \$427 VGND sky130_fd_sc_hd__a21oi_2
* cell instance $526 r180 *1 171.12,130.56
X$526 VPWR VPWR \$2043 \$2049 \$2029 VGND \$2048 VGND sky130_fd_sc_hd__a21oi_2
* cell instance $527 r0 *1 182.16,43.52
X$527 VPWR VPWR \$572 \$796 \$443 VGND \$49 VGND sky130_fd_sc_hd__a21oi_2
* cell instance $528 r0 *1 157.32,38.08
X$528 VPWR VPWR \$418 \$702 \$654 VGND \$606 VGND sky130_fd_sc_hd__a21oi_2
* cell instance $529 r0 *1 155.48,32.64
X$529 VPWR VPWR \$416 \$383 \$486 VGND \$351 VGND sky130_fd_sc_hd__a21oi_2
* cell instance $530 r0 *1 157.78,174.08
X$530 VPWR VPWR \$2697 \$2694 \$2705 VGND \$2640 VGND sky130_fd_sc_hd__a21oi_2
* cell instance $531 r0 *1 159.16,27.2
X$531 VPWR VPWR \$31 \$169 \$181 VGND \$49 VGND sky130_fd_sc_hd__a21oi_2
* cell instance $532 r0 *1 167.9,130.56
X$532 VPWR VPWR \$1412 \$2084 \$1527 VGND \$1362 VGND sky130_fd_sc_hd__a21oi_2
* cell instance $533 r0 *1 178.02,92.48
X$533 VPWR VPWR \$1412 \$1468 \$1363 VGND \$1527 VGND sky130_fd_sc_hd__a21oi_2
* cell instance $534 m90 *1 174.8,146.88
X$534 VPWR \$1363 VPWR \$2235 VGND \$1362 \$2305 \$2323 VGND
+ sky130_fd_sc_hd__o211a_2
* cell instance $535 m90 *1 174.8,48.96
X$535 VPWR \$797 VPWR \$859 VGND \$1073 \$717 \$984 VGND
+ sky130_fd_sc_hd__o211a_2
* cell instance $536 m0 *1 181.24,43.52
X$536 VPWR \$997 VPWR \$797 VGND \$954 \$492 \$760 VGND sky130_fd_sc_hd__o211a_2
* cell instance $537 m0 *1 36.34,103.36
X$537 VPWR \$1839 VPWR \$1642 VGND \$1566 \$1532 \$1765 VGND
+ sky130_fd_sc_hd__o211a_2
* cell instance $538 m0 *1 165.14,244.8
X$538 VPWR \$3813 VPWR \$3860 VGND \$3861 \$1527 \$4002 VGND
+ sky130_fd_sc_hd__o211a_2
* cell instance $539 m0 *1 168.82,244.8
X$539 VGND \$1527 \$3066 \$3882 VPWR VPWR VGND sky130_fd_sc_hd__dfxtp_2
* cell instance $540 r180 *1 174.8,141.44
X$540 \$I13343 \$2168 VPWR \$2100 VGND \$2043 \$1363 \$2161 VGND
+ sky130_fd_sc_hd__o211a_2
* cell instance $541 r180 *1 164.68,32.64
X$541 VPWR \$386 VPWR \$147 VGND \$30 \$413 \$532 VGND sky130_fd_sc_hd__o211a_2
* cell instance $542 r180 *1 176.64,54.4
X$542 VPWR \$797 VPWR \$907 VGND \$856 \$717 \$1050 VGND
+ sky130_fd_sc_hd__o211a_2
* cell instance $543 r180 *1 170.2,48.96
X$543 VPWR \$797 VPWR \$718 VGND \$804 \$717 \$899 VGND sky130_fd_sc_hd__o211a_2
* cell instance $544 r180 *1 85.56,108.8
X$544 VPWR \$933 VPWR \$1783 VGND \$1650 \$1652 \$1728 VGND
+ sky130_fd_sc_hd__o211a_2
* cell instance $545 r0 *1 162.38,27.2
X$545 VPWR \$418 VPWR \$417 VGND \$416 \$348 \$421 VGND sky130_fd_sc_hd__o211a_2
* cell instance $546 m90 *1 177.56,146.88
X$546 VPWR \$1412 \$2235 \$2313 VGND VPWR \$2318 VGND sky130_fd_sc_hd__and3_2
* cell instance $547 m90 *1 94.3,48.96
X$547 VPWR \$689 \$688 \$837 VGND VPWR \$969 VGND sky130_fd_sc_hd__and3_2
* cell instance $548 m90 *1 82.8,59.84
X$548 \$I10294 \$1126 I \$933 VGND VPWR \$836 VGND sky130_fd_sc_hd__and3_2
* cell instance $549 m90 *1 70.84,152.32
X$549 VPWR \$2450 \$2449 \$2416 VGND VPWR \$2453 VGND sky130_fd_sc_hd__and3_2
* cell instance $550 m90 *1 177.56,184.96
X$550 VPWR \$1412 \$1363 \$1362 VGND VPWR \$2972 VGND sky130_fd_sc_hd__and3_2
* cell instance $551 m90 *1 27.14,146.88
X$551 VPWR \$27 \$340 \$933 VGND VPWR \$2174 VGND sky130_fd_sc_hd__and3_2
* cell instance $552 m0 *1 173.88,239.36
X$552 \$I10290 \$3813 \$3623 \$3868 VGND VPWR O[5] VGND sky130_fd_sc_hd__and3_2
* cell instance $553 m0 *1 28.06,97.92
X$553 VPWR \$1558 \$933 \$1532 VGND VPWR \$1564 VGND sky130_fd_sc_hd__and3_2
* cell instance $554 m0 *1 176.64,255.68
X$554 VPWR \$3813 \$3621 \$3868 VGND VPWR O[3] VGND sky130_fd_sc_hd__and3_2
* cell instance $555 m0 *1 87.86,54.4
X$555 VPWR \$1038 \$1095 \$880 VGND VPWR \$1103 VGND sky130_fd_sc_hd__and3_2
* cell instance $556 m0 *1 180.32,250.24
X$556 VPWR \$3813 \$3627 \$3868 VGND VPWR O[4] VGND sky130_fd_sc_hd__and3_2
* cell instance $557 m0 *1 165.14,250.24
X$557 VPWR \$3813 \$3504 \$3868 VGND VPWR O[6] VGND sky130_fd_sc_hd__and3_2
* cell instance $558 m0 *1 176.64,244.8
X$558 VPWR \$3813 \$3874 \$3868 VGND VPWR O[1] VGND sky130_fd_sc_hd__and3_2
* cell instance $559 r180 *1 164.68,48.96
X$559 VPWR \$866 \$986 \$865 VGND VPWR \$1058 VGND sky130_fd_sc_hd__and3_2
* cell instance $560 r180 *1 81.88,27.2
X$560 \$I10282 \$314 \$376 \$373 VGND VPWR \$375 VGND sky130_fd_sc_hd__and3_2
* cell instance $561 r180 *1 85.56,27.2
X$561 \$I10282 \$378 VPWR \$441 \$442 VGND \$376 \$381 VGND
+ sky130_fd_sc_hd__and4_2
* cell instance $562 r180 *1 72.22,48.96
X$562 VPWR \$689 \$688 \$836 VGND VPWR \$593 VGND sky130_fd_sc_hd__and3_2
* cell instance $563 m0 *1 72.22,48.96
X$563 VPWR \$1170 \$730 VGND \$782 VPWR \$929 VGND sky130_fd_sc_hd__nor3_2
* cell instance $564 r180 *1 79.12,27.2
X$564 \$I10282 \$1128 \$374 \$591 VGND VPWR \$373 VGND sky130_fd_sc_hd__and3_2
* cell instance $565 r0 *1 185.38,43.52
X$565 VPWR \$35 \$569 \$23 VGND VPWR \$50 VGND sky130_fd_sc_hd__and3_2
* cell instance $566 r0 *1 154.56,38.08
X$566 VPWR \$664 \$556 \$665 VGND VPWR \$703 VGND sky130_fd_sc_hd__and3_2
* cell instance $567 r0 *1 169.28,152.32
X$567 VPWR \$1412 \$1363 \$1362 VGND VPWR \$2237 VGND sky130_fd_sc_hd__and3_2
* cell instance $568 r0 *1 172.04,152.32
X$568 VGND \$2475 \$2313 \$2498 \$1527 \$1412 \$1362 VPWR VPWR VGND
+ sky130_fd_sc_hd__a2111oi_2
* cell instance $569 r0 *1 174.8,244.8
X$569 VPWR \$3813 \$3515 \$3868 VGND VPWR O[7] VGND sky130_fd_sc_hd__and3_2
* cell instance $570 r0 *1 171.12,54.4
X$570 \$I13345 \$147 \$83 \$1002 VGND VPWR \$805 VGND sky130_fd_sc_hd__and3_2
* cell instance $571 r0 *1 74.98,157.76
X$571 VPWR \$2511 \$2519 \$2453 VGND VPWR \$2455 VGND sky130_fd_sc_hd__and3_2
* cell instance $572 r0 *1 178.02,244.8
X$572 VPWR \$3813 \$3734 \$3868 VGND VPWR O[0] VGND sky130_fd_sc_hd__and3_2
* cell instance $573 r0 *1 180.78,244.8
X$573 VPWR \$3813 \$3497 \$3868 VGND VPWR O[2] VGND sky130_fd_sc_hd__and3_2
* cell instance $574 m90 *1 82.8,141.44
X$574 VGND \$2138 \$2186 \$2135 \$933 VPWR VPWR VGND sky130_fd_sc_hd__mux2_1
* cell instance $575 m90 *1 84.18,152.32
X$575 VGND \$2379 \$2224 \$2377 \$933 VPWR VPWR VGND sky130_fd_sc_hd__mux2_1
* cell instance $576 m90 *1 182.16,27.2
X$576 VGND \$430 \$306 \$58 \$31 VPWR VPWR VGND sky130_fd_sc_hd__mux2_1
* cell instance $577 r0 *1 182.16,27.2
X$577 VPWR VPWR \$345 VGND \$443 \$80 \$35 VGND sky130_fd_sc_hd__o21ba_2
* cell instance $578 m90 *1 81.88,136
X$578 VGND \$2136 \$2104 \$2186 \$933 VPWR VPWR VGND sky130_fd_sc_hd__mux2_1
* cell instance $579 m90 *1 73.6,146.88
X$579 VGND \$2190 \$2264 \$2223 \$933 VPWR VPWR VGND sky130_fd_sc_hd__mux2_1
* cell instance $580 m90 *1 74.52,141.44
X$580 VGND \$2108 \$2222 \$2104 \$933 VPWR VPWR VGND sky130_fd_sc_hd__mux2_1
* cell instance $581 m0 *1 87.86,146.88
X$581 VGND \$2352 \$2135 \$2224 \$933 VPWR VPWR VGND sky130_fd_sc_hd__mux2_1
* cell instance $582 m0 *1 76.82,103.36
X$582 VGND \$1695 \$1773 \$1558 \$1699 VPWR VPWR VGND sky130_fd_sc_hd__mux2_1
* cell instance $583 m0 *1 79.12,163.2
X$583 VGND \$2602 \$2458 \$2548 \$933 VPWR VPWR VGND sky130_fd_sc_hd__mux2_1
* cell instance $584 m0 *1 80.96,103.36
X$584 VGND \$1702 \$1783 \$1650 \$1652 VPWR VPWR VGND sky130_fd_sc_hd__mux2_1
* cell instance $585 m0 *1 85.1,103.36
X$585 VPWR VGND \$1787 VPWR \$1705 VGND sky130_fd_sc_hd__buf_2
* cell instance $586 r180 *1 92,157.76
X$586 VGND \$2530 I \$2462 \$933 VPWR VPWR VGND sky130_fd_sc_hd__mux2_1
* cell instance $587 r180 *1 74.52,146.88
X$587 VGND \$2266 \$2223 \$2222 \$933 VPWR VPWR VGND sky130_fd_sc_hd__mux2_1
* cell instance $588 r180 *1 40.48,97.92
X$588 VGND \$1537 \$1566 \$1564 \$348 VPWR VPWR VGND sky130_fd_sc_hd__mux2_1
* cell instance $589 r180 *1 181.24,38.08
X$589 VGND \$627 \$317 \$631 \$49 VPWR VPWR VGND sky130_fd_sc_hd__mux2_1
* cell instance $590 r180 *1 185.38,38.08
X$590 VGND \$676 \$49 \$519 \$55 \$179 \$380 VPWR VPWR VGND
+ sky130_fd_sc_hd__o32a_2
* cell instance $591 r180 *1 79.12,163.2
X$591 VGND \$2437 \$2548 \$2376 \$933 VPWR VPWR VGND sky130_fd_sc_hd__mux2_1
* cell instance $592 r0 *1 178.02,43.52
X$592 VGND \$856 \$82 \$811 \$572 VPWR VPWR VGND sky130_fd_sc_hd__mux2_1
* cell instance $593 r0 *1 75.9,152.32
X$593 VGND \$2423 \$2376 \$2264 \$933 VPWR VPWR VGND sky130_fd_sc_hd__mux2_1
* cell instance $594 r0 *1 182.62,32.64
X$594 VGND \$558 \$35 \$30 \$51 VPWR VPWR VGND sky130_fd_sc_hd__mux2_1
* cell instance $595 r0 *1 77.74,157.76
X$595 VGND \$2523 \$2462 \$2458 \$933 VPWR VPWR VGND sky130_fd_sc_hd__mux2_1
* cell instance $596 r0 *1 168.82,136
X$596 VGND \$2048 \$1527 \$1363 \$1362 VPWR \$I13343 VGND
+ sky130_fd_sc_hd__mux2_1
* cell instance $597 m90 *1 189.98,21.76
X$597 VPWR VGND VPWR VGND sky130_fd_sc_hd__decap_3
* cell instance $598 m90 *1 189.98,103.36
X$598 \$I10026 VGND VPWR VGND sky130_fd_sc_hd__decap_3
* cell instance $599 m90 *1 189.98,27.2
X$599 \$I10025 VGND VPWR VGND sky130_fd_sc_hd__decap_3
* cell instance $600 m90 *1 189.98,16.32
X$600 \$I10024 VGND VPWR VGND sky130_fd_sc_hd__decap_3
* cell instance $601 m90 *1 189.98,10.88
X$601 VPWR VGND VPWR VGND sky130_fd_sc_hd__decap_3
* cell instance $602 m90 *1 189.98,114.24
X$602 \$I10022 VGND VPWR VGND sky130_fd_sc_hd__decap_3
* cell instance $603 m90 *1 189.98,266.56
X$603 \$I10021 VGND VPWR VGND sky130_fd_sc_hd__decap_3
* cell instance $604 m90 *1 189.98,277.44
X$604 \$I10020 VGND VPWR VGND sky130_fd_sc_hd__decap_3
* cell instance $605 m90 *1 189.98,97.92
X$605 \$I10019 VGND VPWR VGND sky130_fd_sc_hd__decap_3
* cell instance $606 m90 *1 189.98,76.16
X$606 \$I10018 VGND VPWR VGND sky130_fd_sc_hd__decap_3
* cell instance $607 m90 *1 189.98,92.48
X$607 \$I10017 VGND VPWR VGND sky130_fd_sc_hd__decap_3
* cell instance $608 m90 *1 189.98,87.04
X$608 \$I10016 VGND VPWR VGND sky130_fd_sc_hd__decap_3
* cell instance $609 m90 *1 189.98,282.88
X$609 \$I10015 VGND VPWR VGND sky130_fd_sc_hd__decap_3
* cell instance $610 m90 *1 189.98,272
X$610 \$I10014 VGND VPWR VGND sky130_fd_sc_hd__decap_3
* cell instance $611 m90 *1 189.98,261.12
X$611 \$I10013 VGND VPWR VGND sky130_fd_sc_hd__decap_3
* cell instance $612 m90 *1 189.98,250.24
X$612 \$I10012 VGND VPWR VGND sky130_fd_sc_hd__decap_3
* cell instance $613 m90 *1 189.98,255.68
X$613 \$I10011 VGND VPWR VGND sky130_fd_sc_hd__decap_3
* cell instance $614 m90 *1 189.98,141.44
X$614 \$I10010 VGND VPWR VGND sky130_fd_sc_hd__decap_3
* cell instance $615 m90 *1 189.98,152.32
X$615 \$I10009 VGND VPWR VGND sky130_fd_sc_hd__decap_3
* cell instance $616 m90 *1 189.98,146.88
X$616 \$I10008 VGND VPWR VGND sky130_fd_sc_hd__decap_3
* cell instance $617 m90 *1 189.98,32.64
X$617 VPWR VGND VPWR VGND sky130_fd_sc_hd__decap_3
* cell instance $618 m90 *1 189.98,81.6
X$618 \$I10006 VGND VPWR VGND sky130_fd_sc_hd__decap_3
* cell instance $619 m90 *1 189.98,125.12
X$619 \$I10005 VGND VPWR VGND sky130_fd_sc_hd__decap_3
* cell instance $620 m90 *1 189.98,130.56
X$620 \$I10004 VGND VPWR VGND sky130_fd_sc_hd__decap_3
* cell instance $621 m90 *1 189.98,43.52
X$621 \$I10003 VGND VPWR VGND sky130_fd_sc_hd__decap_3
* cell instance $622 m90 *1 189.98,157.76
X$622 \$I10002 VGND VPWR VGND sky130_fd_sc_hd__decap_3
* cell instance $623 m90 *1 189.98,48.96
X$623 \$I10001 VGND VPWR VGND sky130_fd_sc_hd__decap_3
* cell instance $624 m90 *1 189.98,38.08
X$624 VPWR VGND VPWR VGND sky130_fd_sc_hd__decap_3
* cell instance $625 m90 *1 189.98,136
X$625 \$I9999 VGND VPWR VGND sky130_fd_sc_hd__decap_3
* cell instance $626 m90 *1 189.98,239.36
X$626 \$I9998 VGND VPWR VGND sky130_fd_sc_hd__decap_3
* cell instance $627 m90 *1 189.98,201.28
X$627 \$I9997 VGND VPWR VGND sky130_fd_sc_hd__decap_3
* cell instance $628 m90 *1 189.98,179.52
X$628 VPWR VGND VPWR VGND sky130_fd_sc_hd__decap_3
* cell instance $629 m90 *1 189.98,190.4
X$629 \$I9995 VGND VPWR VGND sky130_fd_sc_hd__decap_3
* cell instance $630 m90 *1 189.98,184.96
X$630 VPWR VGND VPWR VGND sky130_fd_sc_hd__decap_3
* cell instance $631 m90 *1 189.98,195.84
X$631 \$I9993 VGND VPWR VGND sky130_fd_sc_hd__decap_3
* cell instance $632 m90 *1 189.98,217.6
X$632 \$I9992 VGND VPWR VGND sky130_fd_sc_hd__decap_3
* cell instance $633 m90 *1 189.98,206.72
X$633 \$I9991 VGND VPWR VGND sky130_fd_sc_hd__decap_3
* cell instance $634 m90 *1 189.98,212.16
X$634 \$I9990 VGND VPWR VGND sky130_fd_sc_hd__decap_3
* cell instance $635 m90 *1 189.98,119.68
X$635 \$I9989 VGND VPWR VGND sky130_fd_sc_hd__decap_3
* cell instance $636 m90 *1 189.98,70.72
X$636 \$I9988 VGND VPWR VGND sky130_fd_sc_hd__decap_3
* cell instance $637 m90 *1 189.98,108.8
X$637 \$I9987 VGND VPWR VGND sky130_fd_sc_hd__decap_3
* cell instance $638 m90 *1 189.98,65.28
X$638 \$I9986 VGND VPWR VGND sky130_fd_sc_hd__decap_3
* cell instance $639 m90 *1 189.98,54.4
X$639 \$I9985 VGND VPWR VGND sky130_fd_sc_hd__decap_3
* cell instance $640 m90 *1 189.98,223.04
X$640 \$I9984 VGND VPWR VGND sky130_fd_sc_hd__decap_3
* cell instance $641 m90 *1 189.98,228.48
X$641 \$I9983 VGND VPWR VGND sky130_fd_sc_hd__decap_3
* cell instance $642 m90 *1 189.98,244.8
X$642 \$I9982 VGND VPWR VGND sky130_fd_sc_hd__decap_3
* cell instance $643 m90 *1 189.98,163.2
X$643 \$I9981 VGND VPWR VGND sky130_fd_sc_hd__decap_3
* cell instance $644 m90 *1 189.98,174.08
X$644 \$I9980 VGND VPWR VGND sky130_fd_sc_hd__decap_3
* cell instance $645 m90 *1 189.98,168.64
X$645 \$I9979 VGND VPWR VGND sky130_fd_sc_hd__decap_3
* cell instance $646 m90 *1 189.98,233.92
X$646 \$I9978 VGND VPWR VGND sky130_fd_sc_hd__decap_3
* cell instance $647 m90 *1 189.98,59.84
X$647 \$I9977 VGND VPWR VGND sky130_fd_sc_hd__decap_3
* cell instance $648 m0 *1 10.12,239.36
X$648 \$I9976 VGND VPWR VGND sky130_fd_sc_hd__decap_3
* cell instance $649 m0 *1 10.12,228.48
X$649 \$I9975 VGND VPWR VGND sky130_fd_sc_hd__decap_3
* cell instance $650 m0 *1 10.12,244.8
X$650 \$I9974 VGND VPWR VGND sky130_fd_sc_hd__decap_3
* cell instance $651 m0 *1 10.12,54.4
X$651 \$I9973 VGND VPWR VGND sky130_fd_sc_hd__decap_3
* cell instance $652 m0 *1 10.12,212.16
X$652 \$I9972 VGND VPWR VGND sky130_fd_sc_hd__decap_3
* cell instance $653 m0 *1 10.12,217.6
X$653 \$I9971 VGND VPWR VGND sky130_fd_sc_hd__decap_3
* cell instance $654 m0 *1 10.12,288.32
X$654 \$I9970 VGND VPWR VGND sky130_fd_sc_hd__decap_3
* cell instance $655 m0 *1 10.12,233.92
X$655 \$I9969 VGND VPWR VGND sky130_fd_sc_hd__decap_3
* cell instance $656 m0 *1 10.12,261.12
X$656 \$I9968 VGND VPWR VGND sky130_fd_sc_hd__decap_3
* cell instance $657 m0 *1 10.12,266.56
X$657 \$I9967 VGND VPWR VGND sky130_fd_sc_hd__decap_3
* cell instance $658 m0 *1 10.12,255.68
X$658 \$I9966 VGND VPWR VGND sky130_fd_sc_hd__decap_3
* cell instance $659 m0 *1 10.12,282.88
X$659 \$I9965 VGND VPWR VGND sky130_fd_sc_hd__decap_3
* cell instance $660 m0 *1 10.12,21.76
X$660 \$I9964 VGND VPWR VGND sky130_fd_sc_hd__decap_3
* cell instance $661 m0 *1 10.12,250.24
X$661 \$I9963 VGND VPWR VGND sky130_fd_sc_hd__decap_3
* cell instance $662 m0 *1 10.12,272
X$662 \$I9962 VGND VPWR VGND sky130_fd_sc_hd__decap_3
* cell instance $663 m0 *1 10.12,277.44
X$663 \$I9961 VGND VPWR VGND sky130_fd_sc_hd__decap_3
* cell instance $664 m0 *1 10.12,65.28
X$664 \$I9960 VGND VPWR VGND sky130_fd_sc_hd__decap_3
* cell instance $665 m0 *1 10.12,32.64
X$665 \$I9959 VGND VPWR VGND sky130_fd_sc_hd__decap_3
* cell instance $666 m0 *1 10.12,76.16
X$666 \$I9958 VGND VPWR VGND sky130_fd_sc_hd__decap_3
* cell instance $667 m0 *1 10.12,146.88
X$667 \$I9957 VGND VPWR VGND sky130_fd_sc_hd__decap_3
* cell instance $668 m0 *1 10.12,130.56
X$668 \$I9956 VGND VPWR VGND sky130_fd_sc_hd__decap_3
* cell instance $669 m0 *1 10.12,136
X$669 \$I9955 VGND VPWR VGND sky130_fd_sc_hd__decap_3
* cell instance $670 m0 *1 10.12,125.12
X$670 \$I9954 VGND VPWR VGND sky130_fd_sc_hd__decap_3
* cell instance $671 m0 *1 10.12,152.32
X$671 \$I9953 VGND VPWR VGND sky130_fd_sc_hd__decap_3
* cell instance $672 m0 *1 10.12,157.76
X$672 \$I9952 VGND VPWR VGND sky130_fd_sc_hd__decap_3
* cell instance $673 m0 *1 10.12,141.44
X$673 \$I9951 VGND VPWR VGND sky130_fd_sc_hd__decap_3
* cell instance $674 m0 *1 10.12,201.28
X$674 \$I9950 VGND VPWR VGND sky130_fd_sc_hd__decap_3
* cell instance $675 m0 *1 10.12,184.96
X$675 \$I9949 VGND VPWR VGND sky130_fd_sc_hd__decap_3
* cell instance $676 m0 *1 10.12,174.08
X$676 \$I9948 VGND VPWR VGND sky130_fd_sc_hd__decap_3
* cell instance $677 m0 *1 10.12,179.52
X$677 \$I9947 VGND VPWR VGND sky130_fd_sc_hd__decap_3
* cell instance $678 m0 *1 10.12,195.84
X$678 \$I9946 VGND VPWR VGND sky130_fd_sc_hd__decap_3
* cell instance $679 m0 *1 10.12,190.4
X$679 \$I9945 VGND VPWR VGND sky130_fd_sc_hd__decap_3
* cell instance $680 m0 *1 10.12,27.2
X$680 \$I9944 VGND VPWR VGND sky130_fd_sc_hd__decap_3
* cell instance $681 m0 *1 10.12,92.48
X$681 \$I9943 VGND VPWR VGND sky130_fd_sc_hd__decap_3
* cell instance $682 m0 *1 10.12,87.04
X$682 \$I9942 VGND VPWR VGND sky130_fd_sc_hd__decap_3
* cell instance $683 m0 *1 10.12,81.6
X$683 \$I9941 VGND VPWR VGND sky130_fd_sc_hd__decap_3
* cell instance $684 m0 *1 10.12,97.92
X$684 \$I9940 VGND VPWR VGND sky130_fd_sc_hd__decap_3
* cell instance $685 m0 *1 10.12,163.2
X$685 \$I9939 VGND VPWR VGND sky130_fd_sc_hd__decap_3
* cell instance $686 m0 *1 10.12,114.24
X$686 \$I9938 VGND VPWR VGND sky130_fd_sc_hd__decap_3
* cell instance $687 m0 *1 10.12,108.8
X$687 \$I9937 VGND VPWR VGND sky130_fd_sc_hd__decap_3
* cell instance $688 m0 *1 10.12,103.36
X$688 \$I9936 VGND VPWR VGND sky130_fd_sc_hd__decap_3
* cell instance $689 m0 *1 10.12,59.84
X$689 \$I9935 VGND VPWR VGND sky130_fd_sc_hd__decap_3
* cell instance $690 m0 *1 10.12,48.96
X$690 \$I9934 VGND VPWR VGND sky130_fd_sc_hd__decap_3
* cell instance $691 m0 *1 10.12,70.72
X$691 \$I9933 VGND VPWR VGND sky130_fd_sc_hd__decap_3
* cell instance $692 m0 *1 10.12,223.04
X$692 \$I9932 VGND VPWR VGND sky130_fd_sc_hd__decap_3
* cell instance $693 m0 *1 10.12,206.72
X$693 \$I9931 VGND VPWR VGND sky130_fd_sc_hd__decap_3
* cell instance $694 m0 *1 10.12,38.08
X$694 \$I9930 VGND VPWR VGND sky130_fd_sc_hd__decap_3
* cell instance $695 m0 *1 10.12,43.52
X$695 \$I9929 VGND VPWR VGND sky130_fd_sc_hd__decap_3
* cell instance $696 m0 *1 10.12,168.64
X$696 \$I9928 VGND VPWR VGND sky130_fd_sc_hd__decap_3
* cell instance $697 m0 *1 10.12,119.68
X$697 \$I9927 VGND VPWR VGND sky130_fd_sc_hd__decap_3
* cell instance $698 r180 *1 189.98,103.36
X$698 \$I10019 VGND VPWR VGND sky130_fd_sc_hd__decap_3
* cell instance $699 r180 *1 189.98,65.28
X$699 \$I9977 VGND VPWR VGND sky130_fd_sc_hd__decap_3
* cell instance $700 r180 *1 189.98,141.44
X$700 \$I9999 VGND VPWR VGND sky130_fd_sc_hd__decap_3
* cell instance $701 r180 *1 189.98,195.84
X$701 \$I9995 VGND VPWR VGND sky130_fd_sc_hd__decap_3
* cell instance $702 r180 *1 189.98,130.56
X$702 \$I10005 VGND VPWR VGND sky130_fd_sc_hd__decap_3
* cell instance $703 r180 *1 189.98,272
X$703 \$I10021 VGND VPWR VGND sky130_fd_sc_hd__decap_3
* cell instance $704 r180 *1 189.98,206.72
X$704 \$I9997 VGND VPWR VGND sky130_fd_sc_hd__decap_3
* cell instance $705 r180 *1 189.98,282.88
X$705 \$I10020 VGND VPWR VGND sky130_fd_sc_hd__decap_3
* cell instance $706 r180 *1 189.98,277.44
X$706 \$I10014 VGND VPWR VGND sky130_fd_sc_hd__decap_3
* cell instance $707 r180 *1 189.98,97.92
X$707 \$I10017 VGND VPWR VGND sky130_fd_sc_hd__decap_3
* cell instance $708 r180 *1 189.98,87.04
X$708 \$I10006 VGND VPWR VGND sky130_fd_sc_hd__decap_3
* cell instance $709 r180 *1 189.98,16.32
X$709 VPWR VGND VPWR VGND sky130_fd_sc_hd__decap_3
* cell instance $710 r180 *1 189.98,136
X$710 \$I10004 VGND VPWR VGND sky130_fd_sc_hd__decap_3
* cell instance $711 r180 *1 189.98,119.68
X$711 \$I10022 VGND VPWR VGND sky130_fd_sc_hd__decap_3
* cell instance $712 r180 *1 189.98,223.04
X$712 \$I9992 VGND VPWR VGND sky130_fd_sc_hd__decap_3
* cell instance $713 r180 *1 189.98,184.96
X$713 VPWR VGND VPWR VGND sky130_fd_sc_hd__decap_3
* cell instance $714 r180 *1 189.98,217.6
X$714 \$I9990 VGND VPWR VGND sky130_fd_sc_hd__decap_3
* cell instance $715 r180 *1 189.98,21.76
X$715 \$I10024 VGND VPWR VGND sky130_fd_sc_hd__decap_3
* cell instance $716 r180 *1 189.98,27.2
X$716 VPWR VGND VPWR VGND sky130_fd_sc_hd__decap_3
* cell instance $717 r180 *1 189.98,288.32
X$717 \$I10015 VGND VPWR VGND sky130_fd_sc_hd__decap_3
* cell instance $718 r180 *1 189.98,255.68
X$718 \$I10012 VGND VPWR VGND sky130_fd_sc_hd__decap_3
* cell instance $719 r180 *1 189.98,190.4
X$719 VPWR VGND VPWR VGND sky130_fd_sc_hd__decap_3
* cell instance $720 r180 *1 189.98,228.48
X$720 \$I9984 VGND VPWR VGND sky130_fd_sc_hd__decap_3
* cell instance $721 r180 *1 189.98,81.6
X$721 \$I10018 VGND VPWR VGND sky130_fd_sc_hd__decap_3
* cell instance $722 r180 *1 189.98,250.24
X$722 \$I9982 VGND VPWR VGND sky130_fd_sc_hd__decap_3
* cell instance $723 r180 *1 189.98,201.28
X$723 \$I9993 VGND VPWR VGND sky130_fd_sc_hd__decap_3
* cell instance $724 r180 *1 189.98,261.12
X$724 \$I10011 VGND VPWR VGND sky130_fd_sc_hd__decap_3
* cell instance $725 r180 *1 189.98,239.36
X$725 \$I9978 VGND VPWR VGND sky130_fd_sc_hd__decap_3
* cell instance $726 r180 *1 189.98,179.52
X$726 \$I9980 VGND VPWR VGND sky130_fd_sc_hd__decap_3
* cell instance $727 r180 *1 189.98,152.32
X$727 \$I10008 VGND VPWR VGND sky130_fd_sc_hd__decap_3
* cell instance $728 r180 *1 189.98,163.2
X$728 \$I10002 VGND VPWR VGND sky130_fd_sc_hd__decap_3
* cell instance $729 r180 *1 189.98,244.8
X$729 \$I9998 VGND VPWR VGND sky130_fd_sc_hd__decap_3
* cell instance $730 r180 *1 189.98,174.08
X$730 \$I9979 VGND VPWR VGND sky130_fd_sc_hd__decap_3
* cell instance $731 r180 *1 189.98,108.8
X$731 \$I10026 VGND VPWR VGND sky130_fd_sc_hd__decap_3
* cell instance $732 r180 *1 189.98,157.76
X$732 \$I10009 VGND VPWR VGND sky130_fd_sc_hd__decap_3
* cell instance $733 r180 *1 189.98,168.64
X$733 \$I9981 VGND VPWR VGND sky130_fd_sc_hd__decap_3
* cell instance $734 r180 *1 189.98,54.4
X$734 \$I10001 VGND VPWR VGND sky130_fd_sc_hd__decap_3
* cell instance $735 r180 *1 189.98,233.92
X$735 \$I9983 VGND VPWR VGND sky130_fd_sc_hd__decap_3
* cell instance $736 r180 *1 189.98,146.88
X$736 \$I10010 VGND VPWR VGND sky130_fd_sc_hd__decap_3
* cell instance $737 r180 *1 189.98,92.48
X$737 \$I10016 VGND VPWR VGND sky130_fd_sc_hd__decap_3
* cell instance $738 r180 *1 189.98,125.12
X$738 \$I9989 VGND VPWR VGND sky130_fd_sc_hd__decap_3
* cell instance $739 r180 *1 189.98,266.56
X$739 \$I10013 VGND VPWR VGND sky130_fd_sc_hd__decap_3
* cell instance $740 r180 *1 189.98,32.64
X$740 \$I10025 VGND VPWR VGND sky130_fd_sc_hd__decap_3
* cell instance $741 r180 *1 189.98,114.24
X$741 \$I9987 VGND VPWR VGND sky130_fd_sc_hd__decap_3
* cell instance $742 r180 *1 189.98,43.52
X$742 VPWR VGND VPWR VGND sky130_fd_sc_hd__decap_3
* cell instance $743 r180 *1 189.98,48.96
X$743 \$I10003 VGND VPWR VGND sky130_fd_sc_hd__decap_3
* cell instance $744 r180 *1 189.98,70.72
X$744 \$I9986 VGND VPWR VGND sky130_fd_sc_hd__decap_3
* cell instance $745 r180 *1 189.98,59.84
X$745 \$I9985 VGND VPWR VGND sky130_fd_sc_hd__decap_3
* cell instance $746 r180 *1 189.98,38.08
X$746 VPWR VGND VPWR VGND sky130_fd_sc_hd__decap_3
* cell instance $747 r180 *1 189.98,76.16
X$747 \$I9988 VGND VPWR VGND sky130_fd_sc_hd__decap_3
* cell instance $748 r180 *1 189.98,212.16
X$748 \$I9991 VGND VPWR VGND sky130_fd_sc_hd__decap_3
* cell instance $749 r0 *1 10.12,277.44
X$749 \$I9965 VGND VPWR VGND sky130_fd_sc_hd__decap_3
* cell instance $750 r0 *1 10.12,146.88
X$750 \$I9953 VGND VPWR VGND sky130_fd_sc_hd__decap_3
* cell instance $751 r0 *1 10.12,130.56
X$751 \$I9955 VGND VPWR VGND sky130_fd_sc_hd__decap_3
* cell instance $752 r0 *1 10.12,43.52
X$752 \$I9934 VGND VPWR VGND sky130_fd_sc_hd__decap_3
* cell instance $753 r0 *1 10.12,223.04
X$753 \$I9975 VGND VPWR VGND sky130_fd_sc_hd__decap_3
* cell instance $754 r0 *1 10.12,70.72
X$754 \$I9958 VGND VPWR VGND sky130_fd_sc_hd__decap_3
* cell instance $755 r0 *1 10.12,108.8
X$755 \$I9938 VGND VPWR VGND sky130_fd_sc_hd__decap_3
* cell instance $756 r0 *1 10.12,141.44
X$756 \$I9957 VGND VPWR VGND sky130_fd_sc_hd__decap_3
* cell instance $757 r0 *1 10.12,250.24
X$757 \$I9966 VGND VPWR VGND sky130_fd_sc_hd__decap_3
* cell instance $758 r0 *1 10.12,190.4
X$758 \$I9946 VGND VPWR VGND sky130_fd_sc_hd__decap_3
* cell instance $759 r0 *1 10.12,87.04
X$759 \$I9943 VGND VPWR VGND sky130_fd_sc_hd__decap_3
* cell instance $760 r0 *1 10.12,233.92
X$760 \$I9976 VGND VPWR VGND sky130_fd_sc_hd__decap_3
* cell instance $761 r0 *1 10.12,163.2
X$761 \$I9928 VGND VPWR VGND sky130_fd_sc_hd__decap_3
* cell instance $762 r0 *1 10.12,179.52
X$762 \$I9949 VGND VPWR VGND sky130_fd_sc_hd__decap_3
* cell instance $763 r0 *1 10.12,174.08
X$763 \$I9947 VGND VPWR VGND sky130_fd_sc_hd__decap_3
* cell instance $764 r0 *1 10.12,217.6
X$764 \$I9932 VGND VPWR VGND sky130_fd_sc_hd__decap_3
* cell instance $765 r0 *1 10.12,168.64
X$765 \$I9948 VGND VPWR VGND sky130_fd_sc_hd__decap_3
* cell instance $766 r0 *1 10.12,239.36
X$766 \$I9974 VGND VPWR VGND sky130_fd_sc_hd__decap_3
* cell instance $767 r0 *1 10.12,103.36
X$767 \$I9937 VGND VPWR VGND sky130_fd_sc_hd__decap_3
* cell instance $768 r0 *1 10.12,32.64
X$768 \$I9930 VGND VPWR VGND sky130_fd_sc_hd__decap_3
* cell instance $769 r0 *1 10.12,114.24
X$769 \$I9927 VGND VPWR VGND sky130_fd_sc_hd__decap_3
* cell instance $770 r0 *1 10.12,184.96
X$770 \$I9945 VGND VPWR VGND sky130_fd_sc_hd__decap_3
* cell instance $771 r0 *1 10.12,255.68
X$771 \$I9968 VGND VPWR VGND sky130_fd_sc_hd__decap_3
* cell instance $772 r0 *1 10.12,97.92
X$772 \$I9936 VGND VPWR VGND sky130_fd_sc_hd__decap_3
* cell instance $773 r0 *1 10.12,201.28
X$773 \$I9931 VGND VPWR VGND sky130_fd_sc_hd__decap_3
* cell instance $774 r0 *1 10.12,228.48
X$774 \$I9969 VGND VPWR VGND sky130_fd_sc_hd__decap_3
* cell instance $775 r0 *1 10.12,92.48
X$775 \$I9940 VGND VPWR VGND sky130_fd_sc_hd__decap_3
* cell instance $776 r0 *1 10.12,261.12
X$776 \$I9967 VGND VPWR VGND sky130_fd_sc_hd__decap_3
* cell instance $777 r0 *1 10.12,81.6
X$777 \$I9942 VGND VPWR VGND sky130_fd_sc_hd__decap_3
* cell instance $778 r0 *1 10.12,266.56
X$778 \$I9962 VGND VPWR VGND sky130_fd_sc_hd__decap_3
* cell instance $779 r0 *1 10.12,59.84
X$779 \$I9960 VGND VPWR VGND sky130_fd_sc_hd__decap_3
* cell instance $780 r0 *1 10.12,136
X$780 \$I9951 VGND VPWR VGND sky130_fd_sc_hd__decap_3
* cell instance $781 r0 *1 10.12,157.76
X$781 \$I9939 VGND VPWR VGND sky130_fd_sc_hd__decap_3
* cell instance $782 r0 *1 10.12,152.32
X$782 \$I9952 VGND VPWR VGND sky130_fd_sc_hd__decap_3
* cell instance $783 r0 *1 10.12,27.2
X$783 \$I9959 VGND VPWR VGND sky130_fd_sc_hd__decap_3
* cell instance $784 r0 *1 10.12,48.96
X$784 \$I9973 VGND VPWR VGND sky130_fd_sc_hd__decap_3
* cell instance $785 r0 *1 10.12,195.84
X$785 \$I9950 VGND VPWR VGND sky130_fd_sc_hd__decap_3
* cell instance $786 r0 *1 10.12,76.16
X$786 \$I9941 VGND VPWR VGND sky130_fd_sc_hd__decap_3
* cell instance $787 r0 *1 10.12,206.72
X$787 \$I9972 VGND VPWR VGND sky130_fd_sc_hd__decap_3
* cell instance $788 r0 *1 10.12,272
X$788 \$I9961 VGND VPWR VGND sky130_fd_sc_hd__decap_3
* cell instance $789 r0 *1 10.12,10.88
X$789 \$I9835 VGND VPWR VGND sky130_fd_sc_hd__decap_3
* cell instance $790 m0 *1 10.12,16.32
X$790 \$I9835 VGND VPWR VGND sky130_fd_sc_hd__decap_3
* cell instance $791 r0 *1 10.12,38.08
X$791 \$I9929 VGND VPWR VGND sky130_fd_sc_hd__decap_3
* cell instance $792 r0 *1 10.12,119.68
X$792 \$I9954 VGND VPWR VGND sky130_fd_sc_hd__decap_3
* cell instance $793 r0 *1 10.12,54.4
X$793 \$I9935 VGND VPWR VGND sky130_fd_sc_hd__decap_3
* cell instance $794 r0 *1 10.12,212.16
X$794 \$I9971 VGND VPWR VGND sky130_fd_sc_hd__decap_3
* cell instance $795 r0 *1 10.12,282.88
X$795 \$I9970 VGND VPWR VGND sky130_fd_sc_hd__decap_3
* cell instance $796 r0 *1 10.12,125.12
X$796 \$I9956 VGND VPWR VGND sky130_fd_sc_hd__decap_3
* cell instance $797 r0 *1 10.12,16.32
X$797 \$I9964 VGND VPWR VGND sky130_fd_sc_hd__decap_3
* cell instance $798 r0 *1 10.12,65.28
X$798 \$I9933 VGND VPWR VGND sky130_fd_sc_hd__decap_3
* cell instance $799 r0 *1 10.12,244.8
X$799 \$I9963 VGND VPWR VGND sky130_fd_sc_hd__decap_3
* cell instance $800 r0 *1 10.12,21.76
X$800 \$I9944 VGND VPWR VGND sky130_fd_sc_hd__decap_3
* cell instance $801 r0 *1 71.07,151.13
X$801 VPWR VIA_M1M2_PR
* cell instance $802 r0 *1 71.53,99.45
X$802 VPWR VIA_M1M2_PR
* cell instance $803 r0 *1 71.07,151.13
X$803 VPWR VIA_L1M1_PR_MR
* cell instance $804 r0 *1 77.51,99.45
X$804 VPWR VIA_L1M1_PR_MR
* cell instance $805 r0 *1 116.44,29.92
X$805 VPWR VIA_via4_5_2000_480_1_5_400_400
* cell instance $806 r0 *1 56.44,274.72
X$806 VPWR VIA_via4_5_2000_480_1_5_400_400
* cell instance $807 r0 *1 176.44,111.52
X$807 VPWR VIA_via4_5_2000_480_1_5_400_400
* cell instance $808 r0 *1 116.44,165.92
X$808 VPWR VIA_via4_5_2000_480_1_5_400_400
* cell instance $809 r0 *1 176.44,116.96
X$809 VPWR VIA_via4_5_2000_480_1_5_400_400
* cell instance $810 r0 *1 56.44,280.16
X$810 VPWR VIA_via4_5_2000_480_1_5_400_400
* cell instance $811 r0 *1 176.44,100.64
X$811 VPWR VIA_via4_5_2000_480_1_5_400_400
* cell instance $812 r0 *1 56.44,269.28
X$812 VPWR VIA_via4_5_2000_480_1_5_400_400
* cell instance $813 r0 *1 176.44,106.08
X$813 VPWR VIA_via4_5_2000_480_1_5_400_400
* cell instance $814 r0 *1 86.44,182.24
X$814 VPWR VIA_via4_5_2000_480_1_5_400_400
* cell instance $815 r0 *1 116.44,258.4
X$815 VPWR VIA_via4_5_2000_480_1_5_400_400
* cell instance $816 r0 *1 116.44,68
X$816 VPWR VIA_via4_5_2000_480_1_5_400_400
* cell instance $817 r0 *1 116.44,24.48
X$817 VPWR VIA_via4_5_2000_480_1_5_400_400
* cell instance $818 r0 *1 116.44,171.36
X$818 VPWR VIA_via4_5_2000_480_1_5_400_400
* cell instance $819 r0 *1 146.44,165.92
X$819 VPWR VIA_via4_5_2000_480_1_5_400_400
* cell instance $820 r0 *1 86.44,165.92
X$820 VPWR VIA_via4_5_2000_480_1_5_400_400
* cell instance $821 r0 *1 116.44,46.24
X$821 VPWR VIA_via4_5_2000_480_1_5_400_400
* cell instance $822 r0 *1 56.44,247.52
X$822 VPWR VIA_via4_5_2000_480_1_5_400_400
* cell instance $823 r0 *1 116.44,182.24
X$823 VPWR VIA_via4_5_2000_480_1_5_400_400
* cell instance $824 r0 *1 116.44,13.6
X$824 VPWR VIA_via4_5_2000_480_1_5_400_400
* cell instance $825 r0 *1 56.44,160.48
X$825 VPWR VIA_via4_5_2000_480_1_5_400_400
* cell instance $826 r0 *1 116.44,187.68
X$826 VPWR VIA_via4_5_2000_480_1_5_400_400
* cell instance $827 r0 *1 116.44,263.84
X$827 VPWR VIA_via4_5_2000_480_1_5_400_400
* cell instance $828 r0 *1 116.44,193.12
X$828 VPWR VIA_via4_5_2000_480_1_5_400_400
* cell instance $829 r0 *1 116.44,73.44
X$829 VPWR VIA_via4_5_2000_480_1_5_400_400
* cell instance $830 r0 *1 86.44,160.48
X$830 VPWR VIA_via4_5_2000_480_1_5_400_400
* cell instance $831 r0 *1 116.44,19.04
X$831 VPWR VIA_via4_5_2000_480_1_5_400_400
* cell instance $832 r0 *1 116.44,198.56
X$832 VPWR VIA_via4_5_2000_480_1_5_400_400
* cell instance $833 r0 *1 56.44,285.6
X$833 VPWR VIA_via4_5_2000_480_1_5_400_400
* cell instance $834 r0 *1 176.44,78.88
X$834 VPWR VIA_via4_5_2000_480_1_5_400_400
* cell instance $835 r0 *1 176.44,57.12
X$835 VPWR VIA_via4_5_2000_480_1_5_400_400
* cell instance $836 r0 *1 176.44,176.8
X$836 VPWR VIA_via4_5_2000_480_1_5_400_400
* cell instance $837 r0 *1 26.44,111.52
X$837 VPWR VIA_via4_5_2000_480_1_5_400_400
* cell instance $838 r0 *1 26.44,116.96
X$838 VPWR VIA_via4_5_2000_480_1_5_400_400
* cell instance $839 r0 *1 26.44,100.64
X$839 VPWR VIA_via4_5_2000_480_1_5_400_400
* cell instance $840 r0 *1 26.44,95.2
X$840 VPWR VIA_via4_5_2000_480_1_5_400_400
* cell instance $841 r0 *1 26.44,78.88
X$841 VPWR VIA_via4_5_2000_480_1_5_400_400
* cell instance $842 r0 *1 26.44,89.76
X$842 VPWR VIA_via4_5_2000_480_1_5_400_400
* cell instance $843 r0 *1 26.44,84.32
X$843 VPWR VIA_via4_5_2000_480_1_5_400_400
* cell instance $844 r0 *1 26.44,57.12
X$844 VPWR VIA_via4_5_2000_480_1_5_400_400
* cell instance $845 r0 *1 26.44,57.53
X$845 VPWR VIA_via5_6_2000_2000_1_1_1600_1600
* cell instance $846 r0 *1 26.44,35.36
X$846 VPWR VIA_via4_5_2000_480_1_5_400_400
* cell instance $847 r0 *1 26.44,68
X$847 VPWR VIA_via4_5_2000_480_1_5_400_400
* cell instance $848 r0 *1 26.44,106.08
X$848 VPWR VIA_via4_5_2000_480_1_5_400_400
* cell instance $849 r0 *1 86.44,144.16
X$849 VPWR VIA_via4_5_2000_480_1_5_400_400
* cell instance $850 r0 *1 116.44,220.32
X$850 VPWR VIA_via4_5_2000_480_1_5_400_400
* cell instance $851 r0 *1 176.44,171.36
X$851 VPWR VIA_via4_5_2000_480_1_5_400_400
* cell instance $852 r0 *1 116.44,35.36
X$852 VPWR VIA_via4_5_2000_480_1_5_400_400
* cell instance $853 r0 *1 86.44,198.56
X$853 VPWR VIA_via4_5_2000_480_1_5_400_400
* cell instance $854 r0 *1 116.44,214.88
X$854 VPWR VIA_via4_5_2000_480_1_5_400_400
* cell instance $855 r0 *1 176.44,73.44
X$855 VPWR VIA_via4_5_2000_480_1_5_400_400
* cell instance $856 r0 *1 176.44,68
X$856 VPWR VIA_via4_5_2000_480_1_5_400_400
* cell instance $857 r0 *1 176.44,62.56
X$857 VPWR VIA_via4_5_2000_480_1_5_400_400
* cell instance $858 r0 *1 176.44,138.72
X$858 VPWR VIA_via4_5_2000_480_1_5_400_400
* cell instance $859 r0 *1 116.44,176.8
X$859 VPWR VIA_via4_5_2000_480_1_5_400_400
* cell instance $860 r0 *1 116.44,209.44
X$860 VPWR VIA_via4_5_2000_480_1_5_400_400
* cell instance $861 r0 *1 26.44,46.24
X$861 VPWR VIA_via4_5_2000_480_1_5_400_400
* cell instance $862 r0 *1 116.44,204
X$862 VPWR VIA_via4_5_2000_480_1_5_400_400
* cell instance $863 r0 *1 176.44,133.28
X$863 VPWR VIA_via4_5_2000_480_1_5_400_400
* cell instance $864 r0 *1 176.44,127.84
X$864 VPWR VIA_via4_5_2000_480_1_5_400_400
* cell instance $865 r0 *1 176.44,122.4
X$865 VPWR VIA_via4_5_2000_480_1_5_400_400
* cell instance $866 r0 *1 176.44,165.92
X$866 VPWR VIA_via4_5_2000_480_1_5_400_400
* cell instance $867 r0 *1 56.44,225.76
X$867 VPWR VIA_via4_5_2000_480_1_5_400_400
* cell instance $868 r0 *1 26.44,62.56
X$868 VPWR VIA_via4_5_2000_480_1_5_400_400
* cell instance $869 r0 *1 26.44,40.8
X$869 VPWR VIA_via4_5_2000_480_1_5_400_400
* cell instance $870 r0 *1 26.44,73.44
X$870 VPWR VIA_via4_5_2000_480_1_5_400_400
* cell instance $871 r0 *1 26.44,51.68
X$871 VPWR VIA_via4_5_2000_480_1_5_400_400
* cell instance $872 r0 *1 86.44,171.36
X$872 VPWR VIA_via4_5_2000_480_1_5_400_400
* cell instance $873 r0 *1 56.44,231.2
X$873 VPWR VIA_via4_5_2000_480_1_5_400_400
* cell instance $874 r0 *1 56.44,236.64
X$874 VPWR VIA_via4_5_2000_480_1_5_400_400
* cell instance $875 r0 *1 56.44,242.08
X$875 VPWR VIA_via4_5_2000_480_1_5_400_400
* cell instance $876 r0 *1 176.44,84.32
X$876 VPWR VIA_via4_5_2000_480_1_5_400_400
* cell instance $877 r0 *1 176.44,149.6
X$877 VPWR VIA_via4_5_2000_480_1_5_400_400
* cell instance $878 r0 *1 176.44,155.04
X$878 VPWR VIA_via4_5_2000_480_1_5_400_400
* cell instance $879 r0 *1 86.44,155.04
X$879 VPWR VIA_via4_5_2000_480_1_5_400_400
* cell instance $880 r0 *1 176.44,89.76
X$880 VPWR VIA_via4_5_2000_480_1_5_400_400
* cell instance $881 r0 *1 86.44,193.12
X$881 VPWR VIA_via4_5_2000_480_1_5_400_400
* cell instance $882 r0 *1 176.44,95.2
X$882 VPWR VIA_via4_5_2000_480_1_5_400_400
* cell instance $883 r0 *1 146.44,13.6
X$883 VPWR VIA_via4_5_2000_480_1_5_400_400
* cell instance $884 r0 *1 146.44,220.32
X$884 VPWR VIA_via4_5_2000_480_1_5_400_400
* cell instance $885 r0 *1 146.44,19.04
X$885 VPWR VIA_via4_5_2000_480_1_5_400_400
* cell instance $886 r0 *1 146.44,24.48
X$886 VPWR VIA_via4_5_2000_480_1_5_400_400
* cell instance $887 r0 *1 146.44,29.92
X$887 VPWR VIA_via4_5_2000_480_1_5_400_400
* cell instance $888 r0 *1 56.44,19.04
X$888 VPWR VIA_via4_5_2000_480_1_5_400_400
* cell instance $889 r0 *1 56.44,24.48
X$889 VPWR VIA_via4_5_2000_480_1_5_400_400
* cell instance $890 r0 *1 56.44,29.92
X$890 VPWR VIA_via4_5_2000_480_1_5_400_400
* cell instance $891 r0 *1 146.44,225.76
X$891 VPWR VIA_via4_5_2000_480_1_5_400_400
* cell instance $892 r0 *1 116.44,57.12
X$892 VPWR VIA_via4_5_2000_480_1_5_400_400
* cell instance $893 r0 *1 176.44,144.16
X$893 VPWR VIA_via4_5_2000_480_1_5_400_400
* cell instance $894 r0 *1 86.44,29.92
X$894 VPWR VIA_via4_5_2000_480_1_5_400_400
* cell instance $895 r0 *1 146.44,204
X$895 VPWR VIA_via4_5_2000_480_1_5_400_400
* cell instance $896 r0 *1 146.44,209.44
X$896 VPWR VIA_via4_5_2000_480_1_5_400_400
* cell instance $897 r0 *1 146.44,214.88
X$897 VPWR VIA_via4_5_2000_480_1_5_400_400
* cell instance $898 r0 *1 116.44,236.64
X$898 VPWR VIA_via4_5_2000_480_1_5_400_400
* cell instance $899 r0 *1 86.44,13.6
X$899 VPWR VIA_via4_5_2000_480_1_5_400_400
* cell instance $900 r0 *1 86.44,280.16
X$900 VPWR VIA_via4_5_2000_480_1_5_400_400
* cell instance $901 r0 *1 146.44,242.08
X$901 VPWR VIA_via4_5_2000_480_1_5_400_400
* cell instance $902 r0 *1 86.44,274.72
X$902 VPWR VIA_via4_5_2000_480_1_5_400_400
* cell instance $903 r0 *1 116.44,225.76
X$903 VPWR VIA_via4_5_2000_480_1_5_400_400
* cell instance $904 r0 *1 146.44,231.2
X$904 VPWR VIA_via4_5_2000_480_1_5_400_400
* cell instance $905 r0 *1 146.44,46.24
X$905 VPWR VIA_via4_5_2000_480_1_5_400_400
* cell instance $906 r0 *1 86.44,269.28
X$906 VPWR VIA_via4_5_2000_480_1_5_400_400
* cell instance $907 r0 *1 86.44,263.84
X$907 VPWR VIA_via4_5_2000_480_1_5_400_400
* cell instance $908 r0 *1 86.44,247.52
X$908 VPWR VIA_via4_5_2000_480_1_5_400_400
* cell instance $909 r0 *1 86.44,252.96
X$909 VPWR VIA_via4_5_2000_480_1_5_400_400
* cell instance $910 r0 *1 56.44,182.24
X$910 VPWR VIA_via4_5_2000_480_1_5_400_400
* cell instance $911 r0 *1 86.44,258.4
X$911 VPWR VIA_via4_5_2000_480_1_5_400_400
* cell instance $912 r0 *1 56.44,187.68
X$912 VPWR VIA_via4_5_2000_480_1_5_400_400
* cell instance $913 r0 *1 116.44,242.08
X$913 VPWR VIA_via4_5_2000_480_1_5_400_400
* cell instance $914 r0 *1 146.44,236.64
X$914 VPWR VIA_via4_5_2000_480_1_5_400_400
* cell instance $915 r0 *1 116.44,231.2
X$915 VPWR VIA_via4_5_2000_480_1_5_400_400
* cell instance $916 r0 *1 86.44,187.68
X$916 VPWR VIA_via4_5_2000_480_1_5_400_400
* cell instance $917 r0 *1 86.44,285.6
X$917 VPWR VIA_via4_5_2000_480_1_5_400_400
* cell instance $918 r0 *1 86.44,176.8
X$918 VPWR VIA_via4_5_2000_480_1_5_400_400
* cell instance $919 r0 *1 116.44,40.8
X$919 VPWR VIA_via4_5_2000_480_1_5_400_400
* cell instance $920 r0 *1 146.44,68
X$920 VPWR VIA_via4_5_2000_480_1_5_400_400
* cell instance $921 r0 *1 56.44,13.6
X$921 VPWR VIA_via4_5_2000_480_1_5_400_400
* cell instance $922 r0 *1 146.44,62.56
X$922 VPWR VIA_via4_5_2000_480_1_5_400_400
* cell instance $923 r0 *1 146.44,57.12
X$923 VPWR VIA_via4_5_2000_480_1_5_400_400
* cell instance $924 r0 *1 146.44,40.8
X$924 VPWR VIA_via4_5_2000_480_1_5_400_400
* cell instance $925 r0 *1 146.44,51.68
X$925 VPWR VIA_via4_5_2000_480_1_5_400_400
* cell instance $926 r0 *1 146.44,73.44
X$926 VPWR VIA_via4_5_2000_480_1_5_400_400
* cell instance $927 r0 *1 146.44,187.68
X$927 VPWR VIA_via4_5_2000_480_1_5_400_400
* cell instance $928 r0 *1 56.44,258.4
X$928 VPWR VIA_via4_5_2000_480_1_5_400_400
* cell instance $929 r0 *1 56.44,144.16
X$929 VPWR VIA_via4_5_2000_480_1_5_400_400
* cell instance $930 r0 *1 146.44,193.12
X$930 VPWR VIA_via4_5_2000_480_1_5_400_400
* cell instance $931 r0 *1 56.44,138.72
X$931 VPWR VIA_via4_5_2000_480_1_5_400_400
* cell instance $932 r0 *1 116.44,51.68
X$932 VPWR VIA_via4_5_2000_480_1_5_400_400
* cell instance $933 r0 *1 146.44,198.56
X$933 VPWR VIA_via4_5_2000_480_1_5_400_400
* cell instance $934 r0 *1 26.44,29.92
X$934 VPWR VIA_via4_5_2000_480_1_5_400_400
* cell instance $935 r0 *1 146.44,171.36
X$935 VPWR VIA_via4_5_2000_480_1_5_400_400
* cell instance $936 r0 *1 116.44,247.52
X$936 VPWR VIA_via4_5_2000_480_1_5_400_400
* cell instance $937 r0 *1 56.44,127.84
X$937 VPWR VIA_via4_5_2000_480_1_5_400_400
* cell instance $938 r0 *1 56.44,133.28
X$938 VPWR VIA_via4_5_2000_480_1_5_400_400
* cell instance $939 r0 *1 56.44,252.96
X$939 VPWR VIA_via4_5_2000_480_1_5_400_400
* cell instance $940 r0 *1 116.44,252.96
X$940 VPWR VIA_via4_5_2000_480_1_5_400_400
* cell instance $941 r0 *1 56.44,122.4
X$941 VPWR VIA_via4_5_2000_480_1_5_400_400
* cell instance $942 r0 *1 146.44,176.8
X$942 VPWR VIA_via4_5_2000_480_1_5_400_400
* cell instance $943 r0 *1 146.44,182.24
X$943 VPWR VIA_via4_5_2000_480_1_5_400_400
* cell instance $944 r0 *1 26.44,19.04
X$944 VPWR VIA_via4_5_2000_480_1_5_400_400
* cell instance $945 r0 *1 86.44,19.04
X$945 VPWR VIA_via4_5_2000_480_1_5_400_400
* cell instance $946 r0 *1 56.44,193.12
X$946 VPWR VIA_via4_5_2000_480_1_5_400_400
* cell instance $947 r0 *1 56.44,155.04
X$947 VPWR VIA_via4_5_2000_480_1_5_400_400
* cell instance $948 r0 *1 56.44,176.8
X$948 VPWR VIA_via4_5_2000_480_1_5_400_400
* cell instance $949 r0 *1 56.44,171.36
X$949 VPWR VIA_via4_5_2000_480_1_5_400_400
* cell instance $950 r0 *1 116.44,62.56
X$950 VPWR VIA_via4_5_2000_480_1_5_400_400
* cell instance $951 r0 *1 56.44,149.6
X$951 VPWR VIA_via4_5_2000_480_1_5_400_400
* cell instance $952 r0 *1 86.44,24.48
X$952 VPWR VIA_via4_5_2000_480_1_5_400_400
* cell instance $953 r0 *1 56.44,165.92
X$953 VPWR VIA_via4_5_2000_480_1_5_400_400
* cell instance $954 r0 *1 146.44,35.36
X$954 VPWR VIA_via4_5_2000_480_1_5_400_400
* cell instance $955 r0 *1 146.44,160.48
X$955 VPWR VIA_via4_5_2000_480_1_5_400_400
* cell instance $956 r0 *1 116.44,160.48
X$956 VPWR VIA_via4_5_2000_480_1_5_400_400
* cell instance $957 r0 *1 26.44,13.6
X$957 VPWR VIA_via4_5_2000_480_1_5_400_400
* cell instance $958 r0 *1 26.44,24.48
X$958 VPWR VIA_via4_5_2000_480_1_5_400_400
* cell instance $959 r0 *1 56.44,198.56
X$959 VPWR VIA_via4_5_2000_480_1_5_400_400
* cell instance $960 r0 *1 56.44,263.84
X$960 VPWR VIA_via4_5_2000_480_1_5_400_400
* cell instance $961 r0 *1 56.44,100.64
X$961 VPWR VIA_via4_5_2000_480_1_5_400_400
* cell instance $962 r0 *1 86.44,122.4
X$962 VPWR VIA_via4_5_2000_480_1_5_400_400
* cell instance $963 r0 *1 176.44,198.56
X$963 VPWR VIA_via4_5_2000_480_1_5_400_400
* cell instance $964 r0 *1 116.44,127.84
X$964 VPWR VIA_via4_5_2000_480_1_5_400_400
* cell instance $965 r0 *1 56.44,84.32
X$965 VPWR VIA_via4_5_2000_480_1_5_400_400
* cell instance $966 r0 *1 116.44,138.72
X$966 VPWR VIA_via4_5_2000_480_1_5_400_400
* cell instance $967 r0 *1 86.44,220.32
X$967 VPWR VIA_via4_5_2000_480_1_5_400_400
* cell instance $968 r0 *1 86.44,225.76
X$968 VPWR VIA_via4_5_2000_480_1_5_400_400
* cell instance $969 r0 *1 116.44,122.4
X$969 VPWR VIA_via4_5_2000_480_1_5_400_400
* cell instance $970 r0 *1 26.44,138.72
X$970 VPWR VIA_via4_5_2000_480_1_5_400_400
* cell instance $971 r0 *1 56.44,73.44
X$971 VPWR VIA_via4_5_2000_480_1_5_400_400
* cell instance $972 r0 *1 26.44,127.84
X$972 VPWR VIA_via4_5_2000_480_1_5_400_400
* cell instance $973 r0 *1 56.44,35.36
X$973 VPWR VIA_via4_5_2000_480_1_5_400_400
* cell instance $974 r0 *1 56.44,106.08
X$974 VPWR VIA_via4_5_2000_480_1_5_400_400
* cell instance $975 r0 *1 56.44,46.24
X$975 VPWR VIA_via4_5_2000_480_1_5_400_400
* cell instance $976 r0 *1 146.44,149.6
X$976 VPWR VIA_via4_5_2000_480_1_5_400_400
* cell instance $977 r0 *1 176.44,19.04
X$977 VPWR VIA_via4_5_2000_480_1_5_400_400
* cell instance $978 r0 *1 146.44,269.28
X$978 VPWR VIA_via4_5_2000_480_1_5_400_400
* cell instance $979 r0 *1 116.44,89.76
X$979 VPWR VIA_via4_5_2000_480_1_5_400_400
* cell instance $980 r0 *1 176.44,13.6
X$980 VPWR VIA_via4_5_2000_480_1_5_400_400
* cell instance $981 r0 *1 56.44,51.68
X$981 VPWR VIA_via4_5_2000_480_1_5_400_400
* cell instance $982 r0 *1 56.44,40.8
X$982 VPWR VIA_via4_5_2000_480_1_5_400_400
* cell instance $983 r0 *1 146.44,280.16
X$983 VPWR VIA_via4_5_2000_480_1_5_400_400
* cell instance $984 r0 *1 146.44,274.72
X$984 VPWR VIA_via4_5_2000_480_1_5_400_400
* cell instance $985 r0 *1 176.44,263.84
X$985 VPWR VIA_via4_5_2000_480_1_5_400_400
* cell instance $986 r0 *1 176.44,274.72
X$986 VPWR VIA_via4_5_2000_480_1_5_400_400
* cell instance $987 r0 *1 116.44,100.64
X$987 VPWR VIA_via4_5_2000_480_1_5_400_400
* cell instance $988 r0 *1 176.44,258.4
X$988 VPWR VIA_via4_5_2000_480_1_5_400_400
* cell instance $989 r0 *1 116.44,106.08
X$989 VPWR VIA_via4_5_2000_480_1_5_400_400
* cell instance $990 r0 *1 86.44,204
X$990 VPWR VIA_via4_5_2000_480_1_5_400_400
* cell instance $991 r0 *1 116.44,78.88
X$991 VPWR VIA_via4_5_2000_480_1_5_400_400
* cell instance $992 r0 *1 116.44,280.16
X$992 VPWR VIA_via4_5_2000_480_1_5_400_400
* cell instance $993 r0 *1 116.44,84.32
X$993 VPWR VIA_via4_5_2000_480_1_5_400_400
* cell instance $994 r0 *1 176.44,40.8
X$994 VPWR VIA_via4_5_2000_480_1_5_400_400
* cell instance $995 r0 *1 86.44,231.2
X$995 VPWR VIA_via4_5_2000_480_1_5_400_400
* cell instance $996 r0 *1 86.44,236.64
X$996 VPWR VIA_via4_5_2000_480_1_5_400_400
* cell instance $997 r0 *1 116.44,116.96
X$997 VPWR VIA_via4_5_2000_480_1_5_400_400
* cell instance $998 r0 *1 56.44,111.52
X$998 VPWR VIA_via4_5_2000_480_1_5_400_400
* cell instance $999 r0 *1 116.44,111.52
X$999 VPWR VIA_via4_5_2000_480_1_5_400_400
* cell instance $1000 r0 *1 176.44,285.6
X$1000 VPWR VIA_via4_5_2000_480_1_5_400_400
* cell instance $1001 r0 *1 176.44,280.16
X$1001 VPWR VIA_via4_5_2000_480_1_5_400_400
* cell instance $1002 r0 *1 86.44,111.52
X$1002 VPWR VIA_via4_5_2000_480_1_5_400_400
* cell instance $1003 r0 *1 86.44,116.96
X$1003 VPWR VIA_via4_5_2000_480_1_5_400_400
* cell instance $1004 r0 *1 116.44,133.28
X$1004 VPWR VIA_via4_5_2000_480_1_5_400_400
* cell instance $1005 r0 *1 146.44,144.16
X$1005 VPWR VIA_via4_5_2000_480_1_5_400_400
* cell instance $1006 r0 *1 26.44,231.2
X$1006 VPWR VIA_via4_5_2000_480_1_5_400_400
* cell instance $1007 r0 *1 26.44,225.76
X$1007 VPWR VIA_via4_5_2000_480_1_5_400_400
* cell instance $1008 r0 *1 26.44,204
X$1008 VPWR VIA_via4_5_2000_480_1_5_400_400
* cell instance $1009 r0 *1 146.44,138.72
X$1009 VPWR VIA_via4_5_2000_480_1_5_400_400
* cell instance $1010 r0 *1 26.44,209.44
X$1010 VPWR VIA_via4_5_2000_480_1_5_400_400
* cell instance $1011 r0 *1 26.44,214.88
X$1011 VPWR VIA_via4_5_2000_480_1_5_400_400
* cell instance $1012 r0 *1 146.44,78.88
X$1012 VPWR VIA_via4_5_2000_480_1_5_400_400
* cell instance $1013 r0 *1 26.44,133.28
X$1013 VPWR VIA_via4_5_2000_480_1_5_400_400
* cell instance $1014 r0 *1 26.44,236.64
X$1014 VPWR VIA_via4_5_2000_480_1_5_400_400
* cell instance $1015 r0 *1 26.44,242.08
X$1015 VPWR VIA_via4_5_2000_480_1_5_400_400
* cell instance $1016 r0 *1 26.44,220.32
X$1016 VPWR VIA_via4_5_2000_480_1_5_400_400
* cell instance $1017 r0 *1 176.44,225.76
X$1017 VPWR VIA_via4_5_2000_480_1_5_400_400
* cell instance $1018 r0 *1 56.44,78.88
X$1018 VPWR VIA_via4_5_2000_480_1_5_400_400
* cell instance $1019 r0 *1 176.44,236.64
X$1019 VPWR VIA_via4_5_2000_480_1_5_400_400
* cell instance $1020 r0 *1 26.44,285.6
X$1020 VPWR VIA_via4_5_2000_480_1_5_400_400
* cell instance $1021 r0 *1 146.44,84.32
X$1021 VPWR VIA_via4_5_2000_480_1_5_400_400
* cell instance $1022 r0 *1 26.44,258.4
X$1022 VPWR VIA_via4_5_2000_480_1_5_400_400
* cell instance $1023 r0 *1 26.44,252.96
X$1023 VPWR VIA_via4_5_2000_480_1_5_400_400
* cell instance $1024 r0 *1 146.44,95.2
X$1024 VPWR VIA_via4_5_2000_480_1_5_400_400
* cell instance $1025 r0 *1 26.44,280.16
X$1025 VPWR VIA_via4_5_2000_480_1_5_400_400
* cell instance $1026 r0 *1 146.44,155.04
X$1026 VPWR VIA_via4_5_2000_480_1_5_400_400
* cell instance $1027 r0 *1 146.44,100.64
X$1027 VPWR VIA_via4_5_2000_480_1_5_400_400
* cell instance $1028 r0 *1 26.44,274.72
X$1028 VPWR VIA_via4_5_2000_480_1_5_400_400
* cell instance $1029 r0 *1 26.44,269.28
X$1029 VPWR VIA_via4_5_2000_480_1_5_400_400
* cell instance $1030 r0 *1 26.44,263.84
X$1030 VPWR VIA_via4_5_2000_480_1_5_400_400
* cell instance $1031 r0 *1 176.44,231.2
X$1031 VPWR VIA_via4_5_2000_480_1_5_400_400
* cell instance $1032 r0 *1 146.44,116.96
X$1032 VPWR VIA_via4_5_2000_480_1_5_400_400
* cell instance $1033 r0 *1 146.44,122.4
X$1033 VPWR VIA_via4_5_2000_480_1_5_400_400
* cell instance $1034 r0 *1 146.44,127.84
X$1034 VPWR VIA_via4_5_2000_480_1_5_400_400
* cell instance $1035 r0 *1 146.44,133.28
X$1035 VPWR VIA_via4_5_2000_480_1_5_400_400
* cell instance $1036 r0 *1 26.44,247.52
X$1036 VPWR VIA_via4_5_2000_480_1_5_400_400
* cell instance $1037 r0 *1 26.44,171.36
X$1037 VPWR VIA_via4_5_2000_480_1_5_400_400
* cell instance $1038 r0 *1 26.44,182.24
X$1038 VPWR VIA_via4_5_2000_480_1_5_400_400
* cell instance $1039 r0 *1 176.44,252.96
X$1039 VPWR VIA_via4_5_2000_480_1_5_400_400
* cell instance $1040 r0 *1 26.44,165.92
X$1040 VPWR VIA_via4_5_2000_480_1_5_400_400
* cell instance $1041 r0 *1 176.44,247.52
X$1041 VPWR VIA_via4_5_2000_480_1_5_400_400
* cell instance $1042 r0 *1 56.44,95.2
X$1042 VPWR VIA_via4_5_2000_480_1_5_400_400
* cell instance $1043 r0 *1 146.44,252.96
X$1043 VPWR VIA_via4_5_2000_480_1_5_400_400
* cell instance $1044 r0 *1 26.44,160.48
X$1044 VPWR VIA_via4_5_2000_480_1_5_400_400
* cell instance $1045 r0 *1 56.44,116.96
X$1045 VPWR VIA_via4_5_2000_480_1_5_400_400
* cell instance $1046 r0 *1 56.44,89.76
X$1046 VPWR VIA_via4_5_2000_480_1_5_400_400
* cell instance $1047 r0 *1 26.44,144.16
X$1047 VPWR VIA_via4_5_2000_480_1_5_400_400
* cell instance $1048 r0 *1 26.44,149.6
X$1048 VPWR VIA_via4_5_2000_480_1_5_400_400
* cell instance $1049 r0 *1 26.44,122.4
X$1049 VPWR VIA_via4_5_2000_480_1_5_400_400
* cell instance $1050 r0 *1 116.44,95.2
X$1050 VPWR VIA_via4_5_2000_480_1_5_400_400
* cell instance $1051 r0 *1 26.44,155.04
X$1051 VPWR VIA_via4_5_2000_480_1_5_400_400
* cell instance $1052 r0 *1 176.44,187.68
X$1052 VPWR VIA_via4_5_2000_480_1_5_400_400
* cell instance $1053 r0 *1 176.44,193.12
X$1053 VPWR VIA_via4_5_2000_480_1_5_400_400
* cell instance $1054 r0 *1 146.44,247.52
X$1054 VPWR VIA_via4_5_2000_480_1_5_400_400
* cell instance $1055 r0 *1 176.44,182.24
X$1055 VPWR VIA_via4_5_2000_480_1_5_400_400
* cell instance $1056 r0 *1 146.44,263.84
X$1056 VPWR VIA_via4_5_2000_480_1_5_400_400
* cell instance $1057 r0 *1 146.44,258.4
X$1057 VPWR VIA_via4_5_2000_480_1_5_400_400
* cell instance $1058 r0 *1 146.44,106.08
X$1058 VPWR VIA_via4_5_2000_480_1_5_400_400
* cell instance $1059 r0 *1 176.44,242.08
X$1059 VPWR VIA_via4_5_2000_480_1_5_400_400
* cell instance $1060 r0 *1 56.44,57.12
X$1060 VPWR VIA_via4_5_2000_480_1_5_400_400
* cell instance $1061 r0 *1 146.44,89.76
X$1061 VPWR VIA_via4_5_2000_480_1_5_400_400
* cell instance $1062 r0 *1 56.44,62.56
X$1062 VPWR VIA_via4_5_2000_480_1_5_400_400
* cell instance $1063 r0 *1 56.44,68
X$1063 VPWR VIA_via4_5_2000_480_1_5_400_400
* cell instance $1064 r0 *1 146.44,285.6
X$1064 VPWR VIA_via4_5_2000_480_1_5_400_400
* cell instance $1065 r0 *1 26.44,193.12
X$1065 VPWR VIA_via4_5_2000_480_1_5_400_400
* cell instance $1066 r0 *1 26.44,198.56
X$1066 VPWR VIA_via4_5_2000_480_1_5_400_400
* cell instance $1067 r0 *1 26.44,187.68
X$1067 VPWR VIA_via4_5_2000_480_1_5_400_400
* cell instance $1068 r0 *1 26.44,176.8
X$1068 VPWR VIA_via4_5_2000_480_1_5_400_400
* cell instance $1069 r0 *1 146.44,111.52
X$1069 VPWR VIA_via4_5_2000_480_1_5_400_400
* cell instance $1070 r0 *1 176.44,209.44
X$1070 VPWR VIA_via4_5_2000_480_1_5_400_400
* cell instance $1071 r0 *1 116.44,144.16
X$1071 VPWR VIA_via4_5_2000_480_1_5_400_400
* cell instance $1072 r0 *1 176.44,160.48
X$1072 VPWR VIA_via4_5_2000_480_1_5_400_400
* cell instance $1073 r0 *1 176.44,46.24
X$1073 VPWR VIA_via4_5_2000_480_1_5_400_400
* cell instance $1074 r0 *1 86.44,40.8
X$1074 VPWR VIA_via4_5_2000_480_1_5_400_400
* cell instance $1075 r0 *1 86.44,89.76
X$1075 VPWR VIA_via4_5_2000_480_1_5_400_400
* cell instance $1076 r0 *1 176.44,220.32
X$1076 VPWR VIA_via4_5_2000_480_1_5_400_400
* cell instance $1077 r0 *1 176.44,51.68
X$1077 VPWR VIA_via4_5_2000_480_1_5_400_400
* cell instance $1078 r0 *1 86.44,78.88
X$1078 VPWR VIA_via4_5_2000_480_1_5_400_400
* cell instance $1079 r0 *1 56.44,209.44
X$1079 VPWR VIA_via4_5_2000_480_1_5_400_400
* cell instance $1080 r0 *1 86.44,95.2
X$1080 VPWR VIA_via4_5_2000_480_1_5_400_400
* cell instance $1081 r0 *1 116.44,274.72
X$1081 VPWR VIA_via4_5_2000_480_1_5_400_400
* cell instance $1082 r0 *1 56.44,214.88
X$1082 VPWR VIA_via4_5_2000_480_1_5_400_400
* cell instance $1083 r0 *1 86.44,100.64
X$1083 VPWR VIA_via4_5_2000_480_1_5_400_400
* cell instance $1084 r0 *1 116.44,155.04
X$1084 VPWR VIA_via4_5_2000_480_1_5_400_400
* cell instance $1085 r0 *1 86.44,133.28
X$1085 VPWR VIA_via4_5_2000_480_1_5_400_400
* cell instance $1086 r0 *1 56.44,204
X$1086 VPWR VIA_via4_5_2000_480_1_5_400_400
* cell instance $1087 r0 *1 86.44,51.68
X$1087 VPWR VIA_via4_5_2000_480_1_5_400_400
* cell instance $1088 r0 *1 86.44,106.08
X$1088 VPWR VIA_via4_5_2000_480_1_5_400_400
* cell instance $1089 r0 *1 86.44,35.36
X$1089 VPWR VIA_via4_5_2000_480_1_5_400_400
* cell instance $1090 r0 *1 116.44,149.6
X$1090 VPWR VIA_via4_5_2000_480_1_5_400_400
* cell instance $1091 r0 *1 86.44,46.24
X$1091 VPWR VIA_via4_5_2000_480_1_5_400_400
* cell instance $1092 r0 *1 86.44,138.72
X$1092 VPWR VIA_via4_5_2000_480_1_5_400_400
* cell instance $1093 r0 *1 86.44,149.6
X$1093 VPWR VIA_via4_5_2000_480_1_5_400_400
* cell instance $1094 r0 *1 56.44,220.32
X$1094 VPWR VIA_via4_5_2000_480_1_5_400_400
* cell instance $1095 r0 *1 176.44,204
X$1095 VPWR VIA_via4_5_2000_480_1_5_400_400
* cell instance $1096 r0 *1 86.44,127.84
X$1096 VPWR VIA_via4_5_2000_480_1_5_400_400
* cell instance $1097 r0 *1 116.44,269.28
X$1097 VPWR VIA_via4_5_2000_480_1_5_400_400
* cell instance $1098 r0 *1 176.44,214.88
X$1098 VPWR VIA_via4_5_2000_480_1_5_400_400
* cell instance $1099 r0 *1 86.44,57.12
X$1099 VPWR VIA_via4_5_2000_480_1_5_400_400
* cell instance $1100 r0 *1 176.44,35.36
X$1100 VPWR VIA_via4_5_2000_480_1_5_400_400
* cell instance $1101 r0 *1 86.44,84.32
X$1101 VPWR VIA_via4_5_2000_480_1_5_400_400
* cell instance $1102 r0 *1 86.44,214.88
X$1102 VPWR VIA_via4_5_2000_480_1_5_400_400
* cell instance $1103 r0 *1 176.44,24.48
X$1103 VPWR VIA_via4_5_2000_480_1_5_400_400
* cell instance $1104 r0 *1 86.44,242.08
X$1104 VPWR VIA_via4_5_2000_480_1_5_400_400
* cell instance $1105 r0 *1 86.44,209.44
X$1105 VPWR VIA_via4_5_2000_480_1_5_400_400
* cell instance $1106 r0 *1 86.44,73.44
X$1106 VPWR VIA_via4_5_2000_480_1_5_400_400
* cell instance $1107 r0 *1 86.44,68
X$1107 VPWR VIA_via4_5_2000_480_1_5_400_400
* cell instance $1108 r0 *1 116.44,285.6
X$1108 VPWR VIA_via4_5_2000_480_1_5_400_400
* cell instance $1109 r0 *1 86.44,62.56
X$1109 VPWR VIA_via4_5_2000_480_1_5_400_400
* cell instance $1110 r0 *1 176.44,29.92
X$1110 VPWR VIA_via4_5_2000_480_1_5_400_400
* cell instance $1111 r0 *1 176.44,269.28
X$1111 VPWR VIA_via4_5_2000_480_1_5_400_400
* cell instance $1112 r0 *1 176.44,40.8
X$1112 VPWR VIA_via3_4_2000_480_1_5_400_400
* cell instance $1113 r0 *1 86.44,73.44
X$1113 VPWR VIA_via3_4_2000_480_1_5_400_400
* cell instance $1114 r0 *1 86.44,62.56
X$1114 VPWR VIA_via3_4_2000_480_1_5_400_400
* cell instance $1115 r0 *1 116.44,280.16
X$1115 VPWR VIA_via3_4_2000_480_1_5_400_400
* cell instance $1116 r0 *1 86.44,57.12
X$1116 VPWR VIA_via3_4_2000_480_1_5_400_400
* cell instance $1117 r0 *1 86.44,68
X$1117 VPWR VIA_via3_4_2000_480_1_5_400_400
* cell instance $1118 r0 *1 176.44,57.12
X$1118 VPWR VIA_via3_4_2000_480_1_5_400_400
* cell instance $1119 r0 *1 56.44,46.24
X$1119 VPWR VIA_via3_4_2000_480_1_5_400_400
* cell instance $1120 r0 *1 56.44,51.68
X$1120 VPWR VIA_via3_4_2000_480_1_5_400_400
* cell instance $1121 r0 *1 56.44,35.36
X$1121 VPWR VIA_via3_4_2000_480_1_5_400_400
* cell instance $1122 r0 *1 56.44,40.8
X$1122 VPWR VIA_via3_4_2000_480_1_5_400_400
* cell instance $1123 r0 *1 86.44,209.44
X$1123 VPWR VIA_via3_4_2000_480_1_5_400_400
* cell instance $1124 r0 *1 86.44,204
X$1124 VPWR VIA_via3_4_2000_480_1_5_400_400
* cell instance $1125 r0 *1 116.44,127.84
X$1125 VPWR VIA_via3_4_2000_480_1_5_400_400
* cell instance $1126 r0 *1 116.44,122.4
X$1126 VPWR VIA_via3_4_2000_480_1_5_400_400
* cell instance $1127 r0 *1 86.44,242.08
X$1127 VPWR VIA_via3_4_2000_480_1_5_400_400
* cell instance $1128 r0 *1 86.44,220.32
X$1128 VPWR VIA_via3_4_2000_480_1_5_400_400
* cell instance $1129 r0 *1 86.44,231.2
X$1129 VPWR VIA_via3_4_2000_480_1_5_400_400
* cell instance $1130 r0 *1 116.44,133.28
X$1130 VPWR VIA_via3_4_2000_480_1_5_400_400
* cell instance $1131 r0 *1 86.44,225.76
X$1131 VPWR VIA_via3_4_2000_480_1_5_400_400
* cell instance $1132 r0 *1 176.44,263.84
X$1132 VPWR VIA_via3_4_2000_480_1_5_400_400
* cell instance $1133 r0 *1 116.44,138.72
X$1133 VPWR VIA_via3_4_2000_480_1_5_400_400
* cell instance $1134 r0 *1 176.44,258.4
X$1134 VPWR VIA_via3_4_2000_480_1_5_400_400
* cell instance $1135 r0 *1 176.44,247.52
X$1135 VPWR VIA_via3_4_2000_480_1_5_400_400
* cell instance $1136 r0 *1 86.44,236.64
X$1136 VPWR VIA_via3_4_2000_480_1_5_400_400
* cell instance $1137 r0 *1 116.44,155.04
X$1137 VPWR VIA_via3_4_2000_480_1_5_400_400
* cell instance $1138 r0 *1 116.44,269.28
X$1138 VPWR VIA_via3_4_2000_480_1_5_400_400
* cell instance $1139 r0 *1 116.44,274.72
X$1139 VPWR VIA_via3_4_2000_480_1_5_400_400
* cell instance $1140 r0 *1 176.44,155.04
X$1140 VPWR VIA_via3_4_2000_480_1_5_400_400
* cell instance $1141 r0 *1 176.44,149.6
X$1141 VPWR VIA_via3_4_2000_480_1_5_400_400
* cell instance $1142 r0 *1 26.44,116.96
X$1142 VPWR VIA_via3_4_2000_480_1_5_400_400
* cell instance $1143 r0 *1 26.44,100.64
X$1143 VPWR VIA_via3_4_2000_480_1_5_400_400
* cell instance $1144 r0 *1 26.44,111.52
X$1144 VPWR VIA_via3_4_2000_480_1_5_400_400
* cell instance $1145 r0 *1 26.44,106.08
X$1145 VPWR VIA_via3_4_2000_480_1_5_400_400
* cell instance $1146 r0 *1 116.44,285.6
X$1146 VPWR VIA_via3_4_2000_480_1_5_400_400
* cell instance $1147 r0 *1 176.44,35.36
X$1147 VPWR VIA_via3_4_2000_480_1_5_400_400
* cell instance $1148 r0 *1 86.44,214.88
X$1148 VPWR VIA_via3_4_2000_480_1_5_400_400
* cell instance $1149 r0 *1 86.44,51.68
X$1149 VPWR VIA_via3_4_2000_480_1_5_400_400
* cell instance $1150 r0 *1 176.44,269.28
X$1150 VPWR VIA_via3_4_2000_480_1_5_400_400
* cell instance $1151 r0 *1 176.44,51.68
X$1151 VPWR VIA_via3_4_2000_480_1_5_400_400
* cell instance $1152 r0 *1 26.44,89.76
X$1152 VPWR VIA_via3_4_2000_480_1_5_400_400
* cell instance $1153 r0 *1 86.44,46.24
X$1153 VPWR VIA_via3_4_2000_480_1_5_400_400
* cell instance $1154 r0 *1 176.44,285.6
X$1154 VPWR VIA_via3_4_2000_480_1_5_400_400
* cell instance $1155 r0 *1 176.44,280.16
X$1155 VPWR VIA_via3_4_2000_480_1_5_400_400
* cell instance $1156 r0 *1 176.44,274.72
X$1156 VPWR VIA_via3_4_2000_480_1_5_400_400
* cell instance $1157 r0 *1 116.44,149.6
X$1157 VPWR VIA_via3_4_2000_480_1_5_400_400
* cell instance $1158 r0 *1 176.44,46.24
X$1158 VPWR VIA_via3_4_2000_480_1_5_400_400
* cell instance $1159 r0 *1 86.44,35.36
X$1159 VPWR VIA_via3_4_2000_480_1_5_400_400
* cell instance $1160 r0 *1 86.44,40.8
X$1160 VPWR VIA_via3_4_2000_480_1_5_400_400
* cell instance $1161 r0 *1 116.44,144.16
X$1161 VPWR VIA_via3_4_2000_480_1_5_400_400
* cell instance $1162 r0 *1 176.44,78.88
X$1162 VPWR VIA_via3_4_2000_480_1_5_400_400
* cell instance $1163 r0 *1 176.44,160.48
X$1163 VPWR VIA_via3_4_2000_480_1_5_400_400
* cell instance $1164 r0 *1 176.44,252.96
X$1164 VPWR VIA_via3_4_2000_480_1_5_400_400
* cell instance $1165 r0 *1 116.44,106.08
X$1165 VPWR VIA_via3_4_2000_480_1_5_400_400
* cell instance $1166 r0 *1 116.44,100.64
X$1166 VPWR VIA_via3_4_2000_480_1_5_400_400
* cell instance $1167 r0 *1 26.44,263.84
X$1167 VPWR VIA_via3_4_2000_480_1_5_400_400
* cell instance $1168 r0 *1 146.44,138.72
X$1168 VPWR VIA_via3_4_2000_480_1_5_400_400
* cell instance $1169 r0 *1 116.44,111.52
X$1169 VPWR VIA_via3_4_2000_480_1_5_400_400
* cell instance $1170 r0 *1 146.44,144.16
X$1170 VPWR VIA_via3_4_2000_480_1_5_400_400
* cell instance $1171 r0 *1 146.44,155.04
X$1171 VPWR VIA_via3_4_2000_480_1_5_400_400
* cell instance $1172 r0 *1 56.44,116.96
X$1172 VPWR VIA_via3_4_2000_480_1_5_400_400
* cell instance $1173 r0 *1 116.44,220.32
X$1173 VPWR VIA_via3_4_2000_480_1_5_400_400
* cell instance $1174 r0 *1 56.44,111.52
X$1174 VPWR VIA_via3_4_2000_480_1_5_400_400
* cell instance $1175 r0 *1 116.44,116.96
X$1175 VPWR VIA_via3_4_2000_480_1_5_400_400
* cell instance $1176 r0 *1 176.44,220.32
X$1176 VPWR VIA_via3_4_2000_480_1_5_400_400
* cell instance $1177 r0 *1 116.44,214.88
X$1177 VPWR VIA_via3_4_2000_480_1_5_400_400
* cell instance $1178 r0 *1 86.44,100.64
X$1178 VPWR VIA_via3_4_2000_480_1_5_400_400
* cell instance $1179 r0 *1 86.44,106.08
X$1179 VPWR VIA_via3_4_2000_480_1_5_400_400
* cell instance $1180 r0 *1 176.44,204
X$1180 VPWR VIA_via3_4_2000_480_1_5_400_400
* cell instance $1181 r0 *1 86.44,84.32
X$1181 VPWR VIA_via3_4_2000_480_1_5_400_400
* cell instance $1182 r0 *1 86.44,89.76
X$1182 VPWR VIA_via3_4_2000_480_1_5_400_400
* cell instance $1183 r0 *1 176.44,209.44
X$1183 VPWR VIA_via3_4_2000_480_1_5_400_400
* cell instance $1184 r0 *1 86.44,95.2
X$1184 VPWR VIA_via3_4_2000_480_1_5_400_400
* cell instance $1185 r0 *1 86.44,78.88
X$1185 VPWR VIA_via3_4_2000_480_1_5_400_400
* cell instance $1186 r0 *1 146.44,269.28
X$1186 VPWR VIA_via3_4_2000_480_1_5_400_400
* cell instance $1187 r0 *1 146.44,116.96
X$1187 VPWR VIA_via3_4_2000_480_1_5_400_400
* cell instance $1188 r0 *1 146.44,280.16
X$1188 VPWR VIA_via3_4_2000_480_1_5_400_400
* cell instance $1189 r0 *1 146.44,274.72
X$1189 VPWR VIA_via3_4_2000_480_1_5_400_400
* cell instance $1190 r0 *1 146.44,285.6
X$1190 VPWR VIA_via3_4_2000_480_1_5_400_400
* cell instance $1191 r0 *1 26.44,209.44
X$1191 VPWR VIA_via3_4_2000_480_1_5_400_400
* cell instance $1192 r0 *1 26.44,214.88
X$1192 VPWR VIA_via3_4_2000_480_1_5_400_400
* cell instance $1193 r0 *1 146.44,133.28
X$1193 VPWR VIA_via3_4_2000_480_1_5_400_400
* cell instance $1194 r0 *1 26.44,236.64
X$1194 VPWR VIA_via3_4_2000_480_1_5_400_400
* cell instance $1195 r0 *1 26.44,225.76
X$1195 VPWR VIA_via3_4_2000_480_1_5_400_400
* cell instance $1196 r0 *1 176.44,95.2
X$1196 VPWR VIA_via3_4_2000_480_1_5_400_400
* cell instance $1197 r0 *1 26.44,247.52
X$1197 VPWR VIA_via3_4_2000_480_1_5_400_400
* cell instance $1198 r0 *1 26.44,252.96
X$1198 VPWR VIA_via3_4_2000_480_1_5_400_400
* cell instance $1199 r0 *1 26.44,258.4
X$1199 VPWR VIA_via3_4_2000_480_1_5_400_400
* cell instance $1200 r0 *1 176.44,62.56
X$1200 VPWR VIA_via3_4_2000_480_1_5_400_400
* cell instance $1201 r0 *1 26.44,269.28
X$1201 VPWR VIA_via3_4_2000_480_1_5_400_400
* cell instance $1202 r0 *1 26.44,274.72
X$1202 VPWR VIA_via3_4_2000_480_1_5_400_400
* cell instance $1203 r0 *1 26.44,280.16
X$1203 VPWR VIA_via3_4_2000_480_1_5_400_400
* cell instance $1204 r0 *1 26.44,285.6
X$1204 VPWR VIA_via3_4_2000_480_1_5_400_400
* cell instance $1205 r0 *1 56.44,73.44
X$1205 VPWR VIA_via3_4_2000_480_1_5_400_400
* cell instance $1206 r0 *1 26.44,231.2
X$1206 VPWR VIA_via3_4_2000_480_1_5_400_400
* cell instance $1207 r0 *1 56.44,78.88
X$1207 VPWR VIA_via3_4_2000_480_1_5_400_400
* cell instance $1208 r0 *1 56.44,100.64
X$1208 VPWR VIA_via3_4_2000_480_1_5_400_400
* cell instance $1209 r0 *1 56.44,95.2
X$1209 VPWR VIA_via3_4_2000_480_1_5_400_400
* cell instance $1210 r0 *1 56.44,84.32
X$1210 VPWR VIA_via3_4_2000_480_1_5_400_400
* cell instance $1211 r0 *1 56.44,106.08
X$1211 VPWR VIA_via3_4_2000_480_1_5_400_400
* cell instance $1212 r0 *1 56.44,89.76
X$1212 VPWR VIA_via3_4_2000_480_1_5_400_400
* cell instance $1213 r0 *1 146.44,106.08
X$1213 VPWR VIA_via3_4_2000_480_1_5_400_400
* cell instance $1214 r0 *1 146.44,100.64
X$1214 VPWR VIA_via3_4_2000_480_1_5_400_400
* cell instance $1215 r0 *1 146.44,95.2
X$1215 VPWR VIA_via3_4_2000_480_1_5_400_400
* cell instance $1216 r0 *1 146.44,89.76
X$1216 VPWR VIA_via3_4_2000_480_1_5_400_400
* cell instance $1217 r0 *1 146.44,84.32
X$1217 VPWR VIA_via3_4_2000_480_1_5_400_400
* cell instance $1218 r0 *1 146.44,111.52
X$1218 VPWR VIA_via3_4_2000_480_1_5_400_400
* cell instance $1219 r0 *1 146.44,252.96
X$1219 VPWR VIA_via3_4_2000_480_1_5_400_400
* cell instance $1220 r0 *1 146.44,78.88
X$1220 VPWR VIA_via3_4_2000_480_1_5_400_400
* cell instance $1221 r0 *1 26.44,242.08
X$1221 VPWR VIA_via3_4_2000_480_1_5_400_400
* cell instance $1222 r0 *1 146.44,149.6
X$1222 VPWR VIA_via3_4_2000_480_1_5_400_400
* cell instance $1223 r0 *1 26.44,220.32
X$1223 VPWR VIA_via3_4_2000_480_1_5_400_400
* cell instance $1224 r0 *1 146.44,122.4
X$1224 VPWR VIA_via3_4_2000_480_1_5_400_400
* cell instance $1225 r0 *1 146.44,127.84
X$1225 VPWR VIA_via3_4_2000_480_1_5_400_400
* cell instance $1226 r0 *1 26.44,204
X$1226 VPWR VIA_via3_4_2000_480_1_5_400_400
* cell instance $1227 r0 *1 146.44,263.84
X$1227 VPWR VIA_via3_4_2000_480_1_5_400_400
* cell instance $1228 r0 *1 146.44,247.52
X$1228 VPWR VIA_via3_4_2000_480_1_5_400_400
* cell instance $1229 r0 *1 56.44,62.56
X$1229 VPWR VIA_via3_4_2000_480_1_5_400_400
* cell instance $1230 r0 *1 146.44,258.4
X$1230 VPWR VIA_via3_4_2000_480_1_5_400_400
* cell instance $1231 r0 *1 56.44,57.12
X$1231 VPWR VIA_via3_4_2000_480_1_5_400_400
* cell instance $1232 r0 *1 56.44,68
X$1232 VPWR VIA_via3_4_2000_480_1_5_400_400
* cell instance $1233 r0 *1 116.44,236.64
X$1233 VPWR VIA_via3_4_2000_480_1_5_400_400
* cell instance $1234 r0 *1 116.44,225.76
X$1234 VPWR VIA_via3_4_2000_480_1_5_400_400
* cell instance $1235 r0 *1 56.44,247.52
X$1235 VPWR VIA_via3_4_2000_480_1_5_400_400
* cell instance $1236 r0 *1 26.44,57.12
X$1236 VPWR VIA_via3_4_2000_480_1_5_400_400
* cell instance $1237 r0 *1 56.44,24.48
X$1237 VPWR VIA_via3_4_2000_480_1_5_400_400
* cell instance $1238 r0 *1 56.44,19.04
X$1238 VPWR VIA_via3_4_2000_480_1_5_400_400
* cell instance $1239 r0 *1 56.44,252.96
X$1239 VPWR VIA_via3_4_2000_480_1_5_400_400
* cell instance $1240 r0 *1 56.44,258.4
X$1240 VPWR VIA_via3_4_2000_480_1_5_400_400
* cell instance $1241 r0 *1 56.44,263.84
X$1241 VPWR VIA_via3_4_2000_480_1_5_400_400
* cell instance $1242 r0 *1 116.44,231.2
X$1242 VPWR VIA_via3_4_2000_480_1_5_400_400
* cell instance $1243 r0 *1 56.44,269.28
X$1243 VPWR VIA_via3_4_2000_480_1_5_400_400
* cell instance $1244 r0 *1 146.44,220.32
X$1244 VPWR VIA_via3_4_2000_480_1_5_400_400
* cell instance $1245 r0 *1 56.44,274.72
X$1245 VPWR VIA_via3_4_2000_480_1_5_400_400
* cell instance $1246 r0 *1 56.44,285.6
X$1246 VPWR VIA_via3_4_2000_480_1_5_400_400
* cell instance $1247 r0 *1 86.44,247.52
X$1247 VPWR VIA_via3_4_2000_480_1_5_400_400
* cell instance $1248 r0 *1 146.44,209.44
X$1248 VPWR VIA_via3_4_2000_480_1_5_400_400
* cell instance $1249 r0 *1 146.44,204
X$1249 VPWR VIA_via3_4_2000_480_1_5_400_400
* cell instance $1250 r0 *1 146.44,214.88
X$1250 VPWR VIA_via3_4_2000_480_1_5_400_400
* cell instance $1251 r0 *1 86.44,29.92
X$1251 VPWR VIA_via3_4_2000_480_1_5_400_400
* cell instance $1252 r0 *1 116.44,242.08
X$1252 VPWR VIA_via3_4_2000_480_1_5_400_400
* cell instance $1253 r0 *1 146.44,225.76
X$1253 VPWR VIA_via3_4_2000_480_1_5_400_400
* cell instance $1254 r0 *1 146.44,242.08
X$1254 VPWR VIA_via3_4_2000_480_1_5_400_400
* cell instance $1255 r0 *1 56.44,13.6
X$1255 VPWR VIA_via3_4_2000_480_1_5_400_400
* cell instance $1256 r0 *1 146.44,231.2
X$1256 VPWR VIA_via3_4_2000_480_1_5_400_400
* cell instance $1257 r0 *1 56.44,29.92
X$1257 VPWR VIA_via3_4_2000_480_1_5_400_400
* cell instance $1258 r0 *1 86.44,19.04
X$1258 VPWR VIA_via3_4_2000_480_1_5_400_400
* cell instance $1259 r0 *1 86.44,285.6
X$1259 VPWR VIA_via3_4_2000_480_1_5_400_400
* cell instance $1260 r0 *1 86.44,280.16
X$1260 VPWR VIA_via3_4_2000_480_1_5_400_400
* cell instance $1261 r0 *1 86.44,274.72
X$1261 VPWR VIA_via3_4_2000_480_1_5_400_400
* cell instance $1262 r0 *1 86.44,269.28
X$1262 VPWR VIA_via3_4_2000_480_1_5_400_400
* cell instance $1263 r0 *1 86.44,263.84
X$1263 VPWR VIA_via3_4_2000_480_1_5_400_400
* cell instance $1264 r0 *1 86.44,258.4
X$1264 VPWR VIA_via3_4_2000_480_1_5_400_400
* cell instance $1265 r0 *1 146.44,236.64
X$1265 VPWR VIA_via3_4_2000_480_1_5_400_400
* cell instance $1266 r0 *1 86.44,252.96
X$1266 VPWR VIA_via3_4_2000_480_1_5_400_400
* cell instance $1267 r0 *1 176.44,106.08
X$1267 VPWR VIA_via3_4_2000_480_1_5_400_400
* cell instance $1268 r0 *1 116.44,204
X$1268 VPWR VIA_via3_4_2000_480_1_5_400_400
* cell instance $1269 r0 *1 176.44,111.52
X$1269 VPWR VIA_via3_4_2000_480_1_5_400_400
* cell instance $1270 r0 *1 176.44,116.96
X$1270 VPWR VIA_via3_4_2000_480_1_5_400_400
* cell instance $1271 r0 *1 176.44,100.64
X$1271 VPWR VIA_via3_4_2000_480_1_5_400_400
* cell instance $1272 r0 *1 176.44,122.4
X$1272 VPWR VIA_via3_4_2000_480_1_5_400_400
* cell instance $1273 r0 *1 176.44,127.84
X$1273 VPWR VIA_via3_4_2000_480_1_5_400_400
* cell instance $1274 r0 *1 176.44,133.28
X$1274 VPWR VIA_via3_4_2000_480_1_5_400_400
* cell instance $1275 r0 *1 116.44,176.8
X$1275 VPWR VIA_via3_4_2000_480_1_5_400_400
* cell instance $1276 r0 *1 56.44,220.32
X$1276 VPWR VIA_via3_4_2000_480_1_5_400_400
* cell instance $1277 r0 *1 56.44,225.76
X$1277 VPWR VIA_via3_4_2000_480_1_5_400_400
* cell instance $1278 r0 *1 56.44,204
X$1278 VPWR VIA_via3_4_2000_480_1_5_400_400
* cell instance $1279 r0 *1 56.44,209.44
X$1279 VPWR VIA_via3_4_2000_480_1_5_400_400
* cell instance $1280 r0 *1 56.44,214.88
X$1280 VPWR VIA_via3_4_2000_480_1_5_400_400
* cell instance $1281 r0 *1 56.44,280.16
X$1281 VPWR VIA_via3_4_2000_480_1_5_400_400
* cell instance $1282 r0 *1 86.44,24.48
X$1282 VPWR VIA_via3_4_2000_480_1_5_400_400
* cell instance $1283 r0 *1 176.44,84.32
X$1283 VPWR VIA_via3_4_2000_480_1_5_400_400
* cell instance $1284 r0 *1 116.44,182.24
X$1284 VPWR VIA_via3_4_2000_480_1_5_400_400
* cell instance $1285 r0 *1 116.44,187.68
X$1285 VPWR VIA_via3_4_2000_480_1_5_400_400
* cell instance $1286 r0 *1 116.44,209.44
X$1286 VPWR VIA_via3_4_2000_480_1_5_400_400
* cell instance $1287 r0 *1 116.44,198.56
X$1287 VPWR VIA_via3_4_2000_480_1_5_400_400
* cell instance $1288 r0 *1 26.44,95.2
X$1288 VPWR VIA_via3_4_2000_480_1_5_400_400
* cell instance $1289 r0 *1 26.44,78.88
X$1289 VPWR VIA_via3_4_2000_480_1_5_400_400
* cell instance $1290 r0 *1 26.44,84.32
X$1290 VPWR VIA_via3_4_2000_480_1_5_400_400
* cell instance $1291 r0 *1 26.44,62.56
X$1291 VPWR VIA_via3_4_2000_480_1_5_400_400
* cell instance $1292 r0 *1 26.44,40.8
X$1292 VPWR VIA_via3_4_2000_480_1_5_400_400
* cell instance $1293 r0 *1 176.44,68
X$1293 VPWR VIA_via3_4_2000_480_1_5_400_400
* cell instance $1294 r0 *1 176.44,73.44
X$1294 VPWR VIA_via3_4_2000_480_1_5_400_400
* cell instance $1295 r0 *1 26.44,68
X$1295 VPWR VIA_via3_4_2000_480_1_5_400_400
* cell instance $1296 r0 *1 26.44,73.44
X$1296 VPWR VIA_via3_4_2000_480_1_5_400_400
* cell instance $1297 r0 *1 26.44,46.24
X$1297 VPWR VIA_via3_4_2000_480_1_5_400_400
* cell instance $1298 r0 *1 26.44,51.68
X$1298 VPWR VIA_via3_4_2000_480_1_5_400_400
* cell instance $1299 r0 *1 176.44,89.76
X$1299 VPWR VIA_via3_4_2000_480_1_5_400_400
* cell instance $1300 r0 *1 56.44,231.2
X$1300 VPWR VIA_via3_4_2000_480_1_5_400_400
* cell instance $1301 r0 *1 116.44,171.36
X$1301 VPWR VIA_via3_4_2000_480_1_5_400_400
* cell instance $1302 r0 *1 116.44,165.92
X$1302 VPWR VIA_via3_4_2000_480_1_5_400_400
* cell instance $1303 r0 *1 56.44,242.08
X$1303 VPWR VIA_via3_4_2000_480_1_5_400_400
* cell instance $1304 r0 *1 56.44,236.64
X$1304 VPWR VIA_via3_4_2000_480_1_5_400_400
* cell instance $1305 r0 *1 26.44,35.36
X$1305 VPWR VIA_via3_4_2000_480_1_5_400_400
* cell instance $1306 r0 *1 26.44,19.04
X$1306 VPWR VIA_via3_4_2000_480_1_5_400_400
* cell instance $1307 r0 *1 26.44,13.6
X$1307 VPWR VIA_via3_4_2000_480_1_5_400_400
* cell instance $1308 r0 *1 26.44,24.48
X$1308 VPWR VIA_via3_4_2000_480_1_5_400_400
* cell instance $1309 r0 *1 146.44,160.48
X$1309 VPWR VIA_via3_4_2000_480_1_5_400_400
* cell instance $1310 r0 *1 116.44,160.48
X$1310 VPWR VIA_via3_4_2000_480_1_5_400_400
* cell instance $1311 r0 *1 26.44,29.92
X$1311 VPWR VIA_via3_4_2000_480_1_5_400_400
* cell instance $1312 r0 *1 116.44,193.12
X$1312 VPWR VIA_via3_4_2000_480_1_5_400_400
* cell instance $1313 r0 *1 176.44,144.16
X$1313 VPWR VIA_via3_4_2000_480_1_5_400_400
* cell instance $1314 r0 *1 86.44,13.6
X$1314 VPWR VIA_via3_4_2000_480_1_5_400_400
* cell instance $1315 r0 *1 116.44,258.4
X$1315 VPWR VIA_via3_4_2000_480_1_5_400_400
* cell instance $1316 r0 *1 116.44,263.84
X$1316 VPWR VIA_via3_4_2000_480_1_5_400_400
* cell instance $1317 r0 *1 146.44,182.24
X$1317 VPWR VIA_via3_4_2000_480_1_5_400_400
* cell instance $1318 r0 *1 116.44,247.52
X$1318 VPWR VIA_via3_4_2000_480_1_5_400_400
* cell instance $1319 r0 *1 146.44,165.92
X$1319 VPWR VIA_via3_4_2000_480_1_5_400_400
* cell instance $1320 r0 *1 116.44,252.96
X$1320 VPWR VIA_via3_4_2000_480_1_5_400_400
* cell instance $1321 r0 *1 146.44,193.12
X$1321 VPWR VIA_via3_4_2000_480_1_5_400_400
* cell instance $1322 r0 *1 146.44,176.8
X$1322 VPWR VIA_via3_4_2000_480_1_5_400_400
* cell instance $1323 r0 *1 176.44,138.72
X$1323 VPWR VIA_via3_4_2000_480_1_5_400_400
* cell instance $1324 r0 *1 146.44,198.56
X$1324 VPWR VIA_via3_4_2000_480_1_5_400_400
* cell instance $1325 r0 *1 146.44,187.68
X$1325 VPWR VIA_via3_4_2000_480_1_5_400_400
* cell instance $1326 r0 *1 146.44,171.36
X$1326 VPWR VIA_via3_4_2000_480_1_5_400_400
* cell instance $1327 r0 *1 26.44,138.72
X$1327 VPWR VIA_via3_4_2000_480_1_5_400_400
* cell instance $1328 r0 *1 116.44,24.48
X$1328 VPWR VIA_via3_4_2000_480_1_5_400_400
* cell instance $1329 r0 *1 116.44,57.12
X$1329 VPWR VIA_via3_4_2000_480_1_5_400_400
* cell instance $1330 r0 *1 116.44,19.04
X$1330 VPWR VIA_via3_4_2000_480_1_5_400_400
* cell instance $1331 r0 *1 26.44,187.68
X$1331 VPWR VIA_via3_4_2000_480_1_5_400_400
* cell instance $1332 r0 *1 146.44,29.92
X$1332 VPWR VIA_via3_4_2000_480_1_5_400_400
* cell instance $1333 r0 *1 176.44,198.56
X$1333 VPWR VIA_via3_4_2000_480_1_5_400_400
* cell instance $1334 r0 *1 146.44,24.48
X$1334 VPWR VIA_via3_4_2000_480_1_5_400_400
* cell instance $1335 r0 *1 146.44,19.04
X$1335 VPWR VIA_via3_4_2000_480_1_5_400_400
* cell instance $1336 r0 *1 146.44,13.6
X$1336 VPWR VIA_via3_4_2000_480_1_5_400_400
* cell instance $1337 r0 *1 116.44,13.6
X$1337 VPWR VIA_via3_4_2000_480_1_5_400_400
* cell instance $1338 r0 *1 176.44,236.64
X$1338 VPWR VIA_via3_4_2000_480_1_5_400_400
* cell instance $1339 r0 *1 176.44,182.24
X$1339 VPWR VIA_via3_4_2000_480_1_5_400_400
* cell instance $1340 r0 *1 116.44,62.56
X$1340 VPWR VIA_via3_4_2000_480_1_5_400_400
* cell instance $1341 r0 *1 176.44,187.68
X$1341 VPWR VIA_via3_4_2000_480_1_5_400_400
* cell instance $1342 r0 *1 56.44,144.16
X$1342 VPWR VIA_via3_4_2000_480_1_5_400_400
* cell instance $1343 r0 *1 56.44,149.6
X$1343 VPWR VIA_via3_4_2000_480_1_5_400_400
* cell instance $1344 r0 *1 116.44,95.2
X$1344 VPWR VIA_via3_4_2000_480_1_5_400_400
* cell instance $1345 r0 *1 116.44,89.76
X$1345 VPWR VIA_via3_4_2000_480_1_5_400_400
* cell instance $1346 r0 *1 56.44,155.04
X$1346 VPWR VIA_via3_4_2000_480_1_5_400_400
* cell instance $1347 r0 *1 26.44,127.84
X$1347 VPWR VIA_via3_4_2000_480_1_5_400_400
* cell instance $1348 r0 *1 146.44,46.24
X$1348 VPWR VIA_via3_4_2000_480_1_5_400_400
* cell instance $1349 r0 *1 26.44,155.04
X$1349 VPWR VIA_via3_4_2000_480_1_5_400_400
* cell instance $1350 r0 *1 176.44,242.08
X$1350 VPWR VIA_via3_4_2000_480_1_5_400_400
* cell instance $1351 r0 *1 26.44,165.92
X$1351 VPWR VIA_via3_4_2000_480_1_5_400_400
* cell instance $1352 r0 *1 26.44,182.24
X$1352 VPWR VIA_via3_4_2000_480_1_5_400_400
* cell instance $1353 r0 *1 26.44,176.8
X$1353 VPWR VIA_via3_4_2000_480_1_5_400_400
* cell instance $1354 r0 *1 26.44,171.36
X$1354 VPWR VIA_via3_4_2000_480_1_5_400_400
* cell instance $1355 r0 *1 116.44,29.92
X$1355 VPWR VIA_via3_4_2000_480_1_5_400_400
* cell instance $1356 r0 *1 26.44,133.28
X$1356 VPWR VIA_via3_4_2000_480_1_5_400_400
* cell instance $1357 r0 *1 146.44,35.36
X$1357 VPWR VIA_via3_4_2000_480_1_5_400_400
* cell instance $1358 r0 *1 176.44,225.76
X$1358 VPWR VIA_via3_4_2000_480_1_5_400_400
* cell instance $1359 r0 *1 26.44,122.4
X$1359 VPWR VIA_via3_4_2000_480_1_5_400_400
* cell instance $1360 r0 *1 146.44,51.68
X$1360 VPWR VIA_via3_4_2000_480_1_5_400_400
* cell instance $1361 r0 *1 26.44,144.16
X$1361 VPWR VIA_via3_4_2000_480_1_5_400_400
* cell instance $1362 r0 *1 26.44,149.6
X$1362 VPWR VIA_via3_4_2000_480_1_5_400_400
* cell instance $1363 r0 *1 146.44,73.44
X$1363 VPWR VIA_via3_4_2000_480_1_5_400_400
* cell instance $1364 r0 *1 26.44,160.48
X$1364 VPWR VIA_via3_4_2000_480_1_5_400_400
* cell instance $1365 r0 *1 146.44,68
X$1365 VPWR VIA_via3_4_2000_480_1_5_400_400
* cell instance $1366 r0 *1 146.44,62.56
X$1366 VPWR VIA_via3_4_2000_480_1_5_400_400
* cell instance $1367 r0 *1 146.44,57.12
X$1367 VPWR VIA_via3_4_2000_480_1_5_400_400
* cell instance $1368 r0 *1 176.44,231.2
X$1368 VPWR VIA_via3_4_2000_480_1_5_400_400
* cell instance $1369 r0 *1 86.44,149.6
X$1369 VPWR VIA_via3_4_2000_480_1_5_400_400
* cell instance $1370 r0 *1 176.44,165.92
X$1370 VPWR VIA_via3_4_2000_480_1_5_400_400
* cell instance $1371 r0 *1 56.44,133.28
X$1371 VPWR VIA_via3_4_2000_480_1_5_400_400
* cell instance $1372 r0 *1 176.44,24.48
X$1372 VPWR VIA_via3_4_2000_480_1_5_400_400
* cell instance $1373 r0 *1 176.44,171.36
X$1373 VPWR VIA_via3_4_2000_480_1_5_400_400
* cell instance $1374 r0 *1 176.44,176.8
X$1374 VPWR VIA_via3_4_2000_480_1_5_400_400
* cell instance $1375 r0 *1 176.44,29.92
X$1375 VPWR VIA_via3_4_2000_480_1_5_400_400
* cell instance $1376 r0 *1 86.44,144.16
X$1376 VPWR VIA_via3_4_2000_480_1_5_400_400
* cell instance $1377 r0 *1 86.44,155.04
X$1377 VPWR VIA_via3_4_2000_480_1_5_400_400
* cell instance $1378 r0 *1 86.44,165.92
X$1378 VPWR VIA_via3_4_2000_480_1_5_400_400
* cell instance $1379 r0 *1 56.44,122.4
X$1379 VPWR VIA_via3_4_2000_480_1_5_400_400
* cell instance $1380 r0 *1 56.44,127.84
X$1380 VPWR VIA_via3_4_2000_480_1_5_400_400
* cell instance $1381 r0 *1 56.44,138.72
X$1381 VPWR VIA_via3_4_2000_480_1_5_400_400
* cell instance $1382 r0 *1 86.44,133.28
X$1382 VPWR VIA_via3_4_2000_480_1_5_400_400
* cell instance $1383 r0 *1 86.44,138.72
X$1383 VPWR VIA_via3_4_2000_480_1_5_400_400
* cell instance $1384 r0 *1 116.44,78.88
X$1384 VPWR VIA_via3_4_2000_480_1_5_400_400
* cell instance $1385 r0 *1 56.44,160.48
X$1385 VPWR VIA_via3_4_2000_480_1_5_400_400
* cell instance $1386 r0 *1 86.44,127.84
X$1386 VPWR VIA_via3_4_2000_480_1_5_400_400
* cell instance $1387 r0 *1 116.44,84.32
X$1387 VPWR VIA_via3_4_2000_480_1_5_400_400
* cell instance $1388 r0 *1 86.44,160.48
X$1388 VPWR VIA_via3_4_2000_480_1_5_400_400
* cell instance $1389 r0 *1 116.44,73.44
X$1389 VPWR VIA_via3_4_2000_480_1_5_400_400
* cell instance $1390 r0 *1 116.44,68
X$1390 VPWR VIA_via3_4_2000_480_1_5_400_400
* cell instance $1391 r0 *1 86.44,122.4
X$1391 VPWR VIA_via3_4_2000_480_1_5_400_400
* cell instance $1392 r0 *1 56.44,182.24
X$1392 VPWR VIA_via3_4_2000_480_1_5_400_400
* cell instance $1393 r0 *1 116.44,35.36
X$1393 VPWR VIA_via3_4_2000_480_1_5_400_400
* cell instance $1394 r0 *1 56.44,171.36
X$1394 VPWR VIA_via3_4_2000_480_1_5_400_400
* cell instance $1395 r0 *1 116.44,46.24
X$1395 VPWR VIA_via3_4_2000_480_1_5_400_400
* cell instance $1396 r0 *1 176.44,214.88
X$1396 VPWR VIA_via3_4_2000_480_1_5_400_400
* cell instance $1397 r0 *1 56.44,165.92
X$1397 VPWR VIA_via3_4_2000_480_1_5_400_400
* cell instance $1398 r0 *1 176.44,193.12
X$1398 VPWR VIA_via3_4_2000_480_1_5_400_400
* cell instance $1399 r0 *1 86.44,111.52
X$1399 VPWR VIA_via3_4_2000_480_1_5_400_400
* cell instance $1400 r0 *1 116.44,40.8
X$1400 VPWR VIA_via3_4_2000_480_1_5_400_400
* cell instance $1401 r0 *1 86.44,182.24
X$1401 VPWR VIA_via3_4_2000_480_1_5_400_400
* cell instance $1402 r0 *1 86.44,176.8
X$1402 VPWR VIA_via3_4_2000_480_1_5_400_400
* cell instance $1403 r0 *1 176.44,19.04
X$1403 VPWR VIA_via3_4_2000_480_1_5_400_400
* cell instance $1404 r0 *1 56.44,198.56
X$1404 VPWR VIA_via3_4_2000_480_1_5_400_400
* cell instance $1405 r0 *1 56.44,193.12
X$1405 VPWR VIA_via3_4_2000_480_1_5_400_400
* cell instance $1406 r0 *1 86.44,116.96
X$1406 VPWR VIA_via3_4_2000_480_1_5_400_400
* cell instance $1407 r0 *1 86.44,171.36
X$1407 VPWR VIA_via3_4_2000_480_1_5_400_400
* cell instance $1408 r0 *1 176.44,13.6
X$1408 VPWR VIA_via3_4_2000_480_1_5_400_400
* cell instance $1409 r0 *1 116.44,51.68
X$1409 VPWR VIA_via3_4_2000_480_1_5_400_400
* cell instance $1410 r0 *1 86.44,193.12
X$1410 VPWR VIA_via3_4_2000_480_1_5_400_400
* cell instance $1411 r0 *1 56.44,187.68
X$1411 VPWR VIA_via3_4_2000_480_1_5_400_400
* cell instance $1412 r0 *1 86.44,198.56
X$1412 VPWR VIA_via3_4_2000_480_1_5_400_400
* cell instance $1413 r0 *1 86.44,187.68
X$1413 VPWR VIA_via3_4_2000_480_1_5_400_400
* cell instance $1414 r0 *1 26.44,193.12
X$1414 VPWR VIA_via3_4_2000_480_1_5_400_400
* cell instance $1415 r0 *1 146.44,40.8
X$1415 VPWR VIA_via3_4_2000_480_1_5_400_400
* cell instance $1416 r0 *1 56.44,176.8
X$1416 VPWR VIA_via3_4_2000_480_1_5_400_400
* cell instance $1417 r0 *1 26.44,198.56
X$1417 VPWR VIA_via3_4_2000_480_1_5_400_400
* cell instance $1418 r0 *1 56.44,187.68
X$1418 VPWR VIA_via2_3_2000_480_1_6_320_320
* cell instance $1419 r0 *1 56.44,193.12
X$1419 VPWR VIA_via2_3_2000_480_1_6_320_320
* cell instance $1420 r0 *1 56.44,171.36
X$1420 VPWR VIA_via2_3_2000_480_1_6_320_320
* cell instance $1421 r0 *1 86.44,252.96
X$1421 VPWR VIA_via2_3_2000_480_1_6_320_320
* cell instance $1422 r0 *1 26.44,247.52
X$1422 VPWR VIA_via2_3_2000_480_1_6_320_320
* cell instance $1423 r0 *1 56.44,176.8
X$1423 VPWR VIA_via2_3_2000_480_1_6_320_320
* cell instance $1424 r0 *1 146.44,220.32
X$1424 VPWR VIA_via2_3_2000_480_1_6_320_320
* cell instance $1425 r0 *1 146.44,204
X$1425 VPWR VIA_via2_3_2000_480_1_6_320_320
* cell instance $1426 r0 *1 56.44,78.88
X$1426 VPWR VIA_via2_3_2000_480_1_6_320_320
* cell instance $1427 r0 *1 116.44,209.44
X$1427 VPWR VIA_via2_3_2000_480_1_6_320_320
* cell instance $1428 r0 *1 56.44,84.32
X$1428 VPWR VIA_via2_3_2000_480_1_6_320_320
* cell instance $1429 r0 *1 86.44,247.52
X$1429 VPWR VIA_via2_3_2000_480_1_6_320_320
* cell instance $1430 r0 *1 26.44,182.24
X$1430 VPWR VIA_via2_3_2000_480_1_6_320_320
* cell instance $1431 r0 *1 26.44,176.8
X$1431 VPWR VIA_via2_3_2000_480_1_6_320_320
* cell instance $1432 r0 *1 26.44,171.36
X$1432 VPWR VIA_via2_3_2000_480_1_6_320_320
* cell instance $1433 r0 *1 56.44,106.08
X$1433 VPWR VIA_via2_3_2000_480_1_6_320_320
* cell instance $1434 r0 *1 26.44,165.92
X$1434 VPWR VIA_via2_3_2000_480_1_6_320_320
* cell instance $1435 r0 *1 56.44,116.96
X$1435 VPWR VIA_via2_3_2000_480_1_6_320_320
* cell instance $1436 r0 *1 56.44,95.2
X$1436 VPWR VIA_via2_3_2000_480_1_6_320_320
* cell instance $1437 r0 *1 86.44,106.08
X$1437 VPWR VIA_via2_3_2000_480_1_6_320_320
* cell instance $1438 r0 *1 86.44,100.64
X$1438 VPWR VIA_via2_3_2000_480_1_6_320_320
* cell instance $1439 r0 *1 146.44,214.88
X$1439 VPWR VIA_via2_3_2000_480_1_6_320_320
* cell instance $1440 r0 *1 116.44,204
X$1440 VPWR VIA_via2_3_2000_480_1_6_320_320
* cell instance $1441 r0 *1 116.44,220.32
X$1441 VPWR VIA_via2_3_2000_480_1_6_320_320
* cell instance $1442 r0 *1 56.44,258.4
X$1442 VPWR VIA_via2_3_2000_480_1_6_320_320
* cell instance $1443 r0 *1 86.44,198.56
X$1443 VPWR VIA_via2_3_2000_480_1_6_320_320
* cell instance $1444 r0 *1 56.44,19.04
X$1444 VPWR VIA_via2_3_2000_480_1_6_320_320
* cell instance $1445 r0 *1 116.44,214.88
X$1445 VPWR VIA_via2_3_2000_480_1_6_320_320
* cell instance $1446 r0 *1 26.44,258.4
X$1446 VPWR VIA_via2_3_2000_480_1_6_320_320
* cell instance $1447 r0 *1 26.44,285.6
X$1447 VPWR VIA_via2_3_2000_480_1_6_320_320
* cell instance $1448 r0 *1 26.44,263.84
X$1448 VPWR VIA_via2_3_2000_480_1_6_320_320
* cell instance $1449 r0 *1 176.44,127.84
X$1449 VPWR VIA_via2_3_2000_480_1_6_320_320
* cell instance $1450 r0 *1 56.44,274.72
X$1450 VPWR VIA_via2_3_2000_480_1_6_320_320
* cell instance $1451 r0 *1 56.44,285.6
X$1451 VPWR VIA_via2_3_2000_480_1_6_320_320
* cell instance $1452 r0 *1 26.44,269.28
X$1452 VPWR VIA_via2_3_2000_480_1_6_320_320
* cell instance $1453 r0 *1 26.44,274.72
X$1453 VPWR VIA_via2_3_2000_480_1_6_320_320
* cell instance $1454 r0 *1 26.44,198.56
X$1454 VPWR VIA_via2_3_2000_480_1_6_320_320
* cell instance $1455 r0 *1 26.44,280.16
X$1455 VPWR VIA_via2_3_2000_480_1_6_320_320
* cell instance $1456 r0 *1 56.44,29.92
X$1456 VPWR VIA_via2_3_2000_480_1_6_320_320
* cell instance $1457 r0 *1 56.44,13.6
X$1457 VPWR VIA_via2_3_2000_480_1_6_320_320
* cell instance $1458 r0 *1 176.44,138.72
X$1458 VPWR VIA_via2_3_2000_480_1_6_320_320
* cell instance $1459 r0 *1 56.44,89.76
X$1459 VPWR VIA_via2_3_2000_480_1_6_320_320
* cell instance $1460 r0 *1 86.44,193.12
X$1460 VPWR VIA_via2_3_2000_480_1_6_320_320
* cell instance $1461 r0 *1 26.44,187.68
X$1461 VPWR VIA_via2_3_2000_480_1_6_320_320
* cell instance $1462 r0 *1 176.44,89.76
X$1462 VPWR VIA_via2_3_2000_480_1_6_320_320
* cell instance $1463 r0 *1 26.44,193.12
X$1463 VPWR VIA_via2_3_2000_480_1_6_320_320
* cell instance $1464 r0 *1 176.44,133.28
X$1464 VPWR VIA_via2_3_2000_480_1_6_320_320
* cell instance $1465 r0 *1 176.44,122.4
X$1465 VPWR VIA_via2_3_2000_480_1_6_320_320
* cell instance $1466 r0 *1 176.44,198.56
X$1466 VPWR VIA_via2_3_2000_480_1_6_320_320
* cell instance $1467 r0 *1 86.44,274.72
X$1467 VPWR VIA_via2_3_2000_480_1_6_320_320
* cell instance $1468 r0 *1 86.44,280.16
X$1468 VPWR VIA_via2_3_2000_480_1_6_320_320
* cell instance $1469 r0 *1 86.44,285.6
X$1469 VPWR VIA_via2_3_2000_480_1_6_320_320
* cell instance $1470 r0 *1 56.44,182.24
X$1470 VPWR VIA_via2_3_2000_480_1_6_320_320
* cell instance $1471 r0 *1 176.44,78.88
X$1471 VPWR VIA_via2_3_2000_480_1_6_320_320
* cell instance $1472 r0 *1 56.44,165.92
X$1472 VPWR VIA_via2_3_2000_480_1_6_320_320
* cell instance $1473 r0 *1 56.44,198.56
X$1473 VPWR VIA_via2_3_2000_480_1_6_320_320
* cell instance $1474 r0 *1 86.44,176.8
X$1474 VPWR VIA_via2_3_2000_480_1_6_320_320
* cell instance $1475 r0 *1 176.44,160.48
X$1475 VPWR VIA_via2_3_2000_480_1_6_320_320
* cell instance $1476 r0 *1 176.44,106.08
X$1476 VPWR VIA_via2_3_2000_480_1_6_320_320
* cell instance $1477 r0 *1 56.44,100.64
X$1477 VPWR VIA_via2_3_2000_480_1_6_320_320
* cell instance $1478 r0 *1 146.44,122.4
X$1478 VPWR VIA_via2_3_2000_480_1_6_320_320
* cell instance $1479 r0 *1 26.44,122.4
X$1479 VPWR VIA_via2_3_2000_480_1_6_320_320
* cell instance $1480 r0 *1 26.44,133.28
X$1480 VPWR VIA_via2_3_2000_480_1_6_320_320
* cell instance $1481 r0 *1 26.44,144.16
X$1481 VPWR VIA_via2_3_2000_480_1_6_320_320
* cell instance $1482 r0 *1 86.44,111.52
X$1482 VPWR VIA_via2_3_2000_480_1_6_320_320
* cell instance $1483 r0 *1 26.44,127.84
X$1483 VPWR VIA_via2_3_2000_480_1_6_320_320
* cell instance $1484 r0 *1 86.44,258.4
X$1484 VPWR VIA_via2_3_2000_480_1_6_320_320
* cell instance $1485 r0 *1 86.44,269.28
X$1485 VPWR VIA_via2_3_2000_480_1_6_320_320
* cell instance $1486 r0 *1 86.44,263.84
X$1486 VPWR VIA_via2_3_2000_480_1_6_320_320
* cell instance $1487 r0 *1 86.44,78.88
X$1487 VPWR VIA_via2_3_2000_480_1_6_320_320
* cell instance $1488 r0 *1 26.44,138.72
X$1488 VPWR VIA_via2_3_2000_480_1_6_320_320
* cell instance $1489 r0 *1 26.44,155.04
X$1489 VPWR VIA_via2_3_2000_480_1_6_320_320
* cell instance $1490 r0 *1 86.44,182.24
X$1490 VPWR VIA_via2_3_2000_480_1_6_320_320
* cell instance $1491 r0 *1 26.44,160.48
X$1491 VPWR VIA_via2_3_2000_480_1_6_320_320
* cell instance $1492 r0 *1 86.44,187.68
X$1492 VPWR VIA_via2_3_2000_480_1_6_320_320
* cell instance $1493 r0 *1 176.44,116.96
X$1493 VPWR VIA_via2_3_2000_480_1_6_320_320
* cell instance $1494 r0 *1 146.44,127.84
X$1494 VPWR VIA_via2_3_2000_480_1_6_320_320
* cell instance $1495 r0 *1 86.44,95.2
X$1495 VPWR VIA_via2_3_2000_480_1_6_320_320
* cell instance $1496 r0 *1 86.44,171.36
X$1496 VPWR VIA_via2_3_2000_480_1_6_320_320
* cell instance $1497 r0 *1 146.44,138.72
X$1497 VPWR VIA_via2_3_2000_480_1_6_320_320
* cell instance $1498 r0 *1 86.44,116.96
X$1498 VPWR VIA_via2_3_2000_480_1_6_320_320
* cell instance $1499 r0 *1 146.44,133.28
X$1499 VPWR VIA_via2_3_2000_480_1_6_320_320
* cell instance $1500 r0 *1 86.44,89.76
X$1500 VPWR VIA_via2_3_2000_480_1_6_320_320
* cell instance $1501 r0 *1 146.44,149.6
X$1501 VPWR VIA_via2_3_2000_480_1_6_320_320
* cell instance $1502 r0 *1 86.44,84.32
X$1502 VPWR VIA_via2_3_2000_480_1_6_320_320
* cell instance $1503 r0 *1 146.44,155.04
X$1503 VPWR VIA_via2_3_2000_480_1_6_320_320
* cell instance $1504 r0 *1 176.44,100.64
X$1504 VPWR VIA_via2_3_2000_480_1_6_320_320
* cell instance $1505 r0 *1 26.44,149.6
X$1505 VPWR VIA_via2_3_2000_480_1_6_320_320
* cell instance $1506 r0 *1 56.44,111.52
X$1506 VPWR VIA_via2_3_2000_480_1_6_320_320
* cell instance $1507 r0 *1 86.44,68
X$1507 VPWR VIA_via2_3_2000_480_1_6_320_320
* cell instance $1508 r0 *1 86.44,73.44
X$1508 VPWR VIA_via2_3_2000_480_1_6_320_320
* cell instance $1509 r0 *1 86.44,62.56
X$1509 VPWR VIA_via2_3_2000_480_1_6_320_320
* cell instance $1510 r0 *1 86.44,24.48
X$1510 VPWR VIA_via2_3_2000_480_1_6_320_320
* cell instance $1511 r0 *1 86.44,225.76
X$1511 VPWR VIA_via2_3_2000_480_1_6_320_320
* cell instance $1512 r0 *1 116.44,171.36
X$1512 VPWR VIA_via2_3_2000_480_1_6_320_320
* cell instance $1513 r0 *1 86.44,122.4
X$1513 VPWR VIA_via2_3_2000_480_1_6_320_320
* cell instance $1514 r0 *1 86.44,138.72
X$1514 VPWR VIA_via2_3_2000_480_1_6_320_320
* cell instance $1515 r0 *1 86.44,133.28
X$1515 VPWR VIA_via2_3_2000_480_1_6_320_320
* cell instance $1516 r0 *1 86.44,51.68
X$1516 VPWR VIA_via2_3_2000_480_1_6_320_320
* cell instance $1517 r0 *1 86.44,46.24
X$1517 VPWR VIA_via2_3_2000_480_1_6_320_320
* cell instance $1518 r0 *1 56.44,236.64
X$1518 VPWR VIA_via2_3_2000_480_1_6_320_320
* cell instance $1519 r0 *1 116.44,165.92
X$1519 VPWR VIA_via2_3_2000_480_1_6_320_320
* cell instance $1520 r0 *1 86.44,236.64
X$1520 VPWR VIA_via2_3_2000_480_1_6_320_320
* cell instance $1521 r0 *1 116.44,198.56
X$1521 VPWR VIA_via2_3_2000_480_1_6_320_320
* cell instance $1522 r0 *1 116.44,193.12
X$1522 VPWR VIA_via2_3_2000_480_1_6_320_320
* cell instance $1523 r0 *1 116.44,187.68
X$1523 VPWR VIA_via2_3_2000_480_1_6_320_320
* cell instance $1524 r0 *1 116.44,182.24
X$1524 VPWR VIA_via2_3_2000_480_1_6_320_320
* cell instance $1525 r0 *1 86.44,231.2
X$1525 VPWR VIA_via2_3_2000_480_1_6_320_320
* cell instance $1526 r0 *1 56.44,160.48
X$1526 VPWR VIA_via2_3_2000_480_1_6_320_320
* cell instance $1527 r0 *1 86.44,57.12
X$1527 VPWR VIA_via2_3_2000_480_1_6_320_320
* cell instance $1528 r0 *1 86.44,127.84
X$1528 VPWR VIA_via2_3_2000_480_1_6_320_320
* cell instance $1529 r0 *1 86.44,160.48
X$1529 VPWR VIA_via2_3_2000_480_1_6_320_320
* cell instance $1530 r0 *1 86.44,144.16
X$1530 VPWR VIA_via2_3_2000_480_1_6_320_320
* cell instance $1531 r0 *1 26.44,116.96
X$1531 VPWR VIA_via2_3_2000_480_1_6_320_320
* cell instance $1532 r0 *1 86.44,149.6
X$1532 VPWR VIA_via2_3_2000_480_1_6_320_320
* cell instance $1533 r0 *1 176.44,171.36
X$1533 VPWR VIA_via2_3_2000_480_1_6_320_320
* cell instance $1534 r0 *1 86.44,220.32
X$1534 VPWR VIA_via2_3_2000_480_1_6_320_320
* cell instance $1535 r0 *1 26.44,89.76
X$1535 VPWR VIA_via2_3_2000_480_1_6_320_320
* cell instance $1536 r0 *1 26.44,78.88
X$1536 VPWR VIA_via2_3_2000_480_1_6_320_320
* cell instance $1537 r0 *1 26.44,46.24
X$1537 VPWR VIA_via2_3_2000_480_1_6_320_320
* cell instance $1538 r0 *1 26.44,51.68
X$1538 VPWR VIA_via2_3_2000_480_1_6_320_320
* cell instance $1539 r0 *1 26.44,73.44
X$1539 VPWR VIA_via2_3_2000_480_1_6_320_320
* cell instance $1540 r0 *1 26.44,62.56
X$1540 VPWR VIA_via2_3_2000_480_1_6_320_320
* cell instance $1541 r0 *1 26.44,35.36
X$1541 VPWR VIA_via2_3_2000_480_1_6_320_320
* cell instance $1542 r0 *1 26.44,57.12
X$1542 VPWR VIA_via2_3_2000_480_1_6_320_320
* cell instance $1543 r0 *1 26.44,68
X$1543 VPWR VIA_via2_3_2000_480_1_6_320_320
* cell instance $1544 r0 *1 26.44,40.8
X$1544 VPWR VIA_via2_3_2000_480_1_6_320_320
* cell instance $1545 r0 *1 56.44,231.2
X$1545 VPWR VIA_via2_3_2000_480_1_6_320_320
* cell instance $1546 r0 *1 116.44,176.8
X$1546 VPWR VIA_via2_3_2000_480_1_6_320_320
* cell instance $1547 r0 *1 176.44,165.92
X$1547 VPWR VIA_via2_3_2000_480_1_6_320_320
* cell instance $1548 r0 *1 86.44,155.04
X$1548 VPWR VIA_via2_3_2000_480_1_6_320_320
* cell instance $1549 r0 *1 56.44,204
X$1549 VPWR VIA_via2_3_2000_480_1_6_320_320
* cell instance $1550 r0 *1 116.44,149.6
X$1550 VPWR VIA_via2_3_2000_480_1_6_320_320
* cell instance $1551 r0 *1 56.44,220.32
X$1551 VPWR VIA_via2_3_2000_480_1_6_320_320
* cell instance $1552 r0 *1 56.44,225.76
X$1552 VPWR VIA_via2_3_2000_480_1_6_320_320
* cell instance $1553 r0 *1 116.44,155.04
X$1553 VPWR VIA_via2_3_2000_480_1_6_320_320
* cell instance $1554 r0 *1 86.44,35.36
X$1554 VPWR VIA_via2_3_2000_480_1_6_320_320
* cell instance $1555 r0 *1 56.44,209.44
X$1555 VPWR VIA_via2_3_2000_480_1_6_320_320
* cell instance $1556 r0 *1 56.44,214.88
X$1556 VPWR VIA_via2_3_2000_480_1_6_320_320
* cell instance $1557 r0 *1 176.44,176.8
X$1557 VPWR VIA_via2_3_2000_480_1_6_320_320
* cell instance $1558 r0 *1 56.44,242.08
X$1558 VPWR VIA_via2_3_2000_480_1_6_320_320
* cell instance $1559 r0 *1 26.44,111.52
X$1559 VPWR VIA_via2_3_2000_480_1_6_320_320
* cell instance $1560 r0 *1 116.44,144.16
X$1560 VPWR VIA_via2_3_2000_480_1_6_320_320
* cell instance $1561 r0 *1 26.44,106.08
X$1561 VPWR VIA_via2_3_2000_480_1_6_320_320
* cell instance $1562 r0 *1 26.44,100.64
X$1562 VPWR VIA_via2_3_2000_480_1_6_320_320
* cell instance $1563 r0 *1 26.44,95.2
X$1563 VPWR VIA_via2_3_2000_480_1_6_320_320
* cell instance $1564 r0 *1 26.44,84.32
X$1564 VPWR VIA_via2_3_2000_480_1_6_320_320
* cell instance $1565 r0 *1 86.44,40.8
X$1565 VPWR VIA_via2_3_2000_480_1_6_320_320
* cell instance $1566 r0 *1 56.44,68
X$1566 VPWR VIA_via2_3_2000_480_1_6_320_320
* cell instance $1567 r0 *1 56.44,73.44
X$1567 VPWR VIA_via2_3_2000_480_1_6_320_320
* cell instance $1568 r0 *1 86.44,13.6
X$1568 VPWR VIA_via2_3_2000_480_1_6_320_320
* cell instance $1569 r0 *1 116.44,160.48
X$1569 VPWR VIA_via2_3_2000_480_1_6_320_320
* cell instance $1570 r0 *1 86.44,19.04
X$1570 VPWR VIA_via2_3_2000_480_1_6_320_320
* cell instance $1571 r0 *1 146.44,160.48
X$1571 VPWR VIA_via2_3_2000_480_1_6_320_320
* cell instance $1572 r0 *1 26.44,19.04
X$1572 VPWR VIA_via2_3_2000_480_1_6_320_320
* cell instance $1573 r0 *1 56.44,155.04
X$1573 VPWR VIA_via2_3_2000_480_1_6_320_320
* cell instance $1574 r0 *1 176.44,149.6
X$1574 VPWR VIA_via2_3_2000_480_1_6_320_320
* cell instance $1575 r0 *1 56.44,62.56
X$1575 VPWR VIA_via2_3_2000_480_1_6_320_320
* cell instance $1576 r0 *1 176.44,155.04
X$1576 VPWR VIA_via2_3_2000_480_1_6_320_320
* cell instance $1577 r0 *1 176.44,187.68
X$1577 VPWR VIA_via2_3_2000_480_1_6_320_320
* cell instance $1578 r0 *1 56.44,122.4
X$1578 VPWR VIA_via2_3_2000_480_1_6_320_320
* cell instance $1579 r0 *1 56.44,57.12
X$1579 VPWR VIA_via2_3_2000_480_1_6_320_320
* cell instance $1580 r0 *1 56.44,144.16
X$1580 VPWR VIA_via2_3_2000_480_1_6_320_320
* cell instance $1581 r0 *1 146.44,144.16
X$1581 VPWR VIA_via2_3_2000_480_1_6_320_320
* cell instance $1582 r0 *1 56.44,263.84
X$1582 VPWR VIA_via2_3_2000_480_1_6_320_320
* cell instance $1583 r0 *1 56.44,24.48
X$1583 VPWR VIA_via2_3_2000_480_1_6_320_320
* cell instance $1584 r0 *1 56.44,252.96
X$1584 VPWR VIA_via2_3_2000_480_1_6_320_320
* cell instance $1585 r0 *1 56.44,280.16
X$1585 VPWR VIA_via2_3_2000_480_1_6_320_320
* cell instance $1586 r0 *1 176.44,193.12
X$1586 VPWR VIA_via2_3_2000_480_1_6_320_320
* cell instance $1587 r0 *1 146.44,242.08
X$1587 VPWR VIA_via2_3_2000_480_1_6_320_320
* cell instance $1588 r0 *1 146.44,231.2
X$1588 VPWR VIA_via2_3_2000_480_1_6_320_320
* cell instance $1589 r0 *1 146.44,236.64
X$1589 VPWR VIA_via2_3_2000_480_1_6_320_320
* cell instance $1590 r0 *1 146.44,209.44
X$1590 VPWR VIA_via2_3_2000_480_1_6_320_320
* cell instance $1591 r0 *1 56.44,149.6
X$1591 VPWR VIA_via2_3_2000_480_1_6_320_320
* cell instance $1592 r0 *1 56.44,269.28
X$1592 VPWR VIA_via2_3_2000_480_1_6_320_320
* cell instance $1593 r0 *1 56.44,247.52
X$1593 VPWR VIA_via2_3_2000_480_1_6_320_320
* cell instance $1594 r0 *1 176.44,144.16
X$1594 VPWR VIA_via2_3_2000_480_1_6_320_320
* cell instance $1595 r0 *1 146.44,225.76
X$1595 VPWR VIA_via2_3_2000_480_1_6_320_320
* cell instance $1596 r0 *1 86.44,29.92
X$1596 VPWR VIA_via2_3_2000_480_1_6_320_320
* cell instance $1597 r0 *1 26.44,231.2
X$1597 VPWR VIA_via2_3_2000_480_1_6_320_320
* cell instance $1598 r0 *1 26.44,252.96
X$1598 VPWR VIA_via2_3_2000_480_1_6_320_320
* cell instance $1599 r0 *1 146.44,182.24
X$1599 VPWR VIA_via2_3_2000_480_1_6_320_320
* cell instance $1600 r0 *1 86.44,204
X$1600 VPWR VIA_via2_3_2000_480_1_6_320_320
* cell instance $1601 r0 *1 116.44,122.4
X$1601 VPWR VIA_via2_3_2000_480_1_6_320_320
* cell instance $1602 r0 *1 116.44,127.84
X$1602 VPWR VIA_via2_3_2000_480_1_6_320_320
* cell instance $1603 r0 *1 86.44,214.88
X$1603 VPWR VIA_via2_3_2000_480_1_6_320_320
* cell instance $1604 r0 *1 116.44,133.28
X$1604 VPWR VIA_via2_3_2000_480_1_6_320_320
* cell instance $1605 r0 *1 56.44,133.28
X$1605 VPWR VIA_via2_3_2000_480_1_6_320_320
* cell instance $1606 r0 *1 86.44,165.92
X$1606 VPWR VIA_via2_3_2000_480_1_6_320_320
* cell instance $1607 r0 *1 146.44,165.92
X$1607 VPWR VIA_via2_3_2000_480_1_6_320_320
* cell instance $1608 r0 *1 86.44,209.44
X$1608 VPWR VIA_via2_3_2000_480_1_6_320_320
* cell instance $1609 r0 *1 86.44,242.08
X$1609 VPWR VIA_via2_3_2000_480_1_6_320_320
* cell instance $1610 r0 *1 116.44,138.72
X$1610 VPWR VIA_via2_3_2000_480_1_6_320_320
* cell instance $1611 r0 *1 56.44,127.84
X$1611 VPWR VIA_via2_3_2000_480_1_6_320_320
* cell instance $1612 r0 *1 26.44,225.76
X$1612 VPWR VIA_via2_3_2000_480_1_6_320_320
* cell instance $1613 r0 *1 176.44,182.24
X$1613 VPWR VIA_via2_3_2000_480_1_6_320_320
* cell instance $1614 r0 *1 56.44,46.24
X$1614 VPWR VIA_via2_3_2000_480_1_6_320_320
* cell instance $1615 r0 *1 56.44,138.72
X$1615 VPWR VIA_via2_3_2000_480_1_6_320_320
* cell instance $1616 r0 *1 26.44,13.6
X$1616 VPWR VIA_via2_3_2000_480_1_6_320_320
* cell instance $1617 r0 *1 26.44,204
X$1617 VPWR VIA_via2_3_2000_480_1_6_320_320
* cell instance $1618 r0 *1 146.44,176.8
X$1618 VPWR VIA_via2_3_2000_480_1_6_320_320
* cell instance $1619 r0 *1 26.44,209.44
X$1619 VPWR VIA_via2_3_2000_480_1_6_320_320
* cell instance $1620 r0 *1 56.44,51.68
X$1620 VPWR VIA_via2_3_2000_480_1_6_320_320
* cell instance $1621 r0 *1 56.44,35.36
X$1621 VPWR VIA_via2_3_2000_480_1_6_320_320
* cell instance $1622 r0 *1 26.44,242.08
X$1622 VPWR VIA_via2_3_2000_480_1_6_320_320
* cell instance $1623 r0 *1 26.44,236.64
X$1623 VPWR VIA_via2_3_2000_480_1_6_320_320
* cell instance $1624 r0 *1 146.44,187.68
X$1624 VPWR VIA_via2_3_2000_480_1_6_320_320
* cell instance $1625 r0 *1 146.44,171.36
X$1625 VPWR VIA_via2_3_2000_480_1_6_320_320
* cell instance $1626 r0 *1 56.44,40.8
X$1626 VPWR VIA_via2_3_2000_480_1_6_320_320
* cell instance $1627 r0 *1 26.44,220.32
X$1627 VPWR VIA_via2_3_2000_480_1_6_320_320
* cell instance $1628 r0 *1 146.44,193.12
X$1628 VPWR VIA_via2_3_2000_480_1_6_320_320
* cell instance $1629 r0 *1 146.44,198.56
X$1629 VPWR VIA_via2_3_2000_480_1_6_320_320
* cell instance $1630 r0 *1 26.44,29.92
X$1630 VPWR VIA_via2_3_2000_480_1_6_320_320
* cell instance $1631 r0 *1 26.44,214.88
X$1631 VPWR VIA_via2_3_2000_480_1_6_320_320
* cell instance $1632 r0 *1 26.44,24.48
X$1632 VPWR VIA_via2_3_2000_480_1_6_320_320
* cell instance $1633 r0 *1 146.44,35.36
X$1633 VPWR VIA_via2_3_2000_480_1_6_320_320
* cell instance $1634 r0 *1 176.44,220.32
X$1634 VPWR VIA_via2_3_2000_480_1_6_320_320
* cell instance $1635 r0 *1 176.44,46.24
X$1635 VPWR VIA_via2_3_2000_480_1_6_320_320
* cell instance $1636 r0 *1 146.44,73.44
X$1636 VPWR VIA_via2_3_2000_480_1_6_320_320
* cell instance $1637 r0 *1 146.44,40.8
X$1637 VPWR VIA_via2_3_2000_480_1_6_320_320
* cell instance $1638 r0 *1 146.44,68
X$1638 VPWR VIA_via2_3_2000_480_1_6_320_320
* cell instance $1639 r0 *1 146.44,62.56
X$1639 VPWR VIA_via2_3_2000_480_1_6_320_320
* cell instance $1640 r0 *1 146.44,57.12
X$1640 VPWR VIA_via2_3_2000_480_1_6_320_320
* cell instance $1641 r0 *1 176.44,280.16
X$1641 VPWR VIA_via2_3_2000_480_1_6_320_320
* cell instance $1642 r0 *1 176.44,214.88
X$1642 VPWR VIA_via2_3_2000_480_1_6_320_320
* cell instance $1643 r0 *1 176.44,231.2
X$1643 VPWR VIA_via2_3_2000_480_1_6_320_320
* cell instance $1644 r0 *1 116.44,280.16
X$1644 VPWR VIA_via2_3_2000_480_1_6_320_320
* cell instance $1645 r0 *1 116.44,40.8
X$1645 VPWR VIA_via2_3_2000_480_1_6_320_320
* cell instance $1646 r0 *1 116.44,35.36
X$1646 VPWR VIA_via2_3_2000_480_1_6_320_320
* cell instance $1647 r0 *1 176.44,285.6
X$1647 VPWR VIA_via2_3_2000_480_1_6_320_320
* cell instance $1648 r0 *1 176.44,269.28
X$1648 VPWR VIA_via2_3_2000_480_1_6_320_320
* cell instance $1649 r0 *1 176.44,274.72
X$1649 VPWR VIA_via2_3_2000_480_1_6_320_320
* cell instance $1650 r0 *1 116.44,225.76
X$1650 VPWR VIA_via2_3_2000_480_1_6_320_320
* cell instance $1651 r0 *1 176.44,29.92
X$1651 VPWR VIA_via2_3_2000_480_1_6_320_320
* cell instance $1652 r0 *1 176.44,225.76
X$1652 VPWR VIA_via2_3_2000_480_1_6_320_320
* cell instance $1653 r0 *1 176.44,242.08
X$1653 VPWR VIA_via2_3_2000_480_1_6_320_320
* cell instance $1654 r0 *1 176.44,57.12
X$1654 VPWR VIA_via2_3_2000_480_1_6_320_320
* cell instance $1655 r0 *1 176.44,236.64
X$1655 VPWR VIA_via2_3_2000_480_1_6_320_320
* cell instance $1656 r0 *1 176.44,62.56
X$1656 VPWR VIA_via2_3_2000_480_1_6_320_320
* cell instance $1657 r0 *1 176.44,68
X$1657 VPWR VIA_via2_3_2000_480_1_6_320_320
* cell instance $1658 r0 *1 146.44,46.24
X$1658 VPWR VIA_via2_3_2000_480_1_6_320_320
* cell instance $1659 r0 *1 116.44,29.92
X$1659 VPWR VIA_via2_3_2000_480_1_6_320_320
* cell instance $1660 r0 *1 116.44,19.04
X$1660 VPWR VIA_via2_3_2000_480_1_6_320_320
* cell instance $1661 r0 *1 146.44,13.6
X$1661 VPWR VIA_via2_3_2000_480_1_6_320_320
* cell instance $1662 r0 *1 146.44,29.92
X$1662 VPWR VIA_via2_3_2000_480_1_6_320_320
* cell instance $1663 r0 *1 146.44,24.48
X$1663 VPWR VIA_via2_3_2000_480_1_6_320_320
* cell instance $1664 r0 *1 116.44,24.48
X$1664 VPWR VIA_via2_3_2000_480_1_6_320_320
* cell instance $1665 r0 *1 146.44,19.04
X$1665 VPWR VIA_via2_3_2000_480_1_6_320_320
* cell instance $1666 r0 *1 116.44,13.6
X$1666 VPWR VIA_via2_3_2000_480_1_6_320_320
* cell instance $1667 r0 *1 146.44,51.68
X$1667 VPWR VIA_via2_3_2000_480_1_6_320_320
* cell instance $1668 r0 *1 176.44,73.44
X$1668 VPWR VIA_via2_3_2000_480_1_6_320_320
* cell instance $1669 r0 *1 176.44,19.04
X$1669 VPWR VIA_via2_3_2000_480_1_6_320_320
* cell instance $1670 r0 *1 176.44,13.6
X$1670 VPWR VIA_via2_3_2000_480_1_6_320_320
* cell instance $1671 r0 *1 146.44,111.52
X$1671 VPWR VIA_via2_3_2000_480_1_6_320_320
* cell instance $1672 r0 *1 146.44,116.96
X$1672 VPWR VIA_via2_3_2000_480_1_6_320_320
* cell instance $1673 r0 *1 146.44,106.08
X$1673 VPWR VIA_via2_3_2000_480_1_6_320_320
* cell instance $1674 r0 *1 146.44,84.32
X$1674 VPWR VIA_via2_3_2000_480_1_6_320_320
* cell instance $1675 r0 *1 146.44,100.64
X$1675 VPWR VIA_via2_3_2000_480_1_6_320_320
* cell instance $1676 r0 *1 146.44,89.76
X$1676 VPWR VIA_via2_3_2000_480_1_6_320_320
* cell instance $1677 r0 *1 146.44,95.2
X$1677 VPWR VIA_via2_3_2000_480_1_6_320_320
* cell instance $1678 r0 *1 116.44,285.6
X$1678 VPWR VIA_via2_3_2000_480_1_6_320_320
* cell instance $1679 r0 *1 146.44,252.96
X$1679 VPWR VIA_via2_3_2000_480_1_6_320_320
* cell instance $1680 r0 *1 146.44,258.4
X$1680 VPWR VIA_via2_3_2000_480_1_6_320_320
* cell instance $1681 r0 *1 146.44,263.84
X$1681 VPWR VIA_via2_3_2000_480_1_6_320_320
* cell instance $1682 r0 *1 116.44,57.12
X$1682 VPWR VIA_via2_3_2000_480_1_6_320_320
* cell instance $1683 r0 *1 146.44,78.88
X$1683 VPWR VIA_via2_3_2000_480_1_6_320_320
* cell instance $1684 r0 *1 146.44,274.72
X$1684 VPWR VIA_via2_3_2000_480_1_6_320_320
* cell instance $1685 r0 *1 146.44,269.28
X$1685 VPWR VIA_via2_3_2000_480_1_6_320_320
* cell instance $1686 r0 *1 146.44,285.6
X$1686 VPWR VIA_via2_3_2000_480_1_6_320_320
* cell instance $1687 r0 *1 146.44,280.16
X$1687 VPWR VIA_via2_3_2000_480_1_6_320_320
* cell instance $1688 r0 *1 116.44,62.56
X$1688 VPWR VIA_via2_3_2000_480_1_6_320_320
* cell instance $1689 r0 *1 116.44,258.4
X$1689 VPWR VIA_via2_3_2000_480_1_6_320_320
* cell instance $1690 r0 *1 116.44,263.84
X$1690 VPWR VIA_via2_3_2000_480_1_6_320_320
* cell instance $1691 r0 *1 116.44,252.96
X$1691 VPWR VIA_via2_3_2000_480_1_6_320_320
* cell instance $1692 r0 *1 116.44,247.52
X$1692 VPWR VIA_via2_3_2000_480_1_6_320_320
* cell instance $1693 r0 *1 146.44,247.52
X$1693 VPWR VIA_via2_3_2000_480_1_6_320_320
* cell instance $1694 r0 *1 116.44,231.2
X$1694 VPWR VIA_via2_3_2000_480_1_6_320_320
* cell instance $1695 r0 *1 176.44,40.8
X$1695 VPWR VIA_via2_3_2000_480_1_6_320_320
* cell instance $1696 r0 *1 116.44,46.24
X$1696 VPWR VIA_via2_3_2000_480_1_6_320_320
* cell instance $1697 r0 *1 116.44,51.68
X$1697 VPWR VIA_via2_3_2000_480_1_6_320_320
* cell instance $1698 r0 *1 116.44,242.08
X$1698 VPWR VIA_via2_3_2000_480_1_6_320_320
* cell instance $1699 r0 *1 176.44,247.52
X$1699 VPWR VIA_via2_3_2000_480_1_6_320_320
* cell instance $1700 r0 *1 176.44,252.96
X$1700 VPWR VIA_via2_3_2000_480_1_6_320_320
* cell instance $1701 r0 *1 176.44,35.36
X$1701 VPWR VIA_via2_3_2000_480_1_6_320_320
* cell instance $1702 r0 *1 176.44,258.4
X$1702 VPWR VIA_via2_3_2000_480_1_6_320_320
* cell instance $1703 r0 *1 176.44,263.84
X$1703 VPWR VIA_via2_3_2000_480_1_6_320_320
* cell instance $1704 r0 *1 116.44,106.08
X$1704 VPWR VIA_via2_3_2000_480_1_6_320_320
* cell instance $1705 r0 *1 116.44,68
X$1705 VPWR VIA_via2_3_2000_480_1_6_320_320
* cell instance $1706 r0 *1 116.44,236.64
X$1706 VPWR VIA_via2_3_2000_480_1_6_320_320
* cell instance $1707 r0 *1 116.44,100.64
X$1707 VPWR VIA_via2_3_2000_480_1_6_320_320
* cell instance $1708 r0 *1 176.44,24.48
X$1708 VPWR VIA_via2_3_2000_480_1_6_320_320
* cell instance $1709 r0 *1 176.44,209.44
X$1709 VPWR VIA_via2_3_2000_480_1_6_320_320
* cell instance $1710 r0 *1 116.44,73.44
X$1710 VPWR VIA_via2_3_2000_480_1_6_320_320
* cell instance $1711 r0 *1 116.44,116.96
X$1711 VPWR VIA_via2_3_2000_480_1_6_320_320
* cell instance $1712 r0 *1 116.44,111.52
X$1712 VPWR VIA_via2_3_2000_480_1_6_320_320
* cell instance $1713 r0 *1 176.44,204
X$1713 VPWR VIA_via2_3_2000_480_1_6_320_320
* cell instance $1714 r0 *1 176.44,51.68
X$1714 VPWR VIA_via2_3_2000_480_1_6_320_320
* cell instance $1715 r0 *1 116.44,274.72
X$1715 VPWR VIA_via2_3_2000_480_1_6_320_320
* cell instance $1716 r0 *1 116.44,95.2
X$1716 VPWR VIA_via2_3_2000_480_1_6_320_320
* cell instance $1717 r0 *1 116.44,269.28
X$1717 VPWR VIA_via2_3_2000_480_1_6_320_320
* cell instance $1718 r0 *1 176.44,84.32
X$1718 VPWR VIA_via2_3_2000_480_1_6_320_320
* cell instance $1719 r0 *1 116.44,89.76
X$1719 VPWR VIA_via2_3_2000_480_1_6_320_320
* cell instance $1720 r0 *1 176.44,95.2
X$1720 VPWR VIA_via2_3_2000_480_1_6_320_320
* cell instance $1721 r0 *1 116.44,84.32
X$1721 VPWR VIA_via2_3_2000_480_1_6_320_320
* cell instance $1722 r0 *1 116.44,78.88
X$1722 VPWR VIA_via2_3_2000_480_1_6_320_320
* cell instance $1723 r0 *1 176.44,111.52
X$1723 VPWR VIA_via2_3_2000_480_1_6_320_320
* cell instance $1724 m90 *1 121.44,65.28
X$1724 VPWR VGND VPWR \$1244 \$1205 \$1227 \$1220 VGND sky130_fd_sc_hd__o21a_2
* cell instance $1725 m90 *1 164.68,16.32
X$1725 VPWR VGND VPWR \$209 \$31 \$17 \$56 VGND sky130_fd_sc_hd__o21a_2
* cell instance $1726 r0 *1 164.68,16.32
X$1726 VGND \$180 \$147 \$148 \$49 \$150 \$151 VPWR VPWR VGND
+ sky130_fd_sc_hd__o221a_2
* cell instance $1727 r0 *1 168.82,16.32
X$1727 VGND \$98 \$143 \$94 VPWR VPWR VGND sky130_fd_sc_hd__xor2_2
* cell instance $1728 r0 *1 174.8,16.32
X$1728 VPWR \$131 VPWR VGND \$157 \$49 \$30 VGND sky130_fd_sc_hd__or3_2
* cell instance $1729 r180 *1 172.04,21.76
X$1729 VGND \$139 \$78 \$27 VPWR VPWR VGND sky130_fd_sc_hd__xnor2_2
* cell instance $1730 m90 *1 175.26,141.44
X$1730 \$I13963 VGND VPWR \$2236 \$2168 \$2100 \$1363 VGND
+ sky130_fd_sc_hd__o21a_2
* cell instance $1731 m90 *1 115.92,228.48
X$1731 VPWR VGND VPWR \$3749 \$3698 \$3694 \$3692 VGND sky130_fd_sc_hd__o21a_2
* cell instance $1732 m90 *1 118.22,65.28
X$1732 VPWR VGND VPWR \$1256 \$1213 \$1223 \$1221 VGND sky130_fd_sc_hd__o21a_2
* cell instance $1733 m90 *1 115.92,223.04
X$1733 VPWR VGND VPWR \$3635 \$3541 \$3532 \$3476 VGND sky130_fd_sc_hd__o21a_2
* cell instance $1734 m90 *1 113.16,201.28
X$1734 VPWR VGND VPWR \$3176 \$3172 \$3173 \$3168 VGND sky130_fd_sc_hd__o21a_2
* cell instance $1735 m90 *1 120.06,103.36
X$1735 VPWR VGND VPWR \$1768 \$1775 \$1743 \$1782 VGND sky130_fd_sc_hd__o21a_2
* cell instance $1736 m90 *1 187.22,195.84
X$1736 VPWR VGND VPWR \$3080 \$3212 \$3079 \$3101 VGND sky130_fd_sc_hd__o21a_2
* cell instance $1737 m90 *1 115.92,239.36
X$1737 VPWR VGND VPWR \$3892 \$3790 \$3824 \$3785 VGND sky130_fd_sc_hd__o21a_2
* cell instance $1738 m0 *1 105.34,288.32
X$1738 VPWR VGND VPWR \$4290 \$4346 \$4352 \$4318 VGND sky130_fd_sc_hd__o21a_2
* cell instance $1739 m0 *1 115,48.96
X$1739 VPWR VGND VPWR \$966 \$967 \$895 \$879 VGND sky130_fd_sc_hd__o21a_2
* cell instance $1740 m0 *1 73.6,43.52
X$1740 VPWR VGND VPWR \$734 \$1021 \$781 \$831 VGND sky130_fd_sc_hd__o21a_2
* cell instance $1741 m0 *1 119.14,119.68
X$1741 VPWR VGND VPWR \$2002 \$2005 \$1958 \$1879 VGND sky130_fd_sc_hd__o21a_2
* cell instance $1742 m0 *1 119.14,190.4
X$1742 VPWR VGND VPWR \$2974 \$2896 \$2889 \$2851 VGND sky130_fd_sc_hd__o21a_2
* cell instance $1743 m0 *1 117.3,272
X$1743 VPWR VGND VPWR \$4171 \$4148 \$4173 \$4168 VGND sky130_fd_sc_hd__o21a_2
* cell instance $1744 r180 *1 127.88,250.24
X$1744 VPWR VGND VPWR \$3951 \$4022 \$3907 \$3902 VGND sky130_fd_sc_hd__o21a_2
* cell instance $1745 r180 *1 118.22,70.72
X$1745 VPWR VGND VPWR \$1302 \$1283 \$1261 \$1281 VGND sky130_fd_sc_hd__o21a_2
* cell instance $1746 r180 *1 113.16,212.16
X$1746 VPWR VGND VPWR \$3385 \$3285 \$3284 \$3381 VGND sky130_fd_sc_hd__o21a_2
* cell instance $1747 r180 *1 113.16,282.88
X$1747 VPWR VGND VPWR \$4245 \$4240 \$4238 \$4196 VGND sky130_fd_sc_hd__o21a_2
* cell instance $1748 r180 *1 185.38,21.76
X$1748 VPWR VGND VPWR \$311 \$61 \$97 \$31 VGND sky130_fd_sc_hd__o21a_2
* cell instance $1749 r0 *1 167.9,146.88
X$1749 VPWR VGND VPWR \$2331 \$2235 \$2237 \$2305 VGND sky130_fd_sc_hd__o21a_2
* cell instance $1750 m0 *1 171.12,152.32
X$1750 VGND \$2404 \$1412 \$1362 \$1363 VPWR VPWR VGND sky130_fd_sc_hd__nor3b_2
* cell instance $1751 r0 *1 108.1,255.68
X$1751 VPWR VGND VPWR \$4030 \$4119 \$4123 \$4090 VGND sky130_fd_sc_hd__o21a_2
* cell instance $1752 r0 *1 109.48,92.48
X$1752 VPWR VGND VPWR \$1557 \$1500 \$1516 \$1555 VGND sky130_fd_sc_hd__o21a_2
* cell instance $1753 r0 *1 111.78,97.92
X$1753 VPWR VGND VPWR \$1709 \$1627 \$1582 \$1618 VGND sky130_fd_sc_hd__o21a_2
* cell instance $1754 r0 *1 120.52,130.56
X$1754 VPWR VGND VPWR \$2125 \$2127 \$2076 \$2052 VGND sky130_fd_sc_hd__o21a_2
* cell instance $1755 r0 *1 110.86,136
X$1755 VPWR VGND VPWR \$2141 \$2202 \$2072 \$2020 VGND sky130_fd_sc_hd__o21a_2
* cell instance $1756 r0 *1 71.3,43.52
X$1756 VPWR VGND VPWR \$920 \$781 \$593 \$837 VGND sky130_fd_sc_hd__o21a_2
* cell instance $1757 r0 *1 111.78,146.88
X$1757 VPWR VGND VPWR \$2295 \$2270 \$2293 \$2229 VGND sky130_fd_sc_hd__o21a_2
* cell instance $1758 m90 *1 164.22,244.8
X$1758 VPWR VGND VPWR \$3492 \$3913 VGND sky130_fd_sc_hd__inv_2
* cell instance $1759 m90 *1 172.5,157.76
X$1759 \$I1151 VGND VPWR \$2305 \$1412 VGND sky130_fd_sc_hd__inv_2
* cell instance $1760 m90 *1 80.5,92.48
X$1760 VPWR VGND VPWR \$1539 \$1512 VGND sky130_fd_sc_hd__inv_2
* cell instance $1761 m90 *1 109.02,233.92
X$1761 VPWR VGND VPWR \$3705 \$3692 VGND sky130_fd_sc_hd__inv_2
* cell instance $1762 m0 *1 165.6,174.08
X$1762 VPWR VGND VPWR \$2654 \$2697 VGND sky130_fd_sc_hd__inv_2
* cell instance $1763 m0 *1 174.34,277.44
X$1763 VPWR VGND VPWR \$4210 \$2269 VGND sky130_fd_sc_hd__inv_2
* cell instance $1764 m0 *1 154.1,179.52
X$1764 VPWR VGND VPWR \$2639 \$1527 VGND sky130_fd_sc_hd__inv_2
* cell instance $1765 m0 *1 33.58,108.8
X$1765 VPWR VGND VPWR \$1839 \$1754 VGND sky130_fd_sc_hd__inv_2
* cell instance $1766 m0 *1 84.64,146.88
X$1766 VPWR VGND VPWR \$2269 \$2265 VGND sky130_fd_sc_hd__inv_2
* cell instance $1767 r180 *1 115,76.16
X$1767 VPWR VGND VPWR \$1274 \$1221 VGND sky130_fd_sc_hd__inv_2
* cell instance $1768 r180 *1 176.18,146.88
X$1768 \$I13963 VGND VPWR \$2235 \$1527 VGND sky130_fd_sc_hd__inv_2
* cell instance $1769 r180 *1 115.92,282.88
X$1769 VPWR VGND VPWR \$4187 \$4168 VGND sky130_fd_sc_hd__inv_2
* cell instance $1770 r180 *1 163.3,250.24
X$1770 VPWR VGND VPWR \$3955 success VGND sky130_fd_sc_hd__inv_2
* cell instance $1771 r180 *1 89.24,103.36
X$1771 VPWR VGND VPWR \$1773 \$1652 VGND sky130_fd_sc_hd__inv_2
* cell instance $1772 r180 *1 115,70.72
X$1772 VPWR VGND VPWR \$1203 \$1220 VGND sky130_fd_sc_hd__inv_2
* cell instance $1773 r180 *1 109.94,212.16
X$1773 VPWR VGND VPWR \$3248 \$3168 VGND sky130_fd_sc_hd__inv_2
* cell instance $1774 r180 *1 115,130.56
X$1774 VPWR VGND VPWR \$2018 \$2020 VGND sky130_fd_sc_hd__inv_2
* cell instance $1775 r180 *1 80.04,97.92
X$1775 VPWR VGND VPWR \$1614 \$1558 VGND sky130_fd_sc_hd__inv_2
* cell instance $1776 r180 *1 115,103.36
X$1776 VPWR VGND VPWR \$1499 \$1555 VGND sky130_fd_sc_hd__inv_2
* cell instance $1777 r180 *1 110.4,217.6
X$1777 VPWR VGND VPWR \$3384 \$3381 VGND sky130_fd_sc_hd__inv_2
* cell instance $1778 r0 *1 168.82,239.36
X$1778 VPWR VGND VPWR \$3886 \$1527 VGND sky130_fd_sc_hd__inv_2
* cell instance $1779 r0 *1 176.18,32.64
X$1779 VPWR VGND VPWR \$569 \$97 VGND sky130_fd_sc_hd__inv_2
* cell instance $1780 r0 *1 75.44,43.52
X$1780 VPWR VGND VPWR \$888 \$836 VGND sky130_fd_sc_hd__inv_2
* cell instance $1781 r0 *1 75.9,103.36
X$1781 VPWR VGND VPWR \$1699 \$933 VGND sky130_fd_sc_hd__inv_2
* cell instance $1782 m0 *1 183.54,195.84
X$1782 VPWR VGND VPWR \$3100 \$2587 \$3084 \$2910 \$2657 VGND
+ sky130_fd_sc_hd__o22a_2
* cell instance $1783 r0 *1 171.12,97.92
X$1783 \$I1121 VGND VPWR \$1682 \$1592 \$1467 \$1663 \$1527 VGND
+ sky130_fd_sc_hd__o22a_2
* cell instance $1784 r0 *1 172.04,108.8
X$1784 VPWR VGND VPWR \$1822 \$1901 \$1910 \$1362 \$1363 VGND
+ sky130_fd_sc_hd__o22a_2
* cell instance $1785 r180 *1 181.7,92.48
X$1785 VGND \$1421 \$1474 \$1472 \$1427 \$1482 \$1468 VPWR VPWR VGND
+ sky130_fd_sc_hd__a311o_2
* cell instance $1786 m90 *1 108.56,277.44
X$1786 VPWR VPWR \$4189 \$4187 \$2449 VGND VGND sky130_fd_sc_hd__and2_2
* cell instance $1787 m90 *1 109.48,206.72
X$1787 VPWR VPWR \$3178 \$3248 \$3333 VGND VGND sky130_fd_sc_hd__and2_2
* cell instance $1788 m90 *1 111.78,97.92
X$1788 VPWR VPWR \$1502 \$1499 \$315 VGND VGND sky130_fd_sc_hd__and2_2
* cell instance $1789 m90 *1 71.3,43.52
X$1789 VPWR VPWR \$609 \$782 \$880 VGND VGND sky130_fd_sc_hd__and2_2
* cell instance $1790 m90 *1 115,81.6
X$1790 VPWR VPWR \$1272 \$1274 \$442 VGND VGND sky130_fd_sc_hd__and2_2
* cell instance $1791 m0 *1 165.14,27.2
X$1791 VPWR VPWR \$340 \$348 \$347 VGND VGND sky130_fd_sc_hd__and2_2
* cell instance $1792 m0 *1 158.7,21.76
X$1792 VPWR VPWR \$126 \$29 \$100 VGND VGND sky130_fd_sc_hd__and2_2
* cell instance $1793 m0 *1 171.12,272
X$1793 \$I13626 VPWR \$1539 \$692 \$4203 VGND VGND sky130_fd_sc_hd__and2_2
* cell instance $1794 m0 *1 166.98,87.04
X$1794 \$I12007 VPWR \$1412 \$1363 \$1427 VGND VGND sky130_fd_sc_hd__and2_2
* cell instance $1795 m0 *1 165.6,87.04
X$1795 \$I12007 VPWR VGND sky130_fd_sc_hd__conb_1
* cell instance $1796 r180 *1 174.8,261.12
X$1796 \$I14138 VPWR \$3813 \$3868 \$3048 VGND VGND sky130_fd_sc_hd__and2_2
* cell instance $1797 r180 *1 113.16,65.28
X$1797 VPWR VPWR \$1140 \$1203 \$381 VGND VGND sky130_fd_sc_hd__and2_2
* cell instance $1798 r180 *1 113.16,217.6
X$1798 VPWR VPWR \$3388 \$3384 \$2518 VGND VGND sky130_fd_sc_hd__and2_2
* cell instance $1799 r180 *1 113.16,239.36
X$1799 VPWR VPWR \$3691 \$3705 \$2419 VGND VGND sky130_fd_sc_hd__and2_2
* cell instance $1800 r180 *1 113.16,130.56
X$1800 VPWR VPWR \$2021 \$2018 \$374 VGND VGND sky130_fd_sc_hd__and2_2
* cell instance $1801 r0 *1 168.36,97.92
X$1801 \$I1121 VPWR \$1663 \$1592 \$1660 VGND VGND sky130_fd_sc_hd__and2_2
* cell instance $1802 r0 *1 165.6,87.04
X$1802 VPWR VPWR \$1363 \$1465 \$1417 VGND VGND sky130_fd_sc_hd__and2_2
* cell instance $1803 m0 *1 138.92,136
X$1803 VPWR VGND sky130_fd_sc_hd__tapvpwrvgnd_1
* cell instance $1804 m0 *1 35.88,195.84
X$1804 VPWR VGND sky130_fd_sc_hd__tapvpwrvgnd_1
* cell instance $1805 m0 *1 138.92,179.52
X$1805 VPWR VGND sky130_fd_sc_hd__tapvpwrvgnd_1
* cell instance $1806 m0 *1 35.88,190.4
X$1806 VPWR VGND sky130_fd_sc_hd__tapvpwrvgnd_1
* cell instance $1807 m0 *1 87.4,54.4
X$1807 VPWR VGND sky130_fd_sc_hd__tapvpwrvgnd_1
* cell instance $1808 m0 *1 138.92,108.8
X$1808 VPWR VGND sky130_fd_sc_hd__tapvpwrvgnd_1
* cell instance $1809 m0 *1 164.68,168.64
X$1809 VPWR VGND sky130_fd_sc_hd__tapvpwrvgnd_1
* cell instance $1810 m0 *1 138.92,87.04
X$1810 VPWR VGND sky130_fd_sc_hd__tapvpwrvgnd_1
* cell instance $1811 m0 *1 138.92,195.84
X$1811 VPWR VGND sky130_fd_sc_hd__tapvpwrvgnd_1
* cell instance $1812 m0 *1 138.92,92.48
X$1812 VPWR VGND sky130_fd_sc_hd__tapvpwrvgnd_1
* cell instance $1813 m0 *1 164.68,206.72
X$1813 VPWR VGND sky130_fd_sc_hd__tapvpwrvgnd_1
* cell instance $1814 m0 *1 138.92,97.92
X$1814 VPWR VGND sky130_fd_sc_hd__tapvpwrvgnd_1
* cell instance $1815 m0 *1 35.88,16.32
X$1815 VPWR VGND sky130_fd_sc_hd__tapvpwrvgnd_1
* cell instance $1816 m0 *1 113.16,261.12
X$1816 VPWR VGND sky130_fd_sc_hd__tapvpwrvgnd_1
* cell instance $1817 m0 *1 35.88,184.96
X$1817 VPWR VGND sky130_fd_sc_hd__tapvpwrvgnd_1
* cell instance $1818 m0 *1 87.4,65.28
X$1818 VPWR VGND sky130_fd_sc_hd__tapvpwrvgnd_1
* cell instance $1819 m0 *1 87.4,70.72
X$1819 VPWR VGND sky130_fd_sc_hd__tapvpwrvgnd_1
* cell instance $1820 m0 *1 87.4,233.92
X$1820 VPWR VGND sky130_fd_sc_hd__tapvpwrvgnd_1
* cell instance $1821 m0 *1 164.68,108.8
X$1821 VPWR VGND sky130_fd_sc_hd__tapvpwrvgnd_1
* cell instance $1822 m0 *1 138.92,163.2
X$1822 VPWR VGND sky130_fd_sc_hd__tapvpwrvgnd_1
* cell instance $1823 m0 *1 164.68,48.96
X$1823 VPWR VGND sky130_fd_sc_hd__tapvpwrvgnd_1
* cell instance $1824 m0 *1 164.68,288.32
X$1824 VPWR VGND sky130_fd_sc_hd__tapvpwrvgnd_1
* cell instance $1825 m0 *1 113.16,146.88
X$1825 VPWR VGND sky130_fd_sc_hd__tapvpwrvgnd_1
* cell instance $1826 m0 *1 164.68,119.68
X$1826 VPWR VGND sky130_fd_sc_hd__tapvpwrvgnd_1
* cell instance $1827 m0 *1 164.68,277.44
X$1827 VPWR VGND sky130_fd_sc_hd__tapvpwrvgnd_1
* cell instance $1828 m0 *1 138.92,114.24
X$1828 VPWR VGND sky130_fd_sc_hd__tapvpwrvgnd_1
* cell instance $1829 m0 *1 164.68,130.56
X$1829 VPWR VGND sky130_fd_sc_hd__tapvpwrvgnd_1
* cell instance $1830 m0 *1 87.4,217.6
X$1830 VPWR VGND sky130_fd_sc_hd__tapvpwrvgnd_1
* cell instance $1831 m0 *1 138.92,174.08
X$1831 VPWR VGND sky130_fd_sc_hd__tapvpwrvgnd_1
* cell instance $1832 m0 *1 138.92,168.64
X$1832 VPWR VGND sky130_fd_sc_hd__tapvpwrvgnd_1
* cell instance $1833 m0 *1 164.68,76.16
X$1833 VPWR VGND sky130_fd_sc_hd__tapvpwrvgnd_1
* cell instance $1834 m0 *1 61.64,103.36
X$1834 VPWR VGND sky130_fd_sc_hd__tapvpwrvgnd_1
* cell instance $1835 m0 *1 113.16,87.04
X$1835 VPWR VGND sky130_fd_sc_hd__tapvpwrvgnd_1
* cell instance $1836 m0 *1 61.64,217.6
X$1836 VPWR VGND sky130_fd_sc_hd__tapvpwrvgnd_1
* cell instance $1837 m0 *1 87.4,38.08
X$1837 VPWR VGND sky130_fd_sc_hd__tapvpwrvgnd_1
* cell instance $1838 m0 *1 113.16,97.92
X$1838 VPWR VGND sky130_fd_sc_hd__tapvpwrvgnd_1
* cell instance $1839 m0 *1 61.64,212.16
X$1839 VPWR VGND sky130_fd_sc_hd__tapvpwrvgnd_1
* cell instance $1840 m0 *1 61.64,206.72
X$1840 VPWR VGND sky130_fd_sc_hd__tapvpwrvgnd_1
* cell instance $1841 m0 *1 113.16,76.16
X$1841 VPWR VGND sky130_fd_sc_hd__tapvpwrvgnd_1
* cell instance $1842 m0 *1 164.68,87.04
X$1842 VPWR VGND sky130_fd_sc_hd__tapvpwrvgnd_1
* cell instance $1843 m0 *1 35.88,43.52
X$1843 VPWR VGND sky130_fd_sc_hd__tapvpwrvgnd_1
* cell instance $1844 m0 *1 164.68,282.88
X$1844 VPWR VGND sky130_fd_sc_hd__tapvpwrvgnd_1
* cell instance $1845 m0 *1 138.92,201.28
X$1845 VPWR VGND sky130_fd_sc_hd__tapvpwrvgnd_1
* cell instance $1846 m0 *1 113.16,266.56
X$1846 VPWR VGND sky130_fd_sc_hd__tapvpwrvgnd_1
* cell instance $1847 m0 *1 126.04,288.32
X$1847 VPWR VGND sky130_fd_sc_hd__tapvpwrvgnd_1
* cell instance $1848 m0 *1 151.8,288.32
X$1848 VPWR VGND sky130_fd_sc_hd__tapvpwrvgnd_1
* cell instance $1849 m0 *1 138.92,76.16
X$1849 VPWR VGND sky130_fd_sc_hd__tapvpwrvgnd_1
* cell instance $1850 m0 *1 164.68,174.08
X$1850 VPWR VGND sky130_fd_sc_hd__tapvpwrvgnd_1
* cell instance $1851 m0 *1 61.64,250.24
X$1851 VPWR VGND sky130_fd_sc_hd__tapvpwrvgnd_1
* cell instance $1852 m0 *1 113.16,206.72
X$1852 VPWR VGND sky130_fd_sc_hd__tapvpwrvgnd_1
* cell instance $1853 m0 *1 113.16,108.8
X$1853 VPWR VGND sky130_fd_sc_hd__tapvpwrvgnd_1
* cell instance $1854 m0 *1 61.64,272
X$1854 VPWR VGND sky130_fd_sc_hd__tapvpwrvgnd_1
* cell instance $1855 m0 *1 113.16,59.84
X$1855 VPWR VGND sky130_fd_sc_hd__tapvpwrvgnd_1
* cell instance $1856 m0 *1 113.16,255.68
X$1856 VPWR VGND sky130_fd_sc_hd__tapvpwrvgnd_1
* cell instance $1857 m0 *1 61.64,277.44
X$1857 VPWR VGND sky130_fd_sc_hd__tapvpwrvgnd_1
* cell instance $1858 m0 *1 113.16,250.24
X$1858 VPWR VGND sky130_fd_sc_hd__tapvpwrvgnd_1
* cell instance $1859 m0 *1 138.92,184.96
X$1859 VPWR VGND sky130_fd_sc_hd__tapvpwrvgnd_1
* cell instance $1860 m0 *1 35.88,21.76
X$1860 VPWR VGND sky130_fd_sc_hd__tapvpwrvgnd_1
* cell instance $1861 m0 *1 35.88,27.2
X$1861 VPWR VGND sky130_fd_sc_hd__tapvpwrvgnd_1
* cell instance $1862 m0 *1 87.4,244.8
X$1862 VPWR VGND sky130_fd_sc_hd__tapvpwrvgnd_1
* cell instance $1863 m0 *1 35.88,70.72
X$1863 VPWR VGND sky130_fd_sc_hd__tapvpwrvgnd_1
* cell instance $1864 m0 *1 35.88,168.64
X$1864 VPWR VGND sky130_fd_sc_hd__tapvpwrvgnd_1
* cell instance $1865 m0 *1 35.88,54.4
X$1865 VPWR VGND sky130_fd_sc_hd__tapvpwrvgnd_1
* cell instance $1866 m0 *1 35.88,65.28
X$1866 VPWR VGND sky130_fd_sc_hd__tapvpwrvgnd_1
* cell instance $1867 m0 *1 35.88,179.52
X$1867 VPWR VGND sky130_fd_sc_hd__tapvpwrvgnd_1
* cell instance $1868 m0 *1 164.68,272
X$1868 VPWR VGND sky130_fd_sc_hd__tapvpwrvgnd_1
* cell instance $1869 m0 *1 164.68,179.52
X$1869 VPWR VGND sky130_fd_sc_hd__tapvpwrvgnd_1
* cell instance $1870 m0 *1 138.92,190.4
X$1870 VPWR VGND sky130_fd_sc_hd__tapvpwrvgnd_1
* cell instance $1871 m0 *1 35.88,59.84
X$1871 VPWR VGND sky130_fd_sc_hd__tapvpwrvgnd_1
* cell instance $1872 m0 *1 100.28,288.32
X$1872 VPWR VGND sky130_fd_sc_hd__tapvpwrvgnd_1
* cell instance $1873 m0 *1 164.68,217.6
X$1873 VPWR VGND sky130_fd_sc_hd__tapvpwrvgnd_1
* cell instance $1874 m0 *1 87.4,92.48
X$1874 VPWR VGND sky130_fd_sc_hd__tapvpwrvgnd_1
* cell instance $1875 m0 *1 87.4,87.04
X$1875 VPWR VGND sky130_fd_sc_hd__tapvpwrvgnd_1
* cell instance $1876 m0 *1 61.64,244.8
X$1876 VPWR VGND sky130_fd_sc_hd__tapvpwrvgnd_1
* cell instance $1877 m0 *1 61.64,228.48
X$1877 VPWR VGND sky130_fd_sc_hd__tapvpwrvgnd_1
* cell instance $1878 m0 *1 61.64,239.36
X$1878 VPWR VGND sky130_fd_sc_hd__tapvpwrvgnd_1
* cell instance $1879 m0 *1 61.64,223.04
X$1879 VPWR VGND sky130_fd_sc_hd__tapvpwrvgnd_1
* cell instance $1880 m0 *1 61.64,233.92
X$1880 VPWR VGND sky130_fd_sc_hd__tapvpwrvgnd_1
* cell instance $1881 m0 *1 35.88,38.08
X$1881 VPWR VGND sky130_fd_sc_hd__tapvpwrvgnd_1
* cell instance $1882 m0 *1 113.16,136
X$1882 VPWR VGND sky130_fd_sc_hd__tapvpwrvgnd_1
* cell instance $1883 m0 *1 35.88,48.96
X$1883 VPWR VGND sky130_fd_sc_hd__tapvpwrvgnd_1
* cell instance $1884 m0 *1 35.88,250.24
X$1884 VPWR VGND sky130_fd_sc_hd__tapvpwrvgnd_1
* cell instance $1885 m0 *1 61.64,125.12
X$1885 VPWR VGND sky130_fd_sc_hd__tapvpwrvgnd_1
* cell instance $1886 m0 *1 164.68,97.92
X$1886 VPWR VGND sky130_fd_sc_hd__tapvpwrvgnd_1
* cell instance $1887 m0 *1 177.56,288.32
X$1887 VPWR VGND sky130_fd_sc_hd__tapvpwrvgnd_1
* cell instance $1888 m0 *1 61.64,130.56
X$1888 VPWR VGND sky130_fd_sc_hd__tapvpwrvgnd_1
* cell instance $1889 m0 *1 61.64,136
X$1889 VPWR VGND sky130_fd_sc_hd__tapvpwrvgnd_1
* cell instance $1890 m0 *1 35.88,261.12
X$1890 VPWR VGND sky130_fd_sc_hd__tapvpwrvgnd_1
* cell instance $1891 m0 *1 138.92,272
X$1891 VPWR VGND sky130_fd_sc_hd__tapvpwrvgnd_1
* cell instance $1892 m0 *1 138.92,239.36
X$1892 VPWR VGND sky130_fd_sc_hd__tapvpwrvgnd_1
* cell instance $1893 m0 *1 138.92,223.04
X$1893 VPWR VGND sky130_fd_sc_hd__tapvpwrvgnd_1
* cell instance $1894 m0 *1 138.92,277.44
X$1894 VPWR VGND sky130_fd_sc_hd__tapvpwrvgnd_1
* cell instance $1895 m0 *1 35.88,201.28
X$1895 VPWR VGND sky130_fd_sc_hd__tapvpwrvgnd_1
* cell instance $1896 m0 *1 164.68,157.76
X$1896 VPWR VGND sky130_fd_sc_hd__tapvpwrvgnd_1
* cell instance $1897 m0 *1 138.92,282.88
X$1897 VPWR VGND sky130_fd_sc_hd__tapvpwrvgnd_1
* cell instance $1898 m0 *1 61.64,27.2
X$1898 VPWR VGND sky130_fd_sc_hd__tapvpwrvgnd_1
* cell instance $1899 m0 *1 61.64,21.76
X$1899 VPWR VGND sky130_fd_sc_hd__tapvpwrvgnd_1
* cell instance $1900 m0 *1 113.16,130.56
X$1900 VPWR VGND sky130_fd_sc_hd__tapvpwrvgnd_1
* cell instance $1901 m0 *1 138.92,81.6
X$1901 VPWR VGND sky130_fd_sc_hd__tapvpwrvgnd_1
* cell instance $1902 m0 *1 61.64,87.04
X$1902 VPWR VGND sky130_fd_sc_hd__tapvpwrvgnd_1
* cell instance $1903 m0 *1 138.92,212.16
X$1903 VPWR VGND sky130_fd_sc_hd__tapvpwrvgnd_1
* cell instance $1904 m0 *1 164.68,27.2
X$1904 VPWR VGND sky130_fd_sc_hd__tapvpwrvgnd_1
* cell instance $1905 m0 *1 113.16,119.68
X$1905 VPWR VGND sky130_fd_sc_hd__tapvpwrvgnd_1
* cell instance $1906 m0 *1 164.68,163.2
X$1906 VPWR VGND sky130_fd_sc_hd__tapvpwrvgnd_1
* cell instance $1907 m0 *1 164.68,146.88
X$1907 VPWR VGND sky130_fd_sc_hd__tapvpwrvgnd_1
* cell instance $1908 m0 *1 87.4,48.96
X$1908 VPWR VGND sky130_fd_sc_hd__tapvpwrvgnd_1
* cell instance $1909 m0 *1 138.92,250.24
X$1909 VPWR VGND sky130_fd_sc_hd__tapvpwrvgnd_1
* cell instance $1910 m0 *1 113.16,32.64
X$1910 VPWR VGND sky130_fd_sc_hd__tapvpwrvgnd_1
* cell instance $1911 m0 *1 164.68,38.08
X$1911 VPWR VGND sky130_fd_sc_hd__tapvpwrvgnd_1
* cell instance $1912 m0 *1 87.4,141.44
X$1912 VPWR VGND sky130_fd_sc_hd__tapvpwrvgnd_1
* cell instance $1913 m0 *1 164.68,136
X$1913 VPWR VGND sky130_fd_sc_hd__tapvpwrvgnd_1
* cell instance $1914 m0 *1 35.88,272
X$1914 VPWR VGND sky130_fd_sc_hd__tapvpwrvgnd_1
* cell instance $1915 m0 *1 87.4,43.52
X$1915 VPWR VGND sky130_fd_sc_hd__tapvpwrvgnd_1
* cell instance $1916 m0 *1 113.16,54.4
X$1916 VPWR VGND sky130_fd_sc_hd__tapvpwrvgnd_1
* cell instance $1917 m0 *1 164.68,16.32
X$1917 VPWR VGND sky130_fd_sc_hd__tapvpwrvgnd_1
* cell instance $1918 m0 *1 113.16,65.28
X$1918 VPWR VGND sky130_fd_sc_hd__tapvpwrvgnd_1
* cell instance $1919 m0 *1 35.88,266.56
X$1919 VPWR VGND sky130_fd_sc_hd__tapvpwrvgnd_1
* cell instance $1920 m0 *1 138.92,233.92
X$1920 VPWR VGND sky130_fd_sc_hd__tapvpwrvgnd_1
* cell instance $1921 m0 *1 113.16,223.04
X$1921 VPWR VGND sky130_fd_sc_hd__tapvpwrvgnd_1
* cell instance $1922 m0 *1 138.92,32.64
X$1922 VPWR VGND sky130_fd_sc_hd__tapvpwrvgnd_1
* cell instance $1923 m0 *1 35.88,288.32
X$1923 VPWR VGND sky130_fd_sc_hd__tapvpwrvgnd_1
* cell instance $1924 m0 *1 164.68,32.64
X$1924 VPWR VGND sky130_fd_sc_hd__tapvpwrvgnd_1
* cell instance $1925 m0 *1 138.92,266.56
X$1925 VPWR VGND sky130_fd_sc_hd__tapvpwrvgnd_1
* cell instance $1926 m0 *1 35.88,282.88
X$1926 VPWR VGND sky130_fd_sc_hd__tapvpwrvgnd_1
* cell instance $1927 m0 *1 138.92,255.68
X$1927 VPWR VGND sky130_fd_sc_hd__tapvpwrvgnd_1
* cell instance $1928 m0 *1 23,288.32
X$1928 VPWR VGND sky130_fd_sc_hd__tapvpwrvgnd_1
* cell instance $1929 m0 *1 138.92,261.12
X$1929 VPWR VGND sky130_fd_sc_hd__tapvpwrvgnd_1
* cell instance $1930 m0 *1 35.88,255.68
X$1930 VPWR VGND sky130_fd_sc_hd__tapvpwrvgnd_1
* cell instance $1931 m0 *1 48.76,288.32
X$1931 VPWR VGND sky130_fd_sc_hd__tapvpwrvgnd_1
* cell instance $1932 m0 *1 113.16,217.6
X$1932 VPWR VGND sky130_fd_sc_hd__tapvpwrvgnd_1
* cell instance $1933 m0 *1 87.4,212.16
X$1933 VPWR VGND sky130_fd_sc_hd__tapvpwrvgnd_1
* cell instance $1934 m0 *1 113.16,92.48
X$1934 VPWR VGND sky130_fd_sc_hd__tapvpwrvgnd_1
* cell instance $1935 m0 *1 35.88,233.92
X$1935 VPWR VGND sky130_fd_sc_hd__tapvpwrvgnd_1
* cell instance $1936 m0 *1 164.68,152.32
X$1936 VPWR VGND sky130_fd_sc_hd__tapvpwrvgnd_1
* cell instance $1937 m0 *1 87.4,228.48
X$1937 VPWR VGND sky130_fd_sc_hd__tapvpwrvgnd_1
* cell instance $1938 m0 *1 87.4,223.04
X$1938 VPWR VGND sky130_fd_sc_hd__tapvpwrvgnd_1
* cell instance $1939 m0 *1 35.88,239.36
X$1939 VPWR VGND sky130_fd_sc_hd__tapvpwrvgnd_1
* cell instance $1940 m0 *1 164.68,141.44
X$1940 VPWR VGND sky130_fd_sc_hd__tapvpwrvgnd_1
* cell instance $1941 m0 *1 164.68,21.76
X$1941 VPWR VGND sky130_fd_sc_hd__tapvpwrvgnd_1
* cell instance $1942 m0 *1 35.88,228.48
X$1942 VPWR VGND sky130_fd_sc_hd__tapvpwrvgnd_1
* cell instance $1943 m0 *1 35.88,277.44
X$1943 VPWR VGND sky130_fd_sc_hd__tapvpwrvgnd_1
* cell instance $1944 m0 *1 87.4,239.36
X$1944 VPWR VGND sky130_fd_sc_hd__tapvpwrvgnd_1
* cell instance $1945 m0 *1 164.68,201.28
X$1945 VPWR VGND sky130_fd_sc_hd__tapvpwrvgnd_1
* cell instance $1946 m0 *1 87.4,59.84
X$1946 VPWR VGND sky130_fd_sc_hd__tapvpwrvgnd_1
* cell instance $1947 m0 *1 164.68,195.84
X$1947 VPWR VGND sky130_fd_sc_hd__tapvpwrvgnd_1
* cell instance $1948 m0 *1 113.16,70.72
X$1948 VPWR VGND sky130_fd_sc_hd__tapvpwrvgnd_1
* cell instance $1949 m0 *1 87.4,16.32
X$1949 VPWR VGND sky130_fd_sc_hd__tapvpwrvgnd_1
* cell instance $1950 m0 *1 35.88,163.2
X$1950 VPWR VGND sky130_fd_sc_hd__tapvpwrvgnd_1
* cell instance $1951 m0 *1 113.16,163.2
X$1951 VPWR VGND sky130_fd_sc_hd__tapvpwrvgnd_1
* cell instance $1952 m0 *1 87.4,157.76
X$1952 VPWR VGND sky130_fd_sc_hd__tapvpwrvgnd_1
* cell instance $1953 m0 *1 138.92,103.36
X$1953 VPWR VGND sky130_fd_sc_hd__tapvpwrvgnd_1
* cell instance $1954 m0 *1 35.88,174.08
X$1954 VPWR VGND sky130_fd_sc_hd__tapvpwrvgnd_1
* cell instance $1955 m0 *1 164.68,212.16
X$1955 VPWR VGND sky130_fd_sc_hd__tapvpwrvgnd_1
* cell instance $1956 m0 *1 87.4,81.6
X$1956 VPWR VGND sky130_fd_sc_hd__tapvpwrvgnd_1
* cell instance $1957 m0 *1 61.64,146.88
X$1957 VPWR VGND sky130_fd_sc_hd__tapvpwrvgnd_1
* cell instance $1958 m0 *1 61.64,16.32
X$1958 VPWR VGND sky130_fd_sc_hd__tapvpwrvgnd_1
* cell instance $1959 m0 *1 61.64,157.76
X$1959 VPWR VGND sky130_fd_sc_hd__tapvpwrvgnd_1
* cell instance $1960 m0 *1 87.4,21.76
X$1960 VPWR VGND sky130_fd_sc_hd__tapvpwrvgnd_1
* cell instance $1961 m0 *1 164.68,114.24
X$1961 VPWR VGND sky130_fd_sc_hd__tapvpwrvgnd_1
* cell instance $1962 m0 *1 164.68,125.12
X$1962 VPWR VGND sky130_fd_sc_hd__tapvpwrvgnd_1
* cell instance $1963 m0 *1 138.92,288.32
X$1963 VPWR VGND sky130_fd_sc_hd__tapvpwrvgnd_1
* cell instance $1964 m0 *1 138.92,228.48
X$1964 VPWR VGND sky130_fd_sc_hd__tapvpwrvgnd_1
* cell instance $1965 m0 *1 35.88,223.04
X$1965 VPWR VGND sky130_fd_sc_hd__tapvpwrvgnd_1
* cell instance $1966 m0 *1 61.64,152.32
X$1966 VPWR VGND sky130_fd_sc_hd__tapvpwrvgnd_1
* cell instance $1967 m0 *1 87.4,206.72
X$1967 VPWR VGND sky130_fd_sc_hd__tapvpwrvgnd_1
* cell instance $1968 m0 *1 35.88,244.8
X$1968 VPWR VGND sky130_fd_sc_hd__tapvpwrvgnd_1
* cell instance $1969 m0 *1 87.4,27.2
X$1969 VPWR VGND sky130_fd_sc_hd__tapvpwrvgnd_1
* cell instance $1970 m0 *1 35.88,212.16
X$1970 VPWR VGND sky130_fd_sc_hd__tapvpwrvgnd_1
* cell instance $1971 m0 *1 35.88,217.6
X$1971 VPWR VGND sky130_fd_sc_hd__tapvpwrvgnd_1
* cell instance $1972 m0 *1 138.92,119.68
X$1972 VPWR VGND sky130_fd_sc_hd__tapvpwrvgnd_1
* cell instance $1973 m0 *1 35.88,206.72
X$1973 VPWR VGND sky130_fd_sc_hd__tapvpwrvgnd_1
* cell instance $1974 m0 *1 138.92,217.6
X$1974 VPWR VGND sky130_fd_sc_hd__tapvpwrvgnd_1
* cell instance $1975 m0 *1 87.4,152.32
X$1975 VPWR VGND sky130_fd_sc_hd__tapvpwrvgnd_1
* cell instance $1976 m0 *1 113.16,81.6
X$1976 VPWR VGND sky130_fd_sc_hd__tapvpwrvgnd_1
* cell instance $1977 m0 *1 138.92,206.72
X$1977 VPWR VGND sky130_fd_sc_hd__tapvpwrvgnd_1
* cell instance $1978 m0 *1 164.68,103.36
X$1978 VPWR VGND sky130_fd_sc_hd__tapvpwrvgnd_1
* cell instance $1979 m0 *1 61.64,92.48
X$1979 VPWR VGND sky130_fd_sc_hd__tapvpwrvgnd_1
* cell instance $1980 m0 *1 138.92,244.8
X$1980 VPWR VGND sky130_fd_sc_hd__tapvpwrvgnd_1
* cell instance $1981 m0 *1 164.68,59.84
X$1981 VPWR VGND sky130_fd_sc_hd__tapvpwrvgnd_1
* cell instance $1982 m0 *1 113.16,190.4
X$1982 VPWR VGND sky130_fd_sc_hd__tapvpwrvgnd_1
* cell instance $1983 m0 *1 35.88,92.48
X$1983 VPWR VGND sky130_fd_sc_hd__tapvpwrvgnd_1
* cell instance $1984 m0 *1 35.88,81.6
X$1984 VPWR VGND sky130_fd_sc_hd__tapvpwrvgnd_1
* cell instance $1985 m0 *1 164.68,65.28
X$1985 VPWR VGND sky130_fd_sc_hd__tapvpwrvgnd_1
* cell instance $1986 m0 *1 35.88,87.04
X$1986 VPWR VGND sky130_fd_sc_hd__tapvpwrvgnd_1
* cell instance $1987 m0 *1 164.68,70.72
X$1987 VPWR VGND sky130_fd_sc_hd__tapvpwrvgnd_1
* cell instance $1988 m0 *1 35.88,114.24
X$1988 VPWR VGND sky130_fd_sc_hd__tapvpwrvgnd_1
* cell instance $1989 m0 *1 87.4,168.64
X$1989 VPWR VGND sky130_fd_sc_hd__tapvpwrvgnd_1
* cell instance $1990 m0 *1 113.16,184.96
X$1990 VPWR VGND sky130_fd_sc_hd__tapvpwrvgnd_1
* cell instance $1991 m0 *1 35.88,125.12
X$1991 VPWR VGND sky130_fd_sc_hd__tapvpwrvgnd_1
* cell instance $1992 m0 *1 113.16,239.36
X$1992 VPWR VGND sky130_fd_sc_hd__tapvpwrvgnd_1
* cell instance $1993 m0 *1 35.88,136
X$1993 VPWR VGND sky130_fd_sc_hd__tapvpwrvgnd_1
* cell instance $1994 m0 *1 113.16,272
X$1994 VPWR VGND sky130_fd_sc_hd__tapvpwrvgnd_1
* cell instance $1995 m0 *1 35.88,130.56
X$1995 VPWR VGND sky130_fd_sc_hd__tapvpwrvgnd_1
* cell instance $1996 m0 *1 35.88,76.16
X$1996 VPWR VGND sky130_fd_sc_hd__tapvpwrvgnd_1
* cell instance $1997 m0 *1 113.16,141.44
X$1997 VPWR VGND sky130_fd_sc_hd__tapvpwrvgnd_1
* cell instance $1998 m0 *1 164.68,190.4
X$1998 VPWR VGND sky130_fd_sc_hd__tapvpwrvgnd_1
* cell instance $1999 m0 *1 87.4,190.4
X$1999 VPWR VGND sky130_fd_sc_hd__tapvpwrvgnd_1
* cell instance $2000 m0 *1 87.4,146.88
X$2000 VPWR VGND sky130_fd_sc_hd__tapvpwrvgnd_1
* cell instance $2001 m0 *1 113.16,228.48
X$2001 VPWR VGND sky130_fd_sc_hd__tapvpwrvgnd_1
* cell instance $2002 m0 *1 113.16,212.16
X$2002 VPWR VGND sky130_fd_sc_hd__tapvpwrvgnd_1
* cell instance $2003 m0 *1 87.4,277.44
X$2003 VPWR VGND sky130_fd_sc_hd__tapvpwrvgnd_1
* cell instance $2004 m0 *1 35.88,157.76
X$2004 VPWR VGND sky130_fd_sc_hd__tapvpwrvgnd_1
* cell instance $2005 m0 *1 87.4,261.12
X$2005 VPWR VGND sky130_fd_sc_hd__tapvpwrvgnd_1
* cell instance $2006 m0 *1 35.88,146.88
X$2006 VPWR VGND sky130_fd_sc_hd__tapvpwrvgnd_1
* cell instance $2007 m0 *1 164.68,54.4
X$2007 VPWR VGND sky130_fd_sc_hd__tapvpwrvgnd_1
* cell instance $2008 m0 *1 138.92,141.44
X$2008 VPWR VGND sky130_fd_sc_hd__tapvpwrvgnd_1
* cell instance $2009 m0 *1 87.4,266.56
X$2009 VPWR VGND sky130_fd_sc_hd__tapvpwrvgnd_1
* cell instance $2010 m0 *1 61.64,54.4
X$2010 VPWR VGND sky130_fd_sc_hd__tapvpwrvgnd_1
* cell instance $2011 m0 *1 61.64,108.8
X$2011 VPWR VGND sky130_fd_sc_hd__tapvpwrvgnd_1
* cell instance $2012 m0 *1 61.64,114.24
X$2012 VPWR VGND sky130_fd_sc_hd__tapvpwrvgnd_1
* cell instance $2013 m0 *1 113.16,114.24
X$2013 VPWR VGND sky130_fd_sc_hd__tapvpwrvgnd_1
* cell instance $2014 m0 *1 138.92,125.12
X$2014 VPWR VGND sky130_fd_sc_hd__tapvpwrvgnd_1
* cell instance $2015 m0 *1 61.64,201.28
X$2015 VPWR VGND sky130_fd_sc_hd__tapvpwrvgnd_1
* cell instance $2016 m0 *1 61.64,184.96
X$2016 VPWR VGND sky130_fd_sc_hd__tapvpwrvgnd_1
* cell instance $2017 m0 *1 138.92,146.88
X$2017 VPWR VGND sky130_fd_sc_hd__tapvpwrvgnd_1
* cell instance $2018 m0 *1 113.16,152.32
X$2018 VPWR VGND sky130_fd_sc_hd__tapvpwrvgnd_1
* cell instance $2019 m0 *1 61.64,190.4
X$2019 VPWR VGND sky130_fd_sc_hd__tapvpwrvgnd_1
* cell instance $2020 m0 *1 164.68,43.52
X$2020 VPWR VGND sky130_fd_sc_hd__tapvpwrvgnd_1
* cell instance $2021 m0 *1 113.16,21.76
X$2021 VPWR VGND sky130_fd_sc_hd__tapvpwrvgnd_1
* cell instance $2022 m0 *1 164.68,228.48
X$2022 VPWR VGND sky130_fd_sc_hd__tapvpwrvgnd_1
* cell instance $2023 m0 *1 164.68,233.92
X$2023 VPWR VGND sky130_fd_sc_hd__tapvpwrvgnd_1
* cell instance $2024 m0 *1 87.4,76.16
X$2024 VPWR VGND sky130_fd_sc_hd__tapvpwrvgnd_1
* cell instance $2025 m0 *1 61.64,59.84
X$2025 VPWR VGND sky130_fd_sc_hd__tapvpwrvgnd_1
* cell instance $2026 m0 *1 61.64,76.16
X$2026 VPWR VGND sky130_fd_sc_hd__tapvpwrvgnd_1
* cell instance $2027 m0 *1 113.16,168.64
X$2027 VPWR VGND sky130_fd_sc_hd__tapvpwrvgnd_1
* cell instance $2028 r0 *1 104.88,163.2
X$2028 VGND clk \$1271 VPWR VPWR VGND sky130_fd_sc_hd__clkbuf_16
* cell instance $2029 m0 *1 61.64,48.96
X$2029 VPWR VGND sky130_fd_sc_hd__tapvpwrvgnd_1
* cell instance $2030 m0 *1 61.64,38.08
X$2030 VPWR VGND sky130_fd_sc_hd__tapvpwrvgnd_1
* cell instance $2031 m0 *1 35.88,97.92
X$2031 VPWR VGND sky130_fd_sc_hd__tapvpwrvgnd_1
* cell instance $2032 m0 *1 61.64,43.52
X$2032 VPWR VGND sky130_fd_sc_hd__tapvpwrvgnd_1
* cell instance $2033 m0 *1 61.64,119.68
X$2033 VPWR VGND sky130_fd_sc_hd__tapvpwrvgnd_1
* cell instance $2034 m0 *1 87.4,103.36
X$2034 VPWR VGND sky130_fd_sc_hd__tapvpwrvgnd_1
* cell instance $2035 m0 *1 164.68,239.36
X$2035 VPWR VGND sky130_fd_sc_hd__tapvpwrvgnd_1
* cell instance $2036 m0 *1 113.16,288.32
X$2036 VPWR VGND sky130_fd_sc_hd__tapvpwrvgnd_1
* cell instance $2037 m0 *1 35.88,32.64
X$2037 VPWR VGND sky130_fd_sc_hd__tapvpwrvgnd_1
* cell instance $2038 m0 *1 164.68,244.8
X$2038 VPWR VGND sky130_fd_sc_hd__tapvpwrvgnd_1
* cell instance $2039 m0 *1 138.92,16.32
X$2039 VPWR VGND sky130_fd_sc_hd__tapvpwrvgnd_1
* cell instance $2040 m0 *1 113.16,27.2
X$2040 VPWR VGND sky130_fd_sc_hd__tapvpwrvgnd_1
* cell instance $2041 m0 *1 35.88,108.8
X$2041 VPWR VGND sky130_fd_sc_hd__tapvpwrvgnd_1
* cell instance $2042 m0 *1 113.16,244.8
X$2042 VPWR VGND sky130_fd_sc_hd__tapvpwrvgnd_1
* cell instance $2043 m0 *1 87.4,184.96
X$2043 VPWR VGND sky130_fd_sc_hd__tapvpwrvgnd_1
* cell instance $2044 m0 *1 113.16,103.36
X$2044 VPWR VGND sky130_fd_sc_hd__tapvpwrvgnd_1
* cell instance $2045 m0 *1 113.16,277.44
X$2045 VPWR VGND sky130_fd_sc_hd__tapvpwrvgnd_1
* cell instance $2046 m0 *1 87.4,130.56
X$2046 VPWR VGND sky130_fd_sc_hd__tapvpwrvgnd_1
* cell instance $2047 m0 *1 61.64,32.64
X$2047 VPWR VGND sky130_fd_sc_hd__tapvpwrvgnd_1
* cell instance $2048 m0 *1 61.64,70.72
X$2048 VPWR VGND sky130_fd_sc_hd__tapvpwrvgnd_1
* cell instance $2049 m0 *1 35.88,103.36
X$2049 VPWR VGND sky130_fd_sc_hd__tapvpwrvgnd_1
* cell instance $2050 m0 *1 87.4,97.92
X$2050 VPWR VGND sky130_fd_sc_hd__tapvpwrvgnd_1
* cell instance $2051 m0 *1 87.4,32.64
X$2051 VPWR VGND sky130_fd_sc_hd__tapvpwrvgnd_1
* cell instance $2052 m0 *1 87.4,125.12
X$2052 VPWR VGND sky130_fd_sc_hd__tapvpwrvgnd_1
* cell instance $2053 m0 *1 113.16,38.08
X$2053 VPWR VGND sky130_fd_sc_hd__tapvpwrvgnd_1
* cell instance $2054 m0 *1 113.16,174.08
X$2054 VPWR VGND sky130_fd_sc_hd__tapvpwrvgnd_1
* cell instance $2055 m0 *1 113.16,179.52
X$2055 VPWR VGND sky130_fd_sc_hd__tapvpwrvgnd_1
* cell instance $2056 m0 *1 113.16,282.88
X$2056 VPWR VGND sky130_fd_sc_hd__tapvpwrvgnd_1
* cell instance $2057 m0 *1 87.4,195.84
X$2057 VPWR VGND sky130_fd_sc_hd__tapvpwrvgnd_1
* cell instance $2058 m0 *1 113.16,48.96
X$2058 VPWR VGND sky130_fd_sc_hd__tapvpwrvgnd_1
* cell instance $2059 m0 *1 87.4,201.28
X$2059 VPWR VGND sky130_fd_sc_hd__tapvpwrvgnd_1
* cell instance $2060 m0 *1 61.64,65.28
X$2060 VPWR VGND sky130_fd_sc_hd__tapvpwrvgnd_1
* cell instance $2061 m0 *1 138.92,21.76
X$2061 VPWR VGND sky130_fd_sc_hd__tapvpwrvgnd_1
* cell instance $2062 m0 *1 61.64,141.44
X$2062 VPWR VGND sky130_fd_sc_hd__tapvpwrvgnd_1
* cell instance $2063 m0 *1 61.64,97.92
X$2063 VPWR VGND sky130_fd_sc_hd__tapvpwrvgnd_1
* cell instance $2064 m0 *1 164.68,250.24
X$2064 VPWR VGND sky130_fd_sc_hd__tapvpwrvgnd_1
* cell instance $2065 m0 *1 138.92,157.76
X$2065 VPWR VGND sky130_fd_sc_hd__tapvpwrvgnd_1
* cell instance $2066 m0 *1 87.4,174.08
X$2066 VPWR VGND sky130_fd_sc_hd__tapvpwrvgnd_1
* cell instance $2067 m0 *1 61.64,174.08
X$2067 VPWR VGND sky130_fd_sc_hd__tapvpwrvgnd_1
* cell instance $2068 m0 *1 61.64,179.52
X$2068 VPWR VGND sky130_fd_sc_hd__tapvpwrvgnd_1
* cell instance $2069 m0 *1 61.64,195.84
X$2069 VPWR VGND sky130_fd_sc_hd__tapvpwrvgnd_1
* cell instance $2070 m0 *1 35.88,141.44
X$2070 VPWR VGND sky130_fd_sc_hd__tapvpwrvgnd_1
* cell instance $2071 m0 *1 87.4,119.68
X$2071 VPWR VGND sky130_fd_sc_hd__tapvpwrvgnd_1
* cell instance $2072 m0 *1 164.68,223.04
X$2072 VPWR VGND sky130_fd_sc_hd__tapvpwrvgnd_1
* cell instance $2073 m0 *1 164.68,261.12
X$2073 VPWR VGND sky130_fd_sc_hd__tapvpwrvgnd_1
* cell instance $2074 m0 *1 113.16,157.76
X$2074 VPWR VGND sky130_fd_sc_hd__tapvpwrvgnd_1
* cell instance $2075 m0 *1 113.16,195.84
X$2075 VPWR VGND sky130_fd_sc_hd__tapvpwrvgnd_1
* cell instance $2076 m0 *1 87.4,250.24
X$2076 VPWR VGND sky130_fd_sc_hd__tapvpwrvgnd_1
* cell instance $2077 m0 *1 138.92,152.32
X$2077 VPWR VGND sky130_fd_sc_hd__tapvpwrvgnd_1
* cell instance $2078 m0 *1 61.64,255.68
X$2078 VPWR VGND sky130_fd_sc_hd__tapvpwrvgnd_1
* cell instance $2079 m0 *1 138.92,43.52
X$2079 VPWR VGND sky130_fd_sc_hd__tapvpwrvgnd_1
* cell instance $2080 m0 *1 74.52,288.32
X$2080 VPWR VGND sky130_fd_sc_hd__tapvpwrvgnd_1
* cell instance $2081 m0 *1 61.64,288.32
X$2081 VPWR VGND sky130_fd_sc_hd__tapvpwrvgnd_1
* cell instance $2082 m0 *1 61.64,261.12
X$2082 VPWR VGND sky130_fd_sc_hd__tapvpwrvgnd_1
* cell instance $2083 m0 *1 138.92,54.4
X$2083 VPWR VGND sky130_fd_sc_hd__tapvpwrvgnd_1
* cell instance $2084 m0 *1 138.92,38.08
X$2084 VPWR VGND sky130_fd_sc_hd__tapvpwrvgnd_1
* cell instance $2085 m0 *1 61.64,282.88
X$2085 VPWR VGND sky130_fd_sc_hd__tapvpwrvgnd_1
* cell instance $2086 m0 *1 164.68,184.96
X$2086 VPWR VGND sky130_fd_sc_hd__tapvpwrvgnd_1
* cell instance $2087 m0 *1 138.92,65.28
X$2087 VPWR VGND sky130_fd_sc_hd__tapvpwrvgnd_1
* cell instance $2088 m0 *1 138.92,70.72
X$2088 VPWR VGND sky130_fd_sc_hd__tapvpwrvgnd_1
* cell instance $2089 m0 *1 87.4,136
X$2089 VPWR VGND sky130_fd_sc_hd__tapvpwrvgnd_1
* cell instance $2090 m0 *1 61.64,266.56
X$2090 VPWR VGND sky130_fd_sc_hd__tapvpwrvgnd_1
* cell instance $2091 m0 *1 164.68,266.56
X$2091 VPWR VGND sky130_fd_sc_hd__tapvpwrvgnd_1
* cell instance $2092 m0 *1 164.68,81.6
X$2092 VPWR VGND sky130_fd_sc_hd__tapvpwrvgnd_1
* cell instance $2093 m0 *1 61.64,81.6
X$2093 VPWR VGND sky130_fd_sc_hd__tapvpwrvgnd_1
* cell instance $2094 m0 *1 87.4,108.8
X$2094 VPWR VGND sky130_fd_sc_hd__tapvpwrvgnd_1
* cell instance $2095 m0 *1 35.88,119.68
X$2095 VPWR VGND sky130_fd_sc_hd__tapvpwrvgnd_1
* cell instance $2096 m0 *1 138.92,130.56
X$2096 VPWR VGND sky130_fd_sc_hd__tapvpwrvgnd_1
* cell instance $2097 m0 *1 61.64,168.64
X$2097 VPWR VGND sky130_fd_sc_hd__tapvpwrvgnd_1
* cell instance $2098 m0 *1 164.68,92.48
X$2098 VPWR VGND sky130_fd_sc_hd__tapvpwrvgnd_1
* cell instance $2099 m0 *1 113.16,43.52
X$2099 VPWR VGND sky130_fd_sc_hd__tapvpwrvgnd_1
* cell instance $2100 m0 *1 87.4,272
X$2100 VPWR VGND sky130_fd_sc_hd__tapvpwrvgnd_1
* cell instance $2101 m0 *1 138.92,48.96
X$2101 VPWR VGND sky130_fd_sc_hd__tapvpwrvgnd_1
* cell instance $2102 m0 *1 113.16,125.12
X$2102 VPWR VGND sky130_fd_sc_hd__tapvpwrvgnd_1
* cell instance $2103 m0 *1 87.4,282.88
X$2103 VPWR VGND sky130_fd_sc_hd__tapvpwrvgnd_1
* cell instance $2104 m0 *1 35.88,152.32
X$2104 VPWR VGND sky130_fd_sc_hd__tapvpwrvgnd_1
* cell instance $2105 m0 *1 113.16,16.32
X$2105 VPWR VGND sky130_fd_sc_hd__tapvpwrvgnd_1
* cell instance $2106 m0 *1 138.92,27.2
X$2106 VPWR VGND sky130_fd_sc_hd__tapvpwrvgnd_1
* cell instance $2107 m0 *1 164.68,255.68
X$2107 VPWR VGND sky130_fd_sc_hd__tapvpwrvgnd_1
* cell instance $2108 m0 *1 87.4,163.2
X$2108 VPWR VGND sky130_fd_sc_hd__tapvpwrvgnd_1
* cell instance $2109 m0 *1 113.16,233.92
X$2109 VPWR VGND sky130_fd_sc_hd__tapvpwrvgnd_1
* cell instance $2110 m0 *1 138.92,59.84
X$2110 VPWR VGND sky130_fd_sc_hd__tapvpwrvgnd_1
* cell instance $2111 m0 *1 61.64,163.2
X$2111 VPWR VGND sky130_fd_sc_hd__tapvpwrvgnd_1
* cell instance $2112 m0 *1 87.4,288.32
X$2112 VPWR VGND sky130_fd_sc_hd__tapvpwrvgnd_1
* cell instance $2113 m0 *1 87.4,114.24
X$2113 VPWR VGND sky130_fd_sc_hd__tapvpwrvgnd_1
* cell instance $2114 m0 *1 87.4,179.52
X$2114 VPWR VGND sky130_fd_sc_hd__tapvpwrvgnd_1
* cell instance $2115 m0 *1 87.4,255.68
X$2115 VPWR VGND sky130_fd_sc_hd__tapvpwrvgnd_1
* cell instance $2116 m0 *1 113.16,201.28
X$2116 VPWR VGND sky130_fd_sc_hd__tapvpwrvgnd_1
* cell instance $2117 r0 *1 48.76,261.12
X$2117 VPWR VGND sky130_fd_sc_hd__tapvpwrvgnd_1
* cell instance $2118 r0 *1 100.28,21.76
X$2118 VPWR VGND sky130_fd_sc_hd__tapvpwrvgnd_1
* cell instance $2119 r0 *1 100.28,136
X$2119 VPWR VGND sky130_fd_sc_hd__tapvpwrvgnd_1
* cell instance $2120 r0 *1 177.56,244.8
X$2120 VPWR VGND sky130_fd_sc_hd__tapvpwrvgnd_1
* cell instance $2121 r0 *1 100.28,152.32
X$2121 VPWR VGND sky130_fd_sc_hd__tapvpwrvgnd_1
* cell instance $2122 r0 *1 100.28,130.56
X$2122 VPWR VGND sky130_fd_sc_hd__tapvpwrvgnd_1
* cell instance $2123 r0 *1 100.28,16.32
X$2123 VPWR VGND sky130_fd_sc_hd__tapvpwrvgnd_1
* cell instance $2124 r0 *1 100.28,27.2
X$2124 VPWR VGND sky130_fd_sc_hd__tapvpwrvgnd_1
* cell instance $2125 r0 *1 100.28,114.24
X$2125 VPWR VGND sky130_fd_sc_hd__tapvpwrvgnd_1
* cell instance $2126 r0 *1 100.28,97.92
X$2126 VPWR VGND sky130_fd_sc_hd__tapvpwrvgnd_1
* cell instance $2127 r0 *1 177.56,266.56
X$2127 VPWR VGND sky130_fd_sc_hd__tapvpwrvgnd_1
* cell instance $2128 r0 *1 100.28,119.68
X$2128 VPWR VGND sky130_fd_sc_hd__tapvpwrvgnd_1
* cell instance $2129 r0 *1 48.76,255.68
X$2129 VPWR VGND sky130_fd_sc_hd__tapvpwrvgnd_1
* cell instance $2130 r0 *1 100.28,108.8
X$2130 VPWR VGND sky130_fd_sc_hd__tapvpwrvgnd_1
* cell instance $2131 r0 *1 48.76,282.88
X$2131 VPWR VGND sky130_fd_sc_hd__tapvpwrvgnd_1
* cell instance $2132 r0 *1 100.28,54.4
X$2132 VPWR VGND sky130_fd_sc_hd__tapvpwrvgnd_1
* cell instance $2133 r0 *1 100.28,70.72
X$2133 VPWR VGND sky130_fd_sc_hd__tapvpwrvgnd_1
* cell instance $2134 r0 *1 97.52,70.72
X$2134 VPWR VGND VPWR \$729 VGND sky130_fd_sc_hd__clkbuf_4
* cell instance $2135 r180 *1 102.58,76.16
X$2135 VGND \$1271 \$729 VPWR VPWR VGND sky130_fd_sc_hd__clkbuf_8
* cell instance $2136 r0 *1 100.28,92.48
X$2136 VPWR VGND sky130_fd_sc_hd__tapvpwrvgnd_1
* cell instance $2137 r0 *1 48.76,250.24
X$2137 VPWR VGND sky130_fd_sc_hd__tapvpwrvgnd_1
* cell instance $2138 r0 *1 100.28,59.84
X$2138 VPWR VGND sky130_fd_sc_hd__tapvpwrvgnd_1
* cell instance $2139 r0 *1 100.28,146.88
X$2139 VPWR VGND sky130_fd_sc_hd__tapvpwrvgnd_1
* cell instance $2140 r0 *1 177.56,92.48
X$2140 VPWR VGND sky130_fd_sc_hd__tapvpwrvgnd_1
* cell instance $2141 r0 *1 100.28,65.28
X$2141 VPWR VGND sky130_fd_sc_hd__tapvpwrvgnd_1
* cell instance $2142 r0 *1 100.28,87.04
X$2142 VPWR VGND sky130_fd_sc_hd__tapvpwrvgnd_1
* cell instance $2143 r0 *1 100.28,48.96
X$2143 VPWR VGND sky130_fd_sc_hd__tapvpwrvgnd_1
* cell instance $2144 r0 *1 151.8,244.8
X$2144 VPWR VGND sky130_fd_sc_hd__tapvpwrvgnd_1
* cell instance $2145 r0 *1 100.28,125.12
X$2145 VPWR VGND sky130_fd_sc_hd__tapvpwrvgnd_1
* cell instance $2146 r0 *1 177.56,136
X$2146 VPWR VGND sky130_fd_sc_hd__tapvpwrvgnd_1
* cell instance $2147 r0 *1 126.04,266.56
X$2147 VPWR VGND sky130_fd_sc_hd__tapvpwrvgnd_1
* cell instance $2148 r0 *1 100.28,76.16
X$2148 VPWR VGND sky130_fd_sc_hd__tapvpwrvgnd_1
* cell instance $2149 r0 *1 100.28,32.64
X$2149 VPWR VGND sky130_fd_sc_hd__tapvpwrvgnd_1
* cell instance $2150 r0 *1 48.76,272
X$2150 VPWR VGND sky130_fd_sc_hd__tapvpwrvgnd_1
* cell instance $2151 r0 *1 48.76,277.44
X$2151 VPWR VGND sky130_fd_sc_hd__tapvpwrvgnd_1
* cell instance $2152 r0 *1 177.56,125.12
X$2152 VPWR VGND sky130_fd_sc_hd__tapvpwrvgnd_1
* cell instance $2153 r0 *1 100.28,103.36
X$2153 VPWR VGND sky130_fd_sc_hd__tapvpwrvgnd_1
* cell instance $2154 r0 *1 100.28,38.08
X$2154 VPWR VGND sky130_fd_sc_hd__tapvpwrvgnd_1
* cell instance $2155 r0 *1 100.28,43.52
X$2155 VPWR VGND sky130_fd_sc_hd__tapvpwrvgnd_1
* cell instance $2156 r0 *1 126.04,108.8
X$2156 VPWR VGND sky130_fd_sc_hd__tapvpwrvgnd_1
* cell instance $2157 r0 *1 126.04,32.64
X$2157 VPWR VGND sky130_fd_sc_hd__tapvpwrvgnd_1
* cell instance $2158 r0 *1 100.28,81.6
X$2158 VPWR VGND sky130_fd_sc_hd__tapvpwrvgnd_1
* cell instance $2159 r0 *1 126.04,272
X$2159 VPWR VGND sky130_fd_sc_hd__tapvpwrvgnd_1
* cell instance $2160 r0 *1 177.56,108.8
X$2160 VPWR VGND sky130_fd_sc_hd__tapvpwrvgnd_1
* cell instance $2161 r0 *1 74.52,277.44
X$2161 VPWR VGND sky130_fd_sc_hd__tapvpwrvgnd_1
* cell instance $2162 r0 *1 100.28,250.24
X$2162 VPWR VGND sky130_fd_sc_hd__tapvpwrvgnd_1
* cell instance $2163 r0 *1 100.28,212.16
X$2163 VPWR VGND sky130_fd_sc_hd__tapvpwrvgnd_1
* cell instance $2164 r0 *1 74.52,223.04
X$2164 VPWR VGND sky130_fd_sc_hd__tapvpwrvgnd_1
* cell instance $2165 r0 *1 100.28,206.72
X$2165 VPWR VGND sky130_fd_sc_hd__tapvpwrvgnd_1
* cell instance $2166 r0 *1 177.56,141.44
X$2166 VPWR VGND sky130_fd_sc_hd__tapvpwrvgnd_1
* cell instance $2167 r0 *1 177.56,130.56
X$2167 VPWR VGND sky130_fd_sc_hd__tapvpwrvgnd_1
* cell instance $2168 r0 *1 74.52,233.92
X$2168 VPWR VGND sky130_fd_sc_hd__tapvpwrvgnd_1
* cell instance $2169 r0 *1 100.28,217.6
X$2169 VPWR VGND sky130_fd_sc_hd__tapvpwrvgnd_1
* cell instance $2170 r0 *1 74.52,228.48
X$2170 VPWR VGND sky130_fd_sc_hd__tapvpwrvgnd_1
* cell instance $2171 r0 *1 100.28,244.8
X$2171 VPWR VGND sky130_fd_sc_hd__tapvpwrvgnd_1
* cell instance $2172 r0 *1 74.52,239.36
X$2172 VPWR VGND sky130_fd_sc_hd__tapvpwrvgnd_1
* cell instance $2173 r0 *1 177.56,157.76
X$2173 VPWR VGND sky130_fd_sc_hd__tapvpwrvgnd_1
* cell instance $2174 r0 *1 126.04,282.88
X$2174 VPWR VGND sky130_fd_sc_hd__tapvpwrvgnd_1
* cell instance $2175 r0 *1 177.56,87.04
X$2175 VPWR VGND sky130_fd_sc_hd__tapvpwrvgnd_1
* cell instance $2176 r0 *1 100.28,266.56
X$2176 VPWR VGND sky130_fd_sc_hd__tapvpwrvgnd_1
* cell instance $2177 r0 *1 126.04,201.28
X$2177 VPWR VGND sky130_fd_sc_hd__tapvpwrvgnd_1
* cell instance $2178 r0 *1 74.52,272
X$2178 VPWR VGND sky130_fd_sc_hd__tapvpwrvgnd_1
* cell instance $2179 r0 *1 74.52,266.56
X$2179 VPWR VGND sky130_fd_sc_hd__tapvpwrvgnd_1
* cell instance $2180 r0 *1 100.28,277.44
X$2180 VPWR VGND sky130_fd_sc_hd__tapvpwrvgnd_1
* cell instance $2181 r0 *1 74.52,282.88
X$2181 VPWR VGND sky130_fd_sc_hd__tapvpwrvgnd_1
* cell instance $2182 r0 *1 151.8,16.32
X$2182 VPWR VGND sky130_fd_sc_hd__tapvpwrvgnd_1
* cell instance $2183 r0 *1 74.52,261.12
X$2183 VPWR VGND sky130_fd_sc_hd__tapvpwrvgnd_1
* cell instance $2184 r0 *1 177.56,76.16
X$2184 VPWR VGND sky130_fd_sc_hd__tapvpwrvgnd_1
* cell instance $2185 r0 *1 177.56,146.88
X$2185 VPWR VGND sky130_fd_sc_hd__tapvpwrvgnd_1
* cell instance $2186 r0 *1 100.28,233.92
X$2186 VPWR VGND sky130_fd_sc_hd__tapvpwrvgnd_1
* cell instance $2187 r0 *1 177.56,152.32
X$2187 VPWR VGND sky130_fd_sc_hd__tapvpwrvgnd_1
* cell instance $2188 r0 *1 74.52,206.72
X$2188 VPWR VGND sky130_fd_sc_hd__tapvpwrvgnd_1
* cell instance $2189 r0 *1 151.8,27.2
X$2189 VPWR VGND sky130_fd_sc_hd__tapvpwrvgnd_1
* cell instance $2190 r0 *1 74.52,212.16
X$2190 VPWR VGND sky130_fd_sc_hd__tapvpwrvgnd_1
* cell instance $2191 r0 *1 126.04,277.44
X$2191 VPWR VGND sky130_fd_sc_hd__tapvpwrvgnd_1
* cell instance $2192 r0 *1 74.52,255.68
X$2192 VPWR VGND sky130_fd_sc_hd__tapvpwrvgnd_1
* cell instance $2193 r0 *1 100.28,223.04
X$2193 VPWR VGND sky130_fd_sc_hd__tapvpwrvgnd_1
* cell instance $2194 r0 *1 74.52,250.24
X$2194 VPWR VGND sky130_fd_sc_hd__tapvpwrvgnd_1
* cell instance $2195 r0 *1 151.8,201.28
X$2195 VPWR VGND sky130_fd_sc_hd__tapvpwrvgnd_1
* cell instance $2196 r0 *1 100.28,184.96
X$2196 VPWR VGND sky130_fd_sc_hd__tapvpwrvgnd_1
* cell instance $2197 r0 *1 126.04,76.16
X$2197 VPWR VGND sky130_fd_sc_hd__tapvpwrvgnd_1
* cell instance $2198 r0 *1 100.28,168.64
X$2198 VPWR VGND sky130_fd_sc_hd__tapvpwrvgnd_1
* cell instance $2199 r0 *1 100.28,179.52
X$2199 VPWR VGND sky130_fd_sc_hd__tapvpwrvgnd_1
* cell instance $2200 r0 *1 100.28,174.08
X$2200 VPWR VGND sky130_fd_sc_hd__tapvpwrvgnd_1
* cell instance $2201 r0 *1 151.8,21.76
X$2201 VPWR VGND sky130_fd_sc_hd__tapvpwrvgnd_1
* cell instance $2202 r0 *1 126.04,250.24
X$2202 VPWR VGND sky130_fd_sc_hd__tapvpwrvgnd_1
* cell instance $2203 r0 *1 126.04,261.12
X$2203 VPWR VGND sky130_fd_sc_hd__tapvpwrvgnd_1
* cell instance $2204 r0 *1 48.76,244.8
X$2204 VPWR VGND sky130_fd_sc_hd__tapvpwrvgnd_1
* cell instance $2205 r0 *1 100.28,163.2
X$2205 VPWR VGND sky130_fd_sc_hd__tapvpwrvgnd_1
* cell instance $2206 r0 *1 100.28,141.44
X$2206 VPWR VGND sky130_fd_sc_hd__tapvpwrvgnd_1
* cell instance $2207 r0 *1 126.04,239.36
X$2207 VPWR VGND sky130_fd_sc_hd__tapvpwrvgnd_1
* cell instance $2208 r0 *1 177.56,179.52
X$2208 VPWR VGND sky130_fd_sc_hd__tapvpwrvgnd_1
* cell instance $2209 r0 *1 100.28,157.76
X$2209 VPWR VGND sky130_fd_sc_hd__tapvpwrvgnd_1
* cell instance $2210 r0 *1 100.28,10.88
X$2210 VPWR VGND sky130_fd_sc_hd__tapvpwrvgnd_1
* cell instance $2211 r0 *1 177.56,81.6
X$2211 VPWR VGND sky130_fd_sc_hd__tapvpwrvgnd_1
* cell instance $2212 r0 *1 23,244.8
X$2212 VPWR VGND sky130_fd_sc_hd__tapvpwrvgnd_1
* cell instance $2213 r0 *1 74.52,217.6
X$2213 VPWR VGND sky130_fd_sc_hd__tapvpwrvgnd_1
* cell instance $2214 r0 *1 100.28,255.68
X$2214 VPWR VGND sky130_fd_sc_hd__tapvpwrvgnd_1
* cell instance $2215 r0 *1 100.28,228.48
X$2215 VPWR VGND sky130_fd_sc_hd__tapvpwrvgnd_1
* cell instance $2216 r0 *1 100.28,239.36
X$2216 VPWR VGND sky130_fd_sc_hd__tapvpwrvgnd_1
* cell instance $2217 r0 *1 177.56,97.92
X$2217 VPWR VGND sky130_fd_sc_hd__tapvpwrvgnd_1
* cell instance $2218 r0 *1 100.28,282.88
X$2218 VPWR VGND sky130_fd_sc_hd__tapvpwrvgnd_1
* cell instance $2219 r0 *1 100.28,190.4
X$2219 VPWR VGND sky130_fd_sc_hd__tapvpwrvgnd_1
* cell instance $2220 r0 *1 100.28,261.12
X$2220 VPWR VGND sky130_fd_sc_hd__tapvpwrvgnd_1
* cell instance $2221 r0 *1 177.56,201.28
X$2221 VPWR VGND sky130_fd_sc_hd__tapvpwrvgnd_1
* cell instance $2222 r0 *1 74.52,244.8
X$2222 VPWR VGND sky130_fd_sc_hd__tapvpwrvgnd_1
* cell instance $2223 r0 *1 23,201.28
X$2223 VPWR VGND sky130_fd_sc_hd__tapvpwrvgnd_1
* cell instance $2224 r0 *1 48.76,201.28
X$2224 VPWR VGND sky130_fd_sc_hd__tapvpwrvgnd_1
* cell instance $2225 r0 *1 74.52,201.28
X$2225 VPWR VGND sky130_fd_sc_hd__tapvpwrvgnd_1
* cell instance $2226 r0 *1 177.56,103.36
X$2226 VPWR VGND sky130_fd_sc_hd__tapvpwrvgnd_1
* cell instance $2227 r0 *1 100.28,201.28
X$2227 VPWR VGND sky130_fd_sc_hd__tapvpwrvgnd_1
* cell instance $2228 r0 *1 177.56,119.68
X$2228 VPWR VGND sky130_fd_sc_hd__tapvpwrvgnd_1
* cell instance $2229 r0 *1 100.28,195.84
X$2229 VPWR VGND sky130_fd_sc_hd__tapvpwrvgnd_1
* cell instance $2230 r0 *1 151.8,157.76
X$2230 VPWR VGND sky130_fd_sc_hd__tapvpwrvgnd_1
* cell instance $2231 r0 *1 100.28,272
X$2231 VPWR VGND sky130_fd_sc_hd__tapvpwrvgnd_1
* cell instance $2232 r0 *1 177.56,195.84
X$2232 VPWR VGND sky130_fd_sc_hd__tapvpwrvgnd_1
* cell instance $2233 r0 *1 23,92.48
X$2233 VPWR VGND sky130_fd_sc_hd__tapvpwrvgnd_1
* cell instance $2234 r0 *1 23,81.6
X$2234 VPWR VGND sky130_fd_sc_hd__tapvpwrvgnd_1
* cell instance $2235 r0 *1 48.76,92.48
X$2235 VPWR VGND sky130_fd_sc_hd__tapvpwrvgnd_1
* cell instance $2236 r0 *1 48.76,76.16
X$2236 VPWR VGND sky130_fd_sc_hd__tapvpwrvgnd_1
* cell instance $2237 r0 *1 74.52,76.16
X$2237 VPWR VGND sky130_fd_sc_hd__tapvpwrvgnd_1
* cell instance $2238 r0 *1 126.04,152.32
X$2238 VPWR VGND sky130_fd_sc_hd__tapvpwrvgnd_1
* cell instance $2239 r0 *1 48.76,87.04
X$2239 VPWR VGND sky130_fd_sc_hd__tapvpwrvgnd_1
* cell instance $2240 r0 *1 48.76,81.6
X$2240 VPWR VGND sky130_fd_sc_hd__tapvpwrvgnd_1
* cell instance $2241 r0 *1 74.52,59.84
X$2241 VPWR VGND sky130_fd_sc_hd__tapvpwrvgnd_1
* cell instance $2242 r0 *1 74.52,54.4
X$2242 VPWR VGND sky130_fd_sc_hd__tapvpwrvgnd_1
* cell instance $2243 r0 *1 151.8,65.28
X$2243 VPWR VGND sky130_fd_sc_hd__tapvpwrvgnd_1
* cell instance $2244 r0 *1 151.8,59.84
X$2244 VPWR VGND sky130_fd_sc_hd__tapvpwrvgnd_1
* cell instance $2245 r0 *1 151.8,54.4
X$2245 VPWR VGND sky130_fd_sc_hd__tapvpwrvgnd_1
* cell instance $2246 r0 *1 177.56,114.24
X$2246 VPWR VGND sky130_fd_sc_hd__tapvpwrvgnd_1
* cell instance $2247 r0 *1 177.56,206.72
X$2247 VPWR VGND sky130_fd_sc_hd__tapvpwrvgnd_1
* cell instance $2248 r0 *1 177.56,21.76
X$2248 VPWR VGND sky130_fd_sc_hd__tapvpwrvgnd_1
* cell instance $2249 m90 *1 182.62,21.76
X$2249 VGND \$56 \$31 \$94 \$313 \$105 VPWR VPWR VGND sky130_fd_sc_hd__o31ai_2
* cell instance $2250 r0 *1 182.62,21.76
X$2250 VPWR \$61 VPWR VGND \$51 \$100 VGND sky130_fd_sc_hd__nand2b_2
* cell instance $2251 r0 *1 151.8,223.04
X$2251 VPWR VGND sky130_fd_sc_hd__tapvpwrvgnd_1
* cell instance $2252 r0 *1 177.56,38.08
X$2252 VPWR VGND sky130_fd_sc_hd__tapvpwrvgnd_1
* cell instance $2253 r0 *1 178.02,38.08
X$2253 VGND \$718 \$572 \$717 \$681 \$627 VPWR VPWR VGND
+ sky130_fd_sc_hd__o211ai_2
* cell instance $2254 r0 *1 74.52,70.72
X$2254 VPWR VGND sky130_fd_sc_hd__tapvpwrvgnd_1
* cell instance $2255 r0 *1 74.52,65.28
X$2255 VPWR VGND sky130_fd_sc_hd__tapvpwrvgnd_1
* cell instance $2256 r0 *1 151.8,43.52
X$2256 VPWR VGND sky130_fd_sc_hd__tapvpwrvgnd_1
* cell instance $2257 r0 *1 151.8,48.96
X$2257 VPWR VGND sky130_fd_sc_hd__tapvpwrvgnd_1
* cell instance $2258 r0 *1 151.8,38.08
X$2258 VPWR VGND sky130_fd_sc_hd__tapvpwrvgnd_1
* cell instance $2259 r0 *1 177.56,48.96
X$2259 VPWR VGND sky130_fd_sc_hd__tapvpwrvgnd_1
* cell instance $2260 m90 *1 181.24,48.96
X$2260 VPWR VPWR \$30 VGND \$50 \$1002 \$49 VGND sky130_fd_sc_hd__o21ai_2
* cell instance $2261 r0 *1 151.8,184.96
X$2261 VPWR VGND sky130_fd_sc_hd__tapvpwrvgnd_1
* cell instance $2262 r0 *1 48.76,32.64
X$2262 VPWR VGND sky130_fd_sc_hd__tapvpwrvgnd_1
* cell instance $2263 r0 *1 74.52,48.96
X$2263 VPWR VGND sky130_fd_sc_hd__tapvpwrvgnd_1
* cell instance $2264 r0 *1 177.56,10.88
X$2264 VPWR VGND sky130_fd_sc_hd__tapvpwrvgnd_1
* cell instance $2265 r0 *1 178.02,10.88
X$2265 VPWR VGND VPWR \$72 \$54 \$57 \$56 VGND sky130_fd_sc_hd__o21a_2
* cell instance $2266 r0 *1 177.56,43.52
X$2266 VPWR VGND sky130_fd_sc_hd__tapvpwrvgnd_1
* cell instance $2267 m90 *1 177.56,43.52
X$2267 VGND \$857 \$796 \$846 \$49 \$501 \$859 VPWR VPWR VGND
+ sky130_fd_sc_hd__a221o_2
* cell instance $2268 r0 *1 151.8,70.72
X$2268 VPWR VGND sky130_fd_sc_hd__tapvpwrvgnd_1
* cell instance $2269 r0 *1 151.8,261.12
X$2269 VPWR VGND sky130_fd_sc_hd__tapvpwrvgnd_1
* cell instance $2270 r0 *1 23,43.52
X$2270 VPWR VGND sky130_fd_sc_hd__tapvpwrvgnd_1
* cell instance $2271 r0 *1 151.8,250.24
X$2271 VPWR VGND sky130_fd_sc_hd__tapvpwrvgnd_1
* cell instance $2272 r0 *1 177.56,16.32
X$2272 VPWR VGND sky130_fd_sc_hd__tapvpwrvgnd_1
* cell instance $2273 m90 *1 181.7,16.32
X$2273 VPWR VPWR VGND \$166 \$169 \$46 \$54 VGND sky130_fd_sc_hd__a21bo_2
* cell instance $2274 r0 *1 23,125.12
X$2274 VPWR VGND sky130_fd_sc_hd__tapvpwrvgnd_1
* cell instance $2275 r0 *1 23,38.08
X$2275 VPWR VGND sky130_fd_sc_hd__tapvpwrvgnd_1
* cell instance $2276 r0 *1 23,141.44
X$2276 VPWR VGND sky130_fd_sc_hd__tapvpwrvgnd_1
* cell instance $2277 r0 *1 151.8,174.08
X$2277 VPWR VGND sky130_fd_sc_hd__tapvpwrvgnd_1
* cell instance $2278 r0 *1 23,136
X$2278 VPWR VGND sky130_fd_sc_hd__tapvpwrvgnd_1
* cell instance $2279 r0 *1 151.8,168.64
X$2279 VPWR VGND sky130_fd_sc_hd__tapvpwrvgnd_1
* cell instance $2280 r0 *1 23,70.72
X$2280 VPWR VGND sky130_fd_sc_hd__tapvpwrvgnd_1
* cell instance $2281 r0 *1 74.52,81.6
X$2281 VPWR VGND sky130_fd_sc_hd__tapvpwrvgnd_1
* cell instance $2282 r0 *1 23,48.96
X$2282 VPWR VGND sky130_fd_sc_hd__tapvpwrvgnd_1
* cell instance $2283 r0 *1 23,59.84
X$2283 VPWR VGND sky130_fd_sc_hd__tapvpwrvgnd_1
* cell instance $2284 r0 *1 126.04,136
X$2284 VPWR VGND sky130_fd_sc_hd__tapvpwrvgnd_1
* cell instance $2285 r0 *1 48.76,152.32
X$2285 VPWR VGND sky130_fd_sc_hd__tapvpwrvgnd_1
* cell instance $2286 r0 *1 151.8,163.2
X$2286 VPWR VGND sky130_fd_sc_hd__tapvpwrvgnd_1
* cell instance $2287 r0 *1 23,54.4
X$2287 VPWR VGND sky130_fd_sc_hd__tapvpwrvgnd_1
* cell instance $2288 r0 *1 23,65.28
X$2288 VPWR VGND sky130_fd_sc_hd__tapvpwrvgnd_1
* cell instance $2289 r0 *1 74.52,97.92
X$2289 VPWR VGND sky130_fd_sc_hd__tapvpwrvgnd_1
* cell instance $2290 r0 *1 74.52,103.36
X$2290 VPWR VGND sky130_fd_sc_hd__tapvpwrvgnd_1
* cell instance $2291 r0 *1 48.76,146.88
X$2291 VPWR VGND sky130_fd_sc_hd__tapvpwrvgnd_1
* cell instance $2292 r0 *1 48.76,141.44
X$2292 VPWR VGND sky130_fd_sc_hd__tapvpwrvgnd_1
* cell instance $2293 r0 *1 177.56,27.2
X$2293 VPWR VGND sky130_fd_sc_hd__tapvpwrvgnd_1
* cell instance $2294 r0 *1 23,108.8
X$2294 VPWR VGND sky130_fd_sc_hd__tapvpwrvgnd_1
* cell instance $2295 r0 *1 23,76.16
X$2295 VPWR VGND sky130_fd_sc_hd__tapvpwrvgnd_1
* cell instance $2296 r0 *1 23,97.92
X$2296 VPWR VGND sky130_fd_sc_hd__tapvpwrvgnd_1
* cell instance $2297 r0 *1 23,103.36
X$2297 VPWR VGND sky130_fd_sc_hd__tapvpwrvgnd_1
* cell instance $2298 r0 *1 23,87.04
X$2298 VPWR VGND sky130_fd_sc_hd__tapvpwrvgnd_1
* cell instance $2299 r0 *1 23,114.24
X$2299 VPWR VGND sky130_fd_sc_hd__tapvpwrvgnd_1
* cell instance $2300 r0 *1 126.04,146.88
X$2300 VPWR VGND sky130_fd_sc_hd__tapvpwrvgnd_1
* cell instance $2301 r0 *1 151.8,190.4
X$2301 VPWR VGND sky130_fd_sc_hd__tapvpwrvgnd_1
* cell instance $2302 r0 *1 177.56,168.64
X$2302 VPWR VGND sky130_fd_sc_hd__tapvpwrvgnd_1
* cell instance $2303 r0 *1 74.52,190.4
X$2303 VPWR VGND sky130_fd_sc_hd__tapvpwrvgnd_1
* cell instance $2304 r0 *1 74.52,195.84
X$2304 VPWR VGND sky130_fd_sc_hd__tapvpwrvgnd_1
* cell instance $2305 r0 *1 74.52,168.64
X$2305 VPWR VGND sky130_fd_sc_hd__tapvpwrvgnd_1
* cell instance $2306 r0 *1 74.52,174.08
X$2306 VPWR VGND sky130_fd_sc_hd__tapvpwrvgnd_1
* cell instance $2307 r0 *1 74.52,179.52
X$2307 VPWR VGND sky130_fd_sc_hd__tapvpwrvgnd_1
* cell instance $2308 r0 *1 177.56,65.28
X$2308 VPWR VGND sky130_fd_sc_hd__tapvpwrvgnd_1
* cell instance $2309 r0 *1 74.52,184.96
X$2309 VPWR VGND sky130_fd_sc_hd__tapvpwrvgnd_1
* cell instance $2310 r0 *1 177.56,70.72
X$2310 VPWR VGND sky130_fd_sc_hd__tapvpwrvgnd_1
* cell instance $2311 r0 *1 177.56,54.4
X$2311 VPWR VGND sky130_fd_sc_hd__tapvpwrvgnd_1
* cell instance $2312 r0 *1 74.52,163.2
X$2312 VPWR VGND sky130_fd_sc_hd__tapvpwrvgnd_1
* cell instance $2313 r0 *1 177.56,212.16
X$2313 VPWR VGND sky130_fd_sc_hd__tapvpwrvgnd_1
* cell instance $2314 r0 *1 177.56,59.84
X$2314 VPWR VGND sky130_fd_sc_hd__tapvpwrvgnd_1
* cell instance $2315 r0 *1 177.56,184.96
X$2315 VPWR VGND sky130_fd_sc_hd__tapvpwrvgnd_1
* cell instance $2316 r0 *1 74.52,43.52
X$2316 VPWR VGND sky130_fd_sc_hd__tapvpwrvgnd_1
* cell instance $2317 r0 *1 74.52,152.32
X$2317 VPWR VGND sky130_fd_sc_hd__tapvpwrvgnd_1
* cell instance $2318 r0 *1 177.56,228.48
X$2318 VPWR VGND sky130_fd_sc_hd__tapvpwrvgnd_1
* cell instance $2319 r0 *1 177.56,233.92
X$2319 VPWR VGND sky130_fd_sc_hd__tapvpwrvgnd_1
* cell instance $2320 r0 *1 177.56,174.08
X$2320 VPWR VGND sky130_fd_sc_hd__tapvpwrvgnd_1
* cell instance $2321 r0 *1 74.52,141.44
X$2321 VPWR VGND sky130_fd_sc_hd__tapvpwrvgnd_1
* cell instance $2322 r0 *1 74.52,146.88
X$2322 VPWR VGND sky130_fd_sc_hd__tapvpwrvgnd_1
* cell instance $2323 r0 *1 177.56,239.36
X$2323 VPWR VGND sky130_fd_sc_hd__tapvpwrvgnd_1
* cell instance $2324 r0 *1 177.56,163.2
X$2324 VPWR VGND sky130_fd_sc_hd__tapvpwrvgnd_1
* cell instance $2325 r0 *1 74.52,119.68
X$2325 VPWR VGND sky130_fd_sc_hd__tapvpwrvgnd_1
* cell instance $2326 r0 *1 74.52,130.56
X$2326 VPWR VGND sky130_fd_sc_hd__tapvpwrvgnd_1
* cell instance $2327 r0 *1 74.52,125.12
X$2327 VPWR VGND sky130_fd_sc_hd__tapvpwrvgnd_1
* cell instance $2328 r0 *1 74.52,136
X$2328 VPWR VGND sky130_fd_sc_hd__tapvpwrvgnd_1
* cell instance $2329 r0 *1 177.56,223.04
X$2329 VPWR VGND sky130_fd_sc_hd__tapvpwrvgnd_1
* cell instance $2330 r0 *1 151.8,179.52
X$2330 VPWR VGND sky130_fd_sc_hd__tapvpwrvgnd_1
* cell instance $2331 r0 *1 74.52,38.08
X$2331 VPWR VGND sky130_fd_sc_hd__tapvpwrvgnd_1
* cell instance $2332 r0 *1 23,32.64
X$2332 VPWR VGND sky130_fd_sc_hd__tapvpwrvgnd_1
* cell instance $2333 r0 *1 74.52,32.64
X$2333 VPWR VGND sky130_fd_sc_hd__tapvpwrvgnd_1
* cell instance $2334 r0 *1 126.04,10.88
X$2334 VPWR VGND sky130_fd_sc_hd__tapvpwrvgnd_1
* cell instance $2335 r0 *1 177.56,217.6
X$2335 VPWR VGND sky130_fd_sc_hd__tapvpwrvgnd_1
* cell instance $2336 r0 *1 126.04,16.32
X$2336 VPWR VGND sky130_fd_sc_hd__tapvpwrvgnd_1
* cell instance $2337 r0 *1 126.04,21.76
X$2337 VPWR VGND sky130_fd_sc_hd__tapvpwrvgnd_1
* cell instance $2338 r0 *1 48.76,136
X$2338 VPWR VGND sky130_fd_sc_hd__tapvpwrvgnd_1
* cell instance $2339 r0 *1 48.76,125.12
X$2339 VPWR VGND sky130_fd_sc_hd__tapvpwrvgnd_1
* cell instance $2340 r0 *1 48.76,130.56
X$2340 VPWR VGND sky130_fd_sc_hd__tapvpwrvgnd_1
* cell instance $2341 r0 *1 48.76,119.68
X$2341 VPWR VGND sky130_fd_sc_hd__tapvpwrvgnd_1
* cell instance $2342 r0 *1 126.04,27.2
X$2342 VPWR VGND sky130_fd_sc_hd__tapvpwrvgnd_1
* cell instance $2343 r0 *1 113.16,10.88
X$2343 VPWR VGND sky130_fd_sc_hd__tapvpwrvgnd_1
* cell instance $2344 r0 *1 138.92,10.88
X$2344 VPWR VGND sky130_fd_sc_hd__tapvpwrvgnd_1
* cell instance $2345 r0 *1 74.52,157.76
X$2345 VPWR VGND sky130_fd_sc_hd__tapvpwrvgnd_1
* cell instance $2346 r0 *1 126.04,43.52
X$2346 VPWR VGND sky130_fd_sc_hd__tapvpwrvgnd_1
* cell instance $2347 r0 *1 48.76,108.8
X$2347 VPWR VGND sky130_fd_sc_hd__tapvpwrvgnd_1
* cell instance $2348 r0 *1 126.04,48.96
X$2348 VPWR VGND sky130_fd_sc_hd__tapvpwrvgnd_1
* cell instance $2349 r0 *1 126.04,59.84
X$2349 VPWR VGND sky130_fd_sc_hd__tapvpwrvgnd_1
* cell instance $2350 r0 *1 126.04,65.28
X$2350 VPWR VGND sky130_fd_sc_hd__tapvpwrvgnd_1
* cell instance $2351 r0 *1 126.04,54.4
X$2351 VPWR VGND sky130_fd_sc_hd__tapvpwrvgnd_1
* cell instance $2352 r0 *1 126.04,70.72
X$2352 VPWR VGND sky130_fd_sc_hd__tapvpwrvgnd_1
* cell instance $2353 r0 *1 151.8,195.84
X$2353 VPWR VGND sky130_fd_sc_hd__tapvpwrvgnd_1
* cell instance $2354 r0 *1 151.8,228.48
X$2354 VPWR VGND sky130_fd_sc_hd__tapvpwrvgnd_1
* cell instance $2355 r0 *1 151.8,239.36
X$2355 VPWR VGND sky130_fd_sc_hd__tapvpwrvgnd_1
* cell instance $2356 r0 *1 151.8,233.92
X$2356 VPWR VGND sky130_fd_sc_hd__tapvpwrvgnd_1
* cell instance $2357 r0 *1 151.8,206.72
X$2357 VPWR VGND sky130_fd_sc_hd__tapvpwrvgnd_1
* cell instance $2358 r0 *1 151.8,217.6
X$2358 VPWR VGND sky130_fd_sc_hd__tapvpwrvgnd_1
* cell instance $2359 r0 *1 151.8,212.16
X$2359 VPWR VGND sky130_fd_sc_hd__tapvpwrvgnd_1
* cell instance $2360 r0 *1 48.76,114.24
X$2360 VPWR VGND sky130_fd_sc_hd__tapvpwrvgnd_1
* cell instance $2361 r0 *1 48.76,97.92
X$2361 VPWR VGND sky130_fd_sc_hd__tapvpwrvgnd_1
* cell instance $2362 r0 *1 48.76,103.36
X$2362 VPWR VGND sky130_fd_sc_hd__tapvpwrvgnd_1
* cell instance $2363 r0 *1 126.04,38.08
X$2363 VPWR VGND sky130_fd_sc_hd__tapvpwrvgnd_1
* cell instance $2364 r0 *1 23,217.6
X$2364 VPWR VGND sky130_fd_sc_hd__tapvpwrvgnd_1
* cell instance $2365 r0 *1 23,228.48
X$2365 VPWR VGND sky130_fd_sc_hd__tapvpwrvgnd_1
* cell instance $2366 r0 *1 74.52,27.2
X$2366 VPWR VGND sky130_fd_sc_hd__tapvpwrvgnd_1
* cell instance $2367 r0 *1 177.56,250.24
X$2367 VPWR VGND sky130_fd_sc_hd__tapvpwrvgnd_1
* cell instance $2368 r0 *1 74.52,10.88
X$2368 VPWR VGND sky130_fd_sc_hd__tapvpwrvgnd_1
* cell instance $2369 r0 *1 74.52,16.32
X$2369 VPWR VGND sky130_fd_sc_hd__tapvpwrvgnd_1
* cell instance $2370 r0 *1 23,212.16
X$2370 VPWR VGND sky130_fd_sc_hd__tapvpwrvgnd_1
* cell instance $2371 r0 *1 23,239.36
X$2371 VPWR VGND sky130_fd_sc_hd__tapvpwrvgnd_1
* cell instance $2372 r0 *1 48.76,239.36
X$2372 VPWR VGND sky130_fd_sc_hd__tapvpwrvgnd_1
* cell instance $2373 r0 *1 126.04,87.04
X$2373 VPWR VGND sky130_fd_sc_hd__tapvpwrvgnd_1
* cell instance $2374 r0 *1 48.76,233.92
X$2374 VPWR VGND sky130_fd_sc_hd__tapvpwrvgnd_1
* cell instance $2375 r0 *1 48.76,223.04
X$2375 VPWR VGND sky130_fd_sc_hd__tapvpwrvgnd_1
* cell instance $2376 r0 *1 48.76,217.6
X$2376 VPWR VGND sky130_fd_sc_hd__tapvpwrvgnd_1
* cell instance $2377 r0 *1 48.76,212.16
X$2377 VPWR VGND sky130_fd_sc_hd__tapvpwrvgnd_1
* cell instance $2378 r0 *1 151.8,255.68
X$2378 VPWR VGND sky130_fd_sc_hd__tapvpwrvgnd_1
* cell instance $2379 r0 *1 177.56,255.68
X$2379 VPWR VGND sky130_fd_sc_hd__tapvpwrvgnd_1
* cell instance $2380 r0 *1 74.52,114.24
X$2380 VPWR VGND sky130_fd_sc_hd__tapvpwrvgnd_1
* cell instance $2381 r0 *1 126.04,130.56
X$2381 VPWR VGND sky130_fd_sc_hd__tapvpwrvgnd_1
* cell instance $2382 r0 *1 126.04,212.16
X$2382 VPWR VGND sky130_fd_sc_hd__tapvpwrvgnd_1
* cell instance $2383 r0 *1 126.04,81.6
X$2383 VPWR VGND sky130_fd_sc_hd__tapvpwrvgnd_1
* cell instance $2384 r0 *1 126.04,217.6
X$2384 VPWR VGND sky130_fd_sc_hd__tapvpwrvgnd_1
* cell instance $2385 r0 *1 126.04,92.48
X$2385 VPWR VGND sky130_fd_sc_hd__tapvpwrvgnd_1
* cell instance $2386 r0 *1 48.76,228.48
X$2386 VPWR VGND sky130_fd_sc_hd__tapvpwrvgnd_1
* cell instance $2387 r0 *1 177.56,261.12
X$2387 VPWR VGND sky130_fd_sc_hd__tapvpwrvgnd_1
* cell instance $2388 r0 *1 126.04,228.48
X$2388 VPWR VGND sky130_fd_sc_hd__tapvpwrvgnd_1
* cell instance $2389 r0 *1 126.04,119.68
X$2389 VPWR VGND sky130_fd_sc_hd__tapvpwrvgnd_1
* cell instance $2390 r0 *1 151.8,10.88
X$2390 VPWR VGND sky130_fd_sc_hd__tapvpwrvgnd_1
* cell instance $2391 r0 *1 126.04,206.72
X$2391 VPWR VGND sky130_fd_sc_hd__tapvpwrvgnd_1
* cell instance $2392 r0 *1 23,157.76
X$2392 VPWR VGND sky130_fd_sc_hd__tapvpwrvgnd_1
* cell instance $2393 r0 *1 48.76,206.72
X$2393 VPWR VGND sky130_fd_sc_hd__tapvpwrvgnd_1
* cell instance $2394 r0 *1 48.76,266.56
X$2394 VPWR VGND sky130_fd_sc_hd__tapvpwrvgnd_1
* cell instance $2395 r0 *1 23,261.12
X$2395 VPWR VGND sky130_fd_sc_hd__tapvpwrvgnd_1
* cell instance $2396 r0 *1 177.56,282.88
X$2396 VPWR VGND sky130_fd_sc_hd__tapvpwrvgnd_1
* cell instance $2397 r0 *1 23,266.56
X$2397 VPWR VGND sky130_fd_sc_hd__tapvpwrvgnd_1
* cell instance $2398 r0 *1 126.04,223.04
X$2398 VPWR VGND sky130_fd_sc_hd__tapvpwrvgnd_1
* cell instance $2399 r0 *1 151.8,136
X$2399 VPWR VGND sky130_fd_sc_hd__tapvpwrvgnd_1
* cell instance $2400 r0 *1 151.8,125.12
X$2400 VPWR VGND sky130_fd_sc_hd__tapvpwrvgnd_1
* cell instance $2401 r0 *1 151.8,130.56
X$2401 VPWR VGND sky130_fd_sc_hd__tapvpwrvgnd_1
* cell instance $2402 r0 *1 151.8,119.68
X$2402 VPWR VGND sky130_fd_sc_hd__tapvpwrvgnd_1
* cell instance $2403 r0 *1 151.8,152.32
X$2403 VPWR VGND sky130_fd_sc_hd__tapvpwrvgnd_1
* cell instance $2404 r0 *1 151.8,141.44
X$2404 VPWR VGND sky130_fd_sc_hd__tapvpwrvgnd_1
* cell instance $2405 r0 *1 151.8,146.88
X$2405 VPWR VGND sky130_fd_sc_hd__tapvpwrvgnd_1
* cell instance $2406 r0 *1 177.56,272
X$2406 VPWR VGND sky130_fd_sc_hd__tapvpwrvgnd_1
* cell instance $2407 r0 *1 177.56,32.64
X$2407 VPWR VGND sky130_fd_sc_hd__tapvpwrvgnd_1
* cell instance $2408 m90 *1 182.62,32.64
X$2408 VGND \$501 \$227 \$572 \$15 \$35 VPWR VPWR VGND sky130_fd_sc_hd__o22ai_2
* cell instance $2409 r0 *1 177.56,190.4
X$2409 VPWR VGND sky130_fd_sc_hd__tapvpwrvgnd_1
* cell instance $2410 r0 *1 23,282.88
X$2410 VPWR VGND sky130_fd_sc_hd__tapvpwrvgnd_1
* cell instance $2411 r0 *1 126.04,103.36
X$2411 VPWR VGND sky130_fd_sc_hd__tapvpwrvgnd_1
* cell instance $2412 r0 *1 23,255.68
X$2412 VPWR VGND sky130_fd_sc_hd__tapvpwrvgnd_1
* cell instance $2413 r0 *1 126.04,97.92
X$2413 VPWR VGND sky130_fd_sc_hd__tapvpwrvgnd_1
* cell instance $2414 r0 *1 126.04,255.68
X$2414 VPWR VGND sky130_fd_sc_hd__tapvpwrvgnd_1
* cell instance $2415 r0 *1 151.8,32.64
X$2415 VPWR VGND sky130_fd_sc_hd__tapvpwrvgnd_1
* cell instance $2416 r0 *1 126.04,233.92
X$2416 VPWR VGND sky130_fd_sc_hd__tapvpwrvgnd_1
* cell instance $2417 r0 *1 61.64,10.88
X$2417 VPWR VGND sky130_fd_sc_hd__tapvpwrvgnd_1
* cell instance $2418 r0 *1 177.56,277.44
X$2418 VPWR VGND sky130_fd_sc_hd__tapvpwrvgnd_1
* cell instance $2419 r0 *1 23,272
X$2419 VPWR VGND sky130_fd_sc_hd__tapvpwrvgnd_1
* cell instance $2420 r0 *1 23,250.24
X$2420 VPWR VGND sky130_fd_sc_hd__tapvpwrvgnd_1
* cell instance $2421 r0 *1 74.52,21.76
X$2421 VPWR VGND sky130_fd_sc_hd__tapvpwrvgnd_1
* cell instance $2422 r0 *1 23,233.92
X$2422 VPWR VGND sky130_fd_sc_hd__tapvpwrvgnd_1
* cell instance $2423 r0 *1 23,223.04
X$2423 VPWR VGND sky130_fd_sc_hd__tapvpwrvgnd_1
* cell instance $2424 r0 *1 23,206.72
X$2424 VPWR VGND sky130_fd_sc_hd__tapvpwrvgnd_1
* cell instance $2425 r0 *1 23,277.44
X$2425 VPWR VGND sky130_fd_sc_hd__tapvpwrvgnd_1
* cell instance $2426 r0 *1 23,195.84
X$2426 VPWR VGND sky130_fd_sc_hd__tapvpwrvgnd_1
* cell instance $2427 r0 *1 23,168.64
X$2427 VPWR VGND sky130_fd_sc_hd__tapvpwrvgnd_1
* cell instance $2428 r0 *1 23,179.52
X$2428 VPWR VGND sky130_fd_sc_hd__tapvpwrvgnd_1
* cell instance $2429 r0 *1 151.8,97.92
X$2429 VPWR VGND sky130_fd_sc_hd__tapvpwrvgnd_1
* cell instance $2430 r0 *1 48.76,48.96
X$2430 VPWR VGND sky130_fd_sc_hd__tapvpwrvgnd_1
* cell instance $2431 r0 *1 151.8,114.24
X$2431 VPWR VGND sky130_fd_sc_hd__tapvpwrvgnd_1
* cell instance $2432 r0 *1 48.76,43.52
X$2432 VPWR VGND sky130_fd_sc_hd__tapvpwrvgnd_1
* cell instance $2433 r0 *1 151.8,103.36
X$2433 VPWR VGND sky130_fd_sc_hd__tapvpwrvgnd_1
* cell instance $2434 r0 *1 23,184.96
X$2434 VPWR VGND sky130_fd_sc_hd__tapvpwrvgnd_1
* cell instance $2435 r0 *1 151.8,76.16
X$2435 VPWR VGND sky130_fd_sc_hd__tapvpwrvgnd_1
* cell instance $2436 r0 *1 74.52,92.48
X$2436 VPWR VGND sky130_fd_sc_hd__tapvpwrvgnd_1
* cell instance $2437 r0 *1 48.76,38.08
X$2437 VPWR VGND sky130_fd_sc_hd__tapvpwrvgnd_1
* cell instance $2438 r0 *1 151.8,92.48
X$2438 VPWR VGND sky130_fd_sc_hd__tapvpwrvgnd_1
* cell instance $2439 r0 *1 151.8,87.04
X$2439 VPWR VGND sky130_fd_sc_hd__tapvpwrvgnd_1
* cell instance $2440 r0 *1 48.76,157.76
X$2440 VPWR VGND sky130_fd_sc_hd__tapvpwrvgnd_1
* cell instance $2441 r0 *1 151.8,81.6
X$2441 VPWR VGND sky130_fd_sc_hd__tapvpwrvgnd_1
* cell instance $2442 r0 *1 23,119.68
X$2442 VPWR VGND sky130_fd_sc_hd__tapvpwrvgnd_1
* cell instance $2443 r0 *1 126.04,190.4
X$2443 VPWR VGND sky130_fd_sc_hd__tapvpwrvgnd_1
* cell instance $2444 r0 *1 48.76,59.84
X$2444 VPWR VGND sky130_fd_sc_hd__tapvpwrvgnd_1
* cell instance $2445 r0 *1 48.76,65.28
X$2445 VPWR VGND sky130_fd_sc_hd__tapvpwrvgnd_1
* cell instance $2446 r0 *1 23,146.88
X$2446 VPWR VGND sky130_fd_sc_hd__tapvpwrvgnd_1
* cell instance $2447 r0 *1 23,130.56
X$2447 VPWR VGND sky130_fd_sc_hd__tapvpwrvgnd_1
* cell instance $2448 r0 *1 23,152.32
X$2448 VPWR VGND sky130_fd_sc_hd__tapvpwrvgnd_1
* cell instance $2449 r0 *1 126.04,195.84
X$2449 VPWR VGND sky130_fd_sc_hd__tapvpwrvgnd_1
* cell instance $2450 r0 *1 151.8,272
X$2450 VPWR VGND sky130_fd_sc_hd__tapvpwrvgnd_1
* cell instance $2451 r0 *1 151.8,282.88
X$2451 VPWR VGND sky130_fd_sc_hd__tapvpwrvgnd_1
* cell instance $2452 r0 *1 151.8,277.44
X$2452 VPWR VGND sky130_fd_sc_hd__tapvpwrvgnd_1
* cell instance $2453 r0 *1 126.04,184.96
X$2453 VPWR VGND sky130_fd_sc_hd__tapvpwrvgnd_1
* cell instance $2454 r0 *1 126.04,244.8
X$2454 VPWR VGND sky130_fd_sc_hd__tapvpwrvgnd_1
* cell instance $2455 r0 *1 126.04,141.44
X$2455 VPWR VGND sky130_fd_sc_hd__tapvpwrvgnd_1
* cell instance $2456 r0 *1 74.52,87.04
X$2456 VPWR VGND sky130_fd_sc_hd__tapvpwrvgnd_1
* cell instance $2457 r0 *1 87.4,10.88
X$2457 VPWR VGND sky130_fd_sc_hd__tapvpwrvgnd_1
* cell instance $2458 r0 *1 48.76,174.08
X$2458 VPWR VGND sky130_fd_sc_hd__tapvpwrvgnd_1
* cell instance $2459 r0 *1 35.88,10.88
X$2459 VPWR VGND sky130_fd_sc_hd__tapvpwrvgnd_1
* cell instance $2460 r0 *1 126.04,157.76
X$2460 VPWR VGND sky130_fd_sc_hd__tapvpwrvgnd_1
* cell instance $2461 r0 *1 48.76,10.88
X$2461 VPWR VGND sky130_fd_sc_hd__tapvpwrvgnd_1
* cell instance $2462 r0 *1 151.8,266.56
X$2462 VPWR VGND sky130_fd_sc_hd__tapvpwrvgnd_1
* cell instance $2463 r0 *1 126.04,114.24
X$2463 VPWR VGND sky130_fd_sc_hd__tapvpwrvgnd_1
* cell instance $2464 r0 *1 48.76,163.2
X$2464 VPWR VGND sky130_fd_sc_hd__tapvpwrvgnd_1
* cell instance $2465 r0 *1 23,16.32
X$2465 VPWR VGND sky130_fd_sc_hd__tapvpwrvgnd_1
* cell instance $2466 r0 *1 48.76,179.52
X$2466 VPWR VGND sky130_fd_sc_hd__tapvpwrvgnd_1
* cell instance $2467 r0 *1 126.04,125.12
X$2467 VPWR VGND sky130_fd_sc_hd__tapvpwrvgnd_1
* cell instance $2468 r0 *1 48.76,168.64
X$2468 VPWR VGND sky130_fd_sc_hd__tapvpwrvgnd_1
* cell instance $2469 r0 *1 126.04,163.2
X$2469 VPWR VGND sky130_fd_sc_hd__tapvpwrvgnd_1
* cell instance $2470 r0 *1 23,10.88
X$2470 VPWR VGND sky130_fd_sc_hd__tapvpwrvgnd_1
* cell instance $2471 r0 *1 23,21.76
X$2471 VPWR VGND sky130_fd_sc_hd__tapvpwrvgnd_1
* cell instance $2472 r0 *1 23,163.2
X$2472 VPWR VGND sky130_fd_sc_hd__tapvpwrvgnd_1
* cell instance $2473 r0 *1 48.76,190.4
X$2473 VPWR VGND sky130_fd_sc_hd__tapvpwrvgnd_1
* cell instance $2474 r0 *1 48.76,21.76
X$2474 VPWR VGND sky130_fd_sc_hd__tapvpwrvgnd_1
* cell instance $2475 r0 *1 48.76,184.96
X$2475 VPWR VGND sky130_fd_sc_hd__tapvpwrvgnd_1
* cell instance $2476 r0 *1 48.76,195.84
X$2476 VPWR VGND sky130_fd_sc_hd__tapvpwrvgnd_1
* cell instance $2477 r0 *1 48.76,27.2
X$2477 VPWR VGND sky130_fd_sc_hd__tapvpwrvgnd_1
* cell instance $2478 r0 *1 48.76,16.32
X$2478 VPWR VGND sky130_fd_sc_hd__tapvpwrvgnd_1
* cell instance $2479 r0 *1 126.04,179.52
X$2479 VPWR VGND sky130_fd_sc_hd__tapvpwrvgnd_1
* cell instance $2480 r0 *1 126.04,168.64
X$2480 VPWR VGND sky130_fd_sc_hd__tapvpwrvgnd_1
* cell instance $2481 r0 *1 23,190.4
X$2481 VPWR VGND sky130_fd_sc_hd__tapvpwrvgnd_1
* cell instance $2482 r0 *1 23,174.08
X$2482 VPWR VGND sky130_fd_sc_hd__tapvpwrvgnd_1
* cell instance $2483 r0 *1 126.04,174.08
X$2483 VPWR VGND sky130_fd_sc_hd__tapvpwrvgnd_1
* cell instance $2484 r0 *1 48.76,70.72
X$2484 VPWR VGND sky130_fd_sc_hd__tapvpwrvgnd_1
* cell instance $2485 r0 *1 74.52,108.8
X$2485 VPWR VGND sky130_fd_sc_hd__tapvpwrvgnd_1
* cell instance $2486 r0 *1 48.76,54.4
X$2486 VPWR VGND sky130_fd_sc_hd__tapvpwrvgnd_1
* cell instance $2487 r0 *1 151.8,108.8
X$2487 VPWR VGND sky130_fd_sc_hd__tapvpwrvgnd_1
* cell instance $2488 r0 *1 23,27.2
X$2488 VPWR VGND sky130_fd_sc_hd__tapvpwrvgnd_1
* cell instance $2489 m90 *1 166.06,48.96
X$2489 VPWR VPWR \$986 \$861 VGND \$864 VGND sky130_fd_sc_hd__nand2_2
* cell instance $2490 m90 *1 155.48,32.64
X$2490 VPWR VPWR \$556 \$486 VGND \$418 VGND sky130_fd_sc_hd__nand2_2
* cell instance $2491 m90 *1 40.94,97.92
X$2491 VPWR VPWR \$1566 \$933 VGND \$1558 VGND sky130_fd_sc_hd__nand2_2
* cell instance $2492 m90 *1 155.48,21.76
X$2492 VPWR VPWR \$105 \$56 VGND \$98 VGND sky130_fd_sc_hd__nand2_2
* cell instance $2493 m90 *1 154.56,27.2
X$2493 VPWR VPWR \$89 \$29 VGND \$98 VGND sky130_fd_sc_hd__nand2_2
* cell instance $2494 m90 *1 126.04,130.56
X$2494 VPWR VPWR \$2079 \$933 VGND I VGND sky130_fd_sc_hd__nand2_2
* cell instance $2495 m90 *1 118.68,266.56
X$2495 VPWR VPWR \$4180 \$933 VGND I VGND sky130_fd_sc_hd__nand2_2
* cell instance $2496 m90 *1 164.22,168.64
X$2496 VPWR VPWR \$2697 \$2648 VGND \$1362 VGND sky130_fd_sc_hd__nand2_2
* cell instance $2497 m90 *1 177.1,97.92
X$2497 \$I1121 VPWR \$1592 \$1527 VGND \$1362 VGND sky130_fd_sc_hd__nand2_2
* cell instance $2498 m90 *1 155.02,190.4
X$2498 VPWR VPWR \$3046 \$2775 VGND \$2904 VGND sky130_fd_sc_hd__nand2_2
* cell instance $2499 m90 *1 166.52,201.28
X$2499 VPWR VPWR \$2872 \$2900 VGND \$2752 VGND sky130_fd_sc_hd__nand2_2
* cell instance $2500 m90 *1 126.04,233.92
X$2500 VPWR VPWR \$3797 \$933 VGND I VGND sky130_fd_sc_hd__nand2_2
* cell instance $2501 m0 *1 152.26,38.08
X$2501 VPWR VPWR \$654 \$417 VGND \$416 VGND sky130_fd_sc_hd__nand2_2
* cell instance $2502 m0 *1 184.46,27.2
X$2502 VPWR VPWR \$368 \$313 VGND \$49 VGND sky130_fd_sc_hd__nand2_2
* cell instance $2503 m0 *1 155.02,27.2
X$2503 VPWR VPWR \$93 \$348 VGND \$340 VGND sky130_fd_sc_hd__nand2_2
* cell instance $2504 m0 *1 162.38,16.32
X$2504 VPWR VPWR \$80 \$97 VGND \$98 VGND sky130_fd_sc_hd__nand2_2
* cell instance $2505 m0 *1 110.86,92.48
X$2505 VPWR VPWR \$1402 \$933 VGND I VGND sky130_fd_sc_hd__nand2_2
* cell instance $2506 m0 *1 153.18,184.96
X$2506 VPWR VPWR \$2705 \$1527 VGND \$1363 VGND sky130_fd_sc_hd__nand2_2
* cell instance $2507 m0 *1 177.1,136
X$2507 VPWR VPWR \$2100 \$2043 VGND \$1412 VGND sky130_fd_sc_hd__nand2_2
* cell instance $2508 m0 *1 167.44,168.64
X$2508 \$I11849 VPWR \$2566 \$1363 VGND \$1412 VGND sky130_fd_sc_hd__nand2_2
* cell instance $2509 m0 *1 160.08,16.32
X$2509 VPWR VPWR \$288 \$93 VGND \$139 VGND sky130_fd_sc_hd__nand2_2
* cell instance $2510 m0 *1 153.18,32.64
X$2510 VPWR VPWR \$664 \$417 VGND \$348 VGND sky130_fd_sc_hd__nand2_2
* cell instance $2511 r180 *1 119.6,201.28
X$2511 VPWR VPWR \$3174 \$933 VGND I VGND sky130_fd_sc_hd__nand2_2
* cell instance $2512 r180 *1 113.16,70.72
X$2512 VPWR VPWR \$1275 \$933 VGND I VGND sky130_fd_sc_hd__nand2_2
* cell instance $2513 r180 *1 157.78,16.32
X$2513 VPWR VPWR \$15 \$14 VGND \$46 VGND sky130_fd_sc_hd__nand2_2
* cell instance $2514 r180 *1 126.04,217.6
X$2514 VPWR VPWR \$3387 \$933 VGND I VGND sky130_fd_sc_hd__nand2_2
* cell instance $2515 r180 *1 69.46,48.96
X$2515 VPWR VPWR \$781 \$969 VGND \$836 VGND sky130_fd_sc_hd__nand2_2
* cell instance $2516 r180 *1 167.44,54.4
X$2516 VPWR VPWR \$490 \$521 VGND \$668 VGND sky130_fd_sc_hd__nand2_2
* cell instance $2517 r180 *1 170.2,97.92
X$2517 VPWR VPWR \$1663 \$1363 VGND \$1412 VGND sky130_fd_sc_hd__nand2_2
* cell instance $2518 r180 *1 155.48,16.32
X$2518 VPWR VPWR \$23 \$46 VGND \$126 VGND sky130_fd_sc_hd__nand2_2
* cell instance $2519 r0 *1 169.74,163.2
X$2519 \$I11849 VPWR \$2567 \$2596 VGND \$2592 VGND sky130_fd_sc_hd__nand2_2
* cell instance $2520 r0 *1 112.7,59.84
X$2520 VPWR VPWR \$1201 \$933 VGND I VGND sky130_fd_sc_hd__nand2_2
* cell instance $2521 r0 *1 156.86,27.2
X$2521 VPWR VPWR \$476 \$416 VGND \$348 VGND sky130_fd_sc_hd__nand2_2
* cell instance $2522 r0 *1 154.56,27.2
X$2522 VPWR VPWR \$413 \$57 VGND \$49 VGND sky130_fd_sc_hd__nand2_2
* cell instance $2523 r0 *1 185.84,27.2
X$2523 VPWR VPWR \$439 \$430 VGND \$49 VGND sky130_fd_sc_hd__nand2_2
* cell instance $2524 r0 *1 181.24,10.88
X$2524 VPWR VPWR \$57 \$15 VGND \$35 VGND sky130_fd_sc_hd__nand2_2
* cell instance $2525 r0 *1 74.98,38.08
X$2525 VPWR VPWR \$831 \$782 VGND \$609 VGND sky130_fd_sc_hd__nand2_2
* cell instance $2526 r0 *1 76.36,108.8
X$2526 \$I280 VPWR \$1650 I VGND \$1729 VGND sky130_fd_sc_hd__nand2_2
* cell instance $2527 m90 *1 162.38,10.88
X$2527 VPWR VGND \$46 VPWR \$181 \$14 VGND sky130_fd_sc_hd__nor2_2
* cell instance $2528 r0 *1 157.78,10.88
X$2528 VPWR \$17 VPWR VGND \$14 \$94 VGND sky130_fd_sc_hd__or2_2
* cell instance $2529 m90 *1 164.68,10.88
X$2529 VPWR VPWR \$28 \$78 VGND \$27 VGND sky130_fd_sc_hd__nand2_2
* cell instance $2530 m90 *1 185.84,10.88
X$2530 VPWR \$16 VPWR VGND \$61 \$35 VGND sky130_fd_sc_hd__or2_2
* cell instance $2531 m90 *1 151.8,184.96
X$2531 VPWR \$2810 VPWR VGND \$2900 \$2752 VGND sky130_fd_sc_hd__or2_2
* cell instance $2532 m0 *1 183.08,48.96
X$2532 VPWR \$846 VPWR VGND \$392 \$572 VGND sky130_fd_sc_hd__or2_2
* cell instance $2533 m0 *1 80.96,114.24
X$2533 VPWR \$1783 VPWR VGND I \$1729 VGND sky130_fd_sc_hd__or2_2
* cell instance $2534 m0 *1 166.52,282.88
X$2534 VPWR \$4316 VPWR VGND \$3813 \$3159 VGND sky130_fd_sc_hd__or2_2
* cell instance $2535 r180 *1 167.9,206.72
X$2535 VPWR \$2910 VPWR VGND \$933 \$3048 VGND sky130_fd_sc_hd__or2_2
* cell instance $2536 r180 *1 158.7,21.76
X$2536 VPWR \$126 VPWR VGND \$247 \$347 VGND sky130_fd_sc_hd__or2_2
* cell instance $2537 r180 *1 186.3,16.32
X$2537 VPWR \$54 VPWR VGND \$14 \$35 VGND sky130_fd_sc_hd__or2_2
* cell instance $2538 r0 *1 164.22,168.64
X$2538 VPWR \$2592 VPWR VGND \$1362 \$1363 VGND sky130_fd_sc_hd__or2_2
* cell instance $2539 r0 *1 154.56,16.32
X$2539 VPWR \$61 VPWR VGND \$29 \$94 VGND sky130_fd_sc_hd__or2_2
* cell instance $2540 r0 *1 166.52,136
X$2540 \$I13343 \$2043 VPWR VGND \$1527 \$1362 VGND sky130_fd_sc_hd__or2_2
* cell instance $2541 r0 *1 186.3,38.08
X$2541 VPWR \$631 VPWR VGND \$311 \$115 VGND sky130_fd_sc_hd__or2_2
* cell instance $2542 m90 *1 154.56,38.08
X$2542 VPWR VGND \$664 VPWR \$606 \$665 VGND sky130_fd_sc_hd__nor2_2
* cell instance $2543 m90 *1 151.8,21.76
X$2543 VPWR VGND \$181 VPWR \$389 \$57 VGND sky130_fd_sc_hd__nor2_2
* cell instance $2544 m90 *1 123.74,233.92
X$2544 VPWR VGND \$3706 VPWR \$3694 \$3797 VGND sky130_fd_sc_hd__nor2_2
* cell instance $2545 m90 *1 115.92,87.04
X$2545 VPWR VGND \$1404 VPWR \$1516 \$1402 VGND sky130_fd_sc_hd__nor2_2
* cell instance $2546 m0 *1 155.48,32.64
X$2546 VPWR VGND \$416 VPWR \$874 \$556 VGND sky130_fd_sc_hd__nor2_2
* cell instance $2547 m0 *1 157.78,32.64
X$2547 VPWR VPWR VGND \$423 \$489 \$291 \$490 VGND sky130_fd_sc_hd__a21o_2
* cell instance $2548 m0 *1 25.76,157.76
X$2548 VPWR VGND \$1558 VPWR \$2492 \$2441 VGND sky130_fd_sc_hd__nor2_2
* cell instance $2549 m0 *1 159.16,174.08
X$2549 VPWR VGND \$1412 VPWR \$2640 \$2639 VGND sky130_fd_sc_hd__nor2_2
* cell instance $2550 m0 *1 186.3,16.32
X$2550 VPWR VGND \$31 VPWR \$115 \$61 VGND sky130_fd_sc_hd__nor2_2
* cell instance $2551 m0 *1 150.42,27.2
X$2551 VPWR VGND \$105 VPWR \$345 \$31 VGND sky130_fd_sc_hd__nor2_2
* cell instance $2552 m0 *1 172.04,103.36
X$2552 \$I1121 VGND \$1527 VPWR \$1757 \$1663 VGND sky130_fd_sc_hd__nor2_2
* cell instance $2553 m0 *1 167.44,54.4
X$2553 VPWR VGND \$1008 VPWR \$563 \$1058 VGND sky130_fd_sc_hd__nor2_2
* cell instance $2554 m0 *1 150.88,32.64
X$2554 VPWR VGND \$31 VPWR \$392 \$89 VGND sky130_fd_sc_hd__nor2_2
* cell instance $2555 m0 *1 169.74,157.76
X$2555 VPWR VGND \$1412 VPWR \$2498 \$1363 VGND sky130_fd_sc_hd__nor2_2
* cell instance $2556 m0 *1 157.78,16.32
X$2556 VPWR VGND \$47 VPWR \$14 \$29 VGND sky130_fd_sc_hd__nor2_2
* cell instance $2557 r180 *1 187.68,21.76
X$2557 VPWR VGND \$35 VPWR \$30 \$181 VGND sky130_fd_sc_hd__nor2_2
* cell instance $2558 r180 *1 113.16,201.28
X$2558 VPWR VGND \$3175 VPWR \$3173 \$3174 VGND sky130_fd_sc_hd__nor2_2
* cell instance $2559 r180 *1 161.92,27.2
X$2559 VPWR VGND \$416 VPWR \$351 \$417 VGND sky130_fd_sc_hd__nor2_2
* cell instance $2560 r180 *1 158.24,43.52
X$2560 VPWR VGND \$668 VPWR \$489 \$521 VGND sky130_fd_sc_hd__nor2_2
* cell instance $2561 r180 *1 153.18,184.96
X$2561 VPWR VGND \$1362 VPWR \$3042 \$1527 VGND sky130_fd_sc_hd__nor2_2
* cell instance $2562 r180 *1 157.32,195.84
X$2562 VPWR VGND \$3048 VPWR \$2834 \$933 VGND sky130_fd_sc_hd__nor2_2
* cell instance $2563 r180 *1 176.64,108.8
X$2563 \$I12478 VGND \$1363 VPWR \$1823 \$1527 VGND sky130_fd_sc_hd__nor2_2
* cell instance $2564 r180 *1 155.02,27.2
X$2564 VPWR VGND \$347 VPWR \$47 \$247 VGND sky130_fd_sc_hd__nor2_2
* cell instance $2565 r180 *1 159.62,27.2
X$2565 VPWR VGND \$340 VPWR \$247 \$348 VGND sky130_fd_sc_hd__nor2_2
* cell instance $2566 r180 *1 179.4,206.72
X$2566 VPWR VGND \$2666 VPWR \$3060 \$3229 VGND sky130_fd_sc_hd__nor2_2
* cell instance $2567 r180 *1 115.92,212.16
X$2567 VPWR VGND \$3292 VPWR \$3284 \$3387 VGND sky130_fd_sc_hd__nor2_2
* cell instance $2568 r180 *1 156.4,21.76
X$2568 VPWR VGND \$139 VPWR \$56 \$126 VGND sky130_fd_sc_hd__nor2_2
* cell instance $2569 r180 *1 153.18,190.4
X$2569 VPWR VGND \$1412 VPWR \$2594 \$1363 VGND sky130_fd_sc_hd__nor2_2
* cell instance $2570 r0 *1 114.08,266.56
X$2570 VPWR VGND \$4142 VPWR \$4173 \$4180 VGND sky130_fd_sc_hd__nor2_2
* cell instance $2571 r0 *1 166.52,168.64
X$2571 VPWR VGND \$1362 VPWR \$2689 \$2600 VGND sky130_fd_sc_hd__nor2_2
* cell instance $2572 r0 *1 168.82,54.4
X$2572 \$I13345 VGND \$1186 VPWR \$797 \$421 VGND sky130_fd_sc_hd__nor2_2
* cell instance $2573 r0 *1 29.9,92.48
X$2573 VPWR VGND \$348 VPWR \$1506 \$1532 VGND sky130_fd_sc_hd__nor2_2
* cell instance $2574 r0 *1 165.6,130.56
X$2574 VPWR VGND \$1527 VPWR \$2033 \$2029 VGND sky130_fd_sc_hd__nor2_2
* cell instance $2575 r0 *1 152.26,16.32
X$2575 VPWR VGND \$31 VPWR \$179 \$181 VGND sky130_fd_sc_hd__nor2_2
* cell instance $2576 r0 *1 165.6,92.48
X$2576 VPWR VGND \$1412 VPWR \$1467 \$1363 VGND sky130_fd_sc_hd__nor2_2
* cell instance $2577 r0 *1 162.84,212.16
X$2577 VPWR VGND \$3301 VPWR \$3467 \$3303 VGND sky130_fd_sc_hd__nor2_2
* cell instance $2578 r0 *1 159.16,16.32
X$2578 VPWR VGND \$46 VPWR \$151 \$97 VGND sky130_fd_sc_hd__nor2_2
* cell instance $2579 r180 *1 164.68,21.76
X$2579 VPWR VGND \$306 \$147 \$49 VPWR \$205 \$209 VGND sky130_fd_sc_hd__or4_2
* cell instance $2580 r0 *1 155.48,21.76
X$2580 VPWR VGND \$247 VPWR \$97 \$288 VGND sky130_fd_sc_hd__nor2_2
* cell instance $2581 r0 *1 123.74,136
X$2581 VPWR VGND \$2068 VPWR \$2072 \$2079 VGND sky130_fd_sc_hd__nor2_2
* cell instance $2582 r0 *1 74.98,48.96
X$2582 VPWR VGND \$836 VPWR \$1026 \$1083 VGND sky130_fd_sc_hd__nor2_2
* cell instance $2583 r0 *1 156.86,16.32
X$2583 VPWR VGND \$139 VPWR \$143 \$93 VGND sky130_fd_sc_hd__nor2_2
* cell instance $2584 r0 *1 109.02,70.72
X$2584 VPWR VGND \$1273 VPWR \$1223 \$1275 VGND sky130_fd_sc_hd__nor2_2
* cell instance $2585 r0 *1 184,174.08
X$2585 VPWR VGND \$2569 VPWR \$2667 \$2666 VGND sky130_fd_sc_hd__nor2_2
* cell instance $2586 r0 *1 121.44,65.28
X$2586 VPWR VGND \$1143 VPWR \$1227 \$1201 VGND sky130_fd_sc_hd__nor2_2
* cell instance $2587 r0 *1 165.14,255.68
X$2587 VPWR VGND \$737 VPWR \$3401 \$4041 VGND sky130_fd_sc_hd__nor2_2
* cell instance $2588 r0 *1 149.5,27.2
X$2588 VPWR VGND \$105 VPWR \$407 \$35 VGND sky130_fd_sc_hd__nor2_2
* cell instance $2589 r0 *1 158.7,43.52
X$2589 VPWR VGND \$791 VPWR \$1186 \$792 VGND sky130_fd_sc_hd__nor2_2
* cell instance $2590 r0 *1 185.84,10.88
X$2590 VPWR VGND \$35 VPWR \$65 \$58 VGND sky130_fd_sc_hd__nor2_2
* cell instance $2591 r0 *1 172.04,163.2
X$2591 \$I11849 VGND \$933 VPWR \$2579 \$2569 VGND sky130_fd_sc_hd__nor2_2
* cell instance $2592 r0 *1 164.68,10.88
X$2592 VPWR VGND sky130_fd_sc_hd__tapvpwrvgnd_1
* cell instance $2593 r0 *1 167.9,10.88
X$2593 VGND \$83 \$29 \$49 \$98 \$30 \$50 VPWR VPWR VGND
+ sky130_fd_sc_hd__a311o_2
* cell instance $2594 m90 *1 175.72,10.88
X$2594 VPWR VGND VPWR \$38 \$16 \$47 \$51 \$31 VGND sky130_fd_sc_hd__o22a_2
* cell instance $2595 m90 *1 177.1,10.88
X$2595 VPWR VGND VPWR \$37 \$17 VGND sky130_fd_sc_hd__inv_2
* cell instance $2596 r180 *1 171.12,16.32
X$2596 VGND \$82 \$120 \$72 \$49 VPWR VPWR VGND sky130_fd_sc_hd__mux2_1
* cell instance $2597 r180 *1 173.88,16.32
X$2597 VPWR \$35 \$46 \$100 VGND VPWR \$519 VGND sky130_fd_sc_hd__and3_2
* cell instance $2598 r180 *1 177.56,16.32
X$2598 VPWR \$105 VPWR \$35 VGND \$94 \$56 \$131 VGND sky130_fd_sc_hd__o211a_2
* cell instance $2599 m0 *1 177.56,16.32
X$2599 VPWR VPWR \$35 \$55 \$100 VGND \$58 VGND sky130_fd_sc_hd__a21oi_2
* cell instance $2600 m0 *1 180.78,16.32
X$2600 VPWR \$120 VPWR \$23 \$89 \$31 VGND \$100 VGND sky130_fd_sc_hd__a31o_2
* cell instance $2601 r0 *1 185.61,14.79
X$2601 \$14 VIA_M1M2_PR
* cell instance $2602 r0 *1 185.61,10.03
X$2602 \$14 VIA_M1M2_PR
* cell instance $2603 r0 *1 185.61,23.97
X$2603 \$14 VIA_M1M2_PR
* cell instance $2604 r0 *1 158.01,22.95
X$2604 \$14 VIA_M1M2_PR
* cell instance $2605 r0 *1 157.55,14.79
X$2605 \$14 VIA_M1M2_PR
* cell instance $2606 r0 *1 161.23,12.07
X$2606 \$14 VIA_M1M2_PR
* cell instance $2607 r0 *1 161.23,10.03
X$2607 \$14 VIA_M1M2_PR
* cell instance $2608 r0 *1 161.23,14.79
X$2608 \$14 VIA_M1M2_PR
* cell instance $2609 r0 *1 158.01,11.73
X$2609 \$14 VIA_L1M1_PR_MR
* cell instance $2610 r0 *1 186.07,15.47
X$2610 \$14 VIA_L1M1_PR_MR
* cell instance $2611 r0 *1 157.09,15.13
X$2611 \$14 VIA_L1M1_PR_MR
* cell instance $2612 r0 *1 161.23,12.07
X$2612 \$14 VIA_L1M1_PR_MR
* cell instance $2613 r0 *1 159.85,14.79
X$2613 \$14 VIA_L1M1_PR_MR
* cell instance $2614 r0 *1 158.01,22.95
X$2614 \$14 VIA_L1M1_PR_MR
* cell instance $2615 r0 *1 186.07,23.97
X$2615 \$14 VIA_L1M1_PR_MR
* cell instance $2616 r0 *1 175.49,22.1
X$2616 \$15 VIA_M2M3_PR
* cell instance $2617 r0 *1 172.27,22.1
X$2617 \$15 VIA_M2M3_PR
* cell instance $2618 r0 *1 156.17,22.1
X$2618 \$15 VIA_M2M3_PR
* cell instance $2619 r0 *1 172.27,33.15
X$2619 \$15 VIA_M1M2_PR
* cell instance $2620 r0 *1 181.93,12.07
X$2620 \$15 VIA_M1M2_PR
* cell instance $2621 r0 *1 177.79,9.69
X$2621 \$15 VIA_M1M2_PR
* cell instance $2622 r0 *1 181.93,9.69
X$2622 \$15 VIA_M1M2_PR
* cell instance $2623 r0 *1 175.49,22.61
X$2623 \$15 VIA_M1M2_PR
* cell instance $2624 r0 *1 177.79,22.61
X$2624 \$15 VIA_M1M2_PR
* cell instance $2625 r0 *1 156.17,14.79
X$2625 \$15 VIA_M1M2_PR
* cell instance $2626 r0 *1 181.93,12.07
X$2626 \$15 VIA_L1M1_PR_MR
* cell instance $2627 r0 *1 155.71,14.79
X$2627 \$15 VIA_L1M1_PR_MR
* cell instance $2628 r0 *1 175.49,22.61
X$2628 \$15 VIA_L1M1_PR_MR
* cell instance $2629 r0 *1 179.63,33.83
X$2629 \$15 VIA_L1M1_PR_MR
* cell instance $2630 r0 *1 183.77,17.51
X$2630 \$16 VIA_M1M2_PR
* cell instance $2631 r0 *1 183.77,11.73
X$2631 \$16 VIA_M1M2_PR
* cell instance $2632 r0 *1 183.77,10.37
X$2632 \$16 VIA_M1M2_PR
* cell instance $2633 r0 *1 183.31,20.23
X$2633 \$16 VIA_M1M2_PR
* cell instance $2634 r0 *1 174.11,10.37
X$2634 \$16 VIA_M1M2_PR
* cell instance $2635 r0 *1 174.11,12.07
X$2635 \$16 VIA_M1M2_PR
* cell instance $2636 r0 *1 181.93,20.23
X$2636 \$16 VIA_L1M1_PR_MR
* cell instance $2637 r0 *1 174.11,12.07
X$2637 \$16 VIA_L1M1_PR_MR
* cell instance $2638 r0 *1 183.31,17.51
X$2638 \$16 VIA_L1M1_PR_MR
* cell instance $2639 r0 *1 183.77,11.73
X$2639 \$16 VIA_L1M1_PR_MR
* cell instance $2640 r0 *1 175.49,9.69
X$2640 \$17 VIA_M1M2_PR
* cell instance $2641 r0 *1 175.03,22.61
X$2641 \$17 VIA_M1M2_PR
* cell instance $2642 r0 *1 175.03,16.83
X$2642 \$17 VIA_M1M2_PR
* cell instance $2643 r0 *1 175.49,12.07
X$2643 \$17 VIA_M1M2_PR
* cell instance $2644 r0 *1 160.31,11.73
X$2644 \$17 VIA_M1M2_PR
* cell instance $2645 r0 *1 160.77,17.85
X$2645 \$17 VIA_M1M2_PR
* cell instance $2646 r0 *1 160.77,9.69
X$2646 \$17 VIA_M1M2_PR
* cell instance $2647 r0 *1 159.85,11.73
X$2647 \$17 VIA_L1M1_PR_MR
* cell instance $2648 r0 *1 162.15,17.85
X$2648 \$17 VIA_L1M1_PR_MR
* cell instance $2649 r0 *1 185.15,17.51
X$2649 \$17 VIA_L1M1_PR_MR
* cell instance $2650 r0 *1 175.03,22.61
X$2650 \$17 VIA_L1M1_PR_MR
* cell instance $2651 r0 *1 176.87,12.07
X$2651 \$17 VIA_L1M1_PR_MR
* cell instance $2652 r0 *1 166.29,12.07
X$2652 \$23 VIA_M1M2_PR
* cell instance $2653 r0 *1 166.29,11.9
X$2653 \$23 VIA_M2M3_PR
* cell instance $2654 r0 *1 154.79,11.9
X$2654 \$23 VIA_M2M3_PR
* cell instance $2655 r0 *1 182.85,11.9
X$2655 \$23 VIA_M2M3_PR
* cell instance $2656 r0 *1 190.67,44.37
X$2656 \$23 VIA_M1M2_PR
* cell instance $2657 r0 *1 182.85,15.13
X$2657 \$23 VIA_M1M2_PR
* cell instance $2658 r0 *1 154.79,14.11
X$2658 \$23 VIA_M1M2_PR
* cell instance $2659 r0 *1 190.67,15.81
X$2659 \$23 VIA_M1M2_PR
* cell instance $2660 r0 *1 166.29,12.07
X$2660 \$23 VIA_L1M1_PR_MR
* cell instance $2661 r0 *1 181.93,15.13
X$2661 \$23 VIA_L1M1_PR_MR
* cell instance $2662 r0 *1 154.79,14.11
X$2662 \$23 VIA_L1M1_PR_MR
* cell instance $2663 r0 *1 186.53,44.37
X$2663 \$23 VIA_L1M1_PR_MR
* cell instance $2664 r0 *1 113.39,241.06
X$2664 \$27 VIA_M2M3_PR
* cell instance $2665 r0 *1 148.35,22.78
X$2665 \$27 VIA_M2M3_PR
* cell instance $2666 r0 *1 115.69,241.06
X$2666 \$27 VIA_M2M3_PR
* cell instance $2667 r0 *1 115.69,283.9
X$2667 \$27 VIA_M2M3_PR
* cell instance $2668 r0 *1 119.37,104.38
X$2668 \$27 VIA_M2M3_PR
* cell instance $2669 r0 *1 129.95,283.9
X$2669 \$27 VIA_M2M3_PR
* cell instance $2670 r0 *1 166.75,22.78
X$2670 \$27 VIA_M2M3_PR
* cell instance $2671 r0 *1 112.93,104.38
X$2671 \$27 VIA_M2M3_PR
* cell instance $2672 r0 *1 114.31,270.81
X$2672 \$27 VIA_M1M2_PR
* cell instance $2673 r0 *1 113.39,270.13
X$2673 \$27 VIA_M1M2_PR
* cell instance $2674 r0 *1 115.69,284.07
X$2674 \$27 VIA_M1M2_PR
* cell instance $2675 r0 *1 114.31,270.13
X$2675 \$27 VIA_M1M2_PR
* cell instance $2676 r0 *1 114.77,280.67
X$2676 \$27 VIA_M1M2_PR
* cell instance $2677 r0 *1 148.35,104.89
X$2677 \$27 VIA_M1M2_PR
* cell instance $2678 r0 *1 112.93,104.21
X$2678 \$27 VIA_M1M2_PR
* cell instance $2679 r0 *1 115.69,280.67
X$2679 \$27 VIA_M1M2_PR
* cell instance $2680 r0 *1 129.95,283.73
X$2680 \$27 VIA_M1M2_PR
* cell instance $2681 r0 *1 115.69,227.63
X$2681 \$27 VIA_M1M2_PR
* cell instance $2682 r0 *1 118.91,205.19
X$2682 \$27 VIA_M1M2_PR
* cell instance $2683 r0 *1 113.39,255.17
X$2683 \$27 VIA_M1M2_PR
* cell instance $2684 r0 *1 117.07,235.11
X$2684 \$27 VIA_M1M2_PR
* cell instance $2685 r0 *1 116.15,223.55
X$2685 \$27 VIA_M1M2_PR
* cell instance $2686 r0 *1 170.89,11.39
X$2686 \$27 VIA_M1M2_PR
* cell instance $2687 r0 *1 166.75,22.27
X$2687 \$27 VIA_M1M2_PR
* cell instance $2688 r0 *1 166.75,20.91
X$2688 \$27 VIA_M1M2_PR
* cell instance $2689 r0 *1 170.89,20.57
X$2689 \$27 VIA_M1M2_PR
* cell instance $2690 r0 *1 119.37,104.89
X$2690 \$27 VIA_M1M2_PR
* cell instance $2691 r0 *1 80.27,158.27
X$2691 \$27 VIA_M1M2_PR
* cell instance $2692 r0 *1 82.11,158.61
X$2692 \$27 VIA_M1M2_PR
* cell instance $2693 r0 *1 80.27,104.55
X$2693 \$27 VIA_M1M2_PR
* cell instance $2694 r0 *1 80.27,106.59
X$2694 \$27 VIA_M1M2_PR
* cell instance $2695 r0 *1 79.81,154.19
X$2695 \$27 VIA_M1M2_PR
* cell instance $2696 r0 *1 24.61,155.89
X$2696 \$27 VIA_M1M2_PR
* cell instance $2697 r0 *1 24.61,151.81
X$2697 \$27 VIA_M1M2_PR
* cell instance $2698 r0 *1 82.11,194.65
X$2698 \$27 VIA_M1M2_PR
* cell instance $2699 r0 *1 24.61,148.41
X$2699 \$27 VIA_M1M2_PR
* cell instance $2700 r0 *1 39.79,151.47
X$2700 \$27 VIA_M1M2_PR
* cell instance $2701 r0 *1 39.79,149.09
X$2701 \$27 VIA_M1M2_PR
* cell instance $2702 r0 *1 39.79,153.85
X$2702 \$27 VIA_M1M2_PR
* cell instance $2703 r0 *1 26.91,152.83
X$2703 \$27 VIA_M1M2_PR
* cell instance $2704 r0 *1 26.91,151.81
X$2704 \$27 VIA_M1M2_PR
* cell instance $2705 r0 *1 115.69,205.19
X$2705 \$27 VIA_M1M2_PR
* cell instance $2706 r0 *1 115.69,207.91
X$2706 \$27 VIA_M1M2_PR
* cell instance $2707 r0 *1 114.77,194.65
X$2707 \$27 VIA_M1M2_PR
* cell instance $2708 r0 *1 118.91,200.77
X$2708 \$27 VIA_M1M2_PR
* cell instance $2709 r0 *1 114.77,200.09
X$2709 \$27 VIA_M1M2_PR
* cell instance $2710 r0 *1 27.37,147.73
X$2710 \$27 VIA_L1M1_PR_MR
* cell instance $2711 r0 *1 27.37,148.41
X$2711 \$27 VIA_L1M1_PR_MR
* cell instance $2712 r0 *1 163.53,12.07
X$2712 \$27 VIA_L1M1_PR_MR
* cell instance $2713 r0 *1 166.75,22.27
X$2713 \$27 VIA_L1M1_PR_MR
* cell instance $2714 r0 *1 169.51,20.57
X$2714 \$27 VIA_L1M1_PR_MR
* cell instance $2715 r0 *1 39.79,149.09
X$2715 \$27 VIA_L1M1_PR_MR
* cell instance $2716 r0 *1 26.91,147.73
X$2716 \$27 VIA_L1M1_PR_MR
* cell instance $2717 r0 *1 26.91,152.83
X$2717 \$27 VIA_L1M1_PR_MR
* cell instance $2718 r0 *1 36.57,151.13
X$2718 \$27 VIA_L1M1_PR_MR
* cell instance $2719 r0 *1 30.13,156.57
X$2719 \$27 VIA_L1M1_PR_MR
* cell instance $2720 r0 *1 116.15,194.65
X$2720 \$27 VIA_L1M1_PR_MR
* cell instance $2721 r0 *1 115.69,200.09
X$2721 \$27 VIA_L1M1_PR_MR
* cell instance $2722 r0 *1 123.97,254.49
X$2722 \$27 VIA_L1M1_PR_MR
* cell instance $2723 r0 *1 117.07,223.55
X$2723 \$27 VIA_L1M1_PR_MR
* cell instance $2724 r0 *1 115.69,207.91
X$2724 \$27 VIA_L1M1_PR_MR
* cell instance $2725 r0 *1 117.07,235.11
X$2725 \$27 VIA_L1M1_PR_MR
* cell instance $2726 r0 *1 118.45,227.29
X$2726 \$27 VIA_L1M1_PR_MR
* cell instance $2727 r0 *1 126.73,254.15
X$2727 \$27 VIA_L1M1_PR_MR
* cell instance $2728 r0 *1 129.95,283.73
X$2728 \$27 VIA_L1M1_PR_MR
* cell instance $2729 r0 *1 80.27,106.59
X$2729 \$27 VIA_L1M1_PR_MR
* cell instance $2730 r0 *1 84.41,104.55
X$2730 \$27 VIA_L1M1_PR_MR
* cell instance $2731 r0 *1 115.69,284.07
X$2731 \$27 VIA_L1M1_PR_MR
* cell instance $2732 r0 *1 115.69,270.81
X$2732 \$27 VIA_L1M1_PR_MR
* cell instance $2733 r0 *1 166.75,12.75
X$2733 \$28 VIA_M1M2_PR
* cell instance $2734 r0 *1 169.51,22.95
X$2734 \$28 VIA_M1M2_PR
* cell instance $2735 r0 *1 169.51,22.95
X$2735 \$28 VIA_L1M1_PR_MR
* cell instance $2736 r0 *1 163.99,12.75
X$2736 \$28 VIA_L1M1_PR_MR
* cell instance $2737 r0 *1 161.23,22.27
X$2737 \$29 VIA_M1M2_PR
* cell instance $2738 r0 *1 154.33,28.39
X$2738 \$29 VIA_M1M2_PR
* cell instance $2739 r0 *1 159.39,20.57
X$2739 \$29 VIA_M1M2_PR
* cell instance $2740 r0 *1 159.39,13.09
X$2740 \$29 VIA_M1M2_PR
* cell instance $2741 r0 *1 161.23,20.57
X$2741 \$29 VIA_M1M2_PR
* cell instance $2742 r0 *1 159.39,15.13
X$2742 \$29 VIA_M1M2_PR
* cell instance $2743 r0 *1 154.33,17.17
X$2743 \$29 VIA_M1M2_PR
* cell instance $2744 r0 *1 159.39,16.83
X$2744 \$29 VIA_M1M2_PR
* cell instance $2745 r0 *1 154.79,17.17
X$2745 \$29 VIA_L1M1_PR_MR
* cell instance $2746 r0 *1 154.33,28.39
X$2746 \$29 VIA_L1M1_PR_MR
* cell instance $2747 r0 *1 159.39,15.13
X$2747 \$29 VIA_L1M1_PR_MR
* cell instance $2748 r0 *1 159.85,20.57
X$2748 \$29 VIA_L1M1_PR_MR
* cell instance $2749 r0 *1 169.51,12.07
X$2749 \$29 VIA_L1M1_PR_MR
* cell instance $2750 r0 *1 161.23,22.27
X$2750 \$29 VIA_L1M1_PR_MR
* cell instance $2751 r0 *1 184.46,33.66
X$2751 \$30 VIA_M3M4_PR
* cell instance $2752 r0 *1 184.46,49.98
X$2752 \$30 VIA_M3M4_PR
* cell instance $2753 r0 *1 184.46,19.38
X$2753 \$30 VIA_M3M4_PR
* cell instance $2754 r0 *1 184.46,31.62
X$2754 \$30 VIA_M3M4_PR
* cell instance $2755 r0 *1 179.63,49.98
X$2755 \$30 VIA_M2M3_PR
* cell instance $2756 r0 *1 184.69,19.38
X$2756 \$30 VIA_M2M3_PR
* cell instance $2757 r0 *1 184.69,33.66
X$2757 \$30 VIA_M2M3_PR
* cell instance $2758 r0 *1 163.99,31.62
X$2758 \$30 VIA_M2M3_PR
* cell instance $2759 r0 *1 173.19,14.62
X$2759 \$30 VIA_M2M3_PR
* cell instance $2760 r0 *1 176.41,14.62
X$2760 \$30 VIA_M2M3_PR
* cell instance $2761 r0 *1 179.63,50.15
X$2761 \$30 VIA_M1M2_PR
* cell instance $2762 r0 *1 184.69,33.15
X$2762 \$30 VIA_M1M2_PR
* cell instance $2763 r0 *1 179.63,17.51
X$2763 \$30 VIA_M1M2_PR
* cell instance $2764 r0 *1 184.69,19.55
X$2764 \$30 VIA_M1M2_PR
* cell instance $2765 r0 *1 176.41,17.51
X$2765 \$30 VIA_M1M2_PR
* cell instance $2766 r0 *1 179.63,19.55
X$2766 \$30 VIA_M1M2_PR
* cell instance $2767 r0 *1 176.41,18.53
X$2767 \$30 VIA_M1M2_PR
* cell instance $2768 r0 *1 176.41,19.55
X$2768 \$30 VIA_M1M2_PR
* cell instance $2769 r0 *1 176.41,22.95
X$2769 \$30 VIA_M1M2_PR
* cell instance $2770 r0 *1 163.99,31.79
X$2770 \$30 VIA_M1M2_PR
* cell instance $2771 r0 *1 173.19,12.75
X$2771 \$30 VIA_M1M2_PR
* cell instance $2772 r0 *1 163.07,31.45
X$2772 \$30 VIA_L1M1_PR_MR
* cell instance $2773 r0 *1 170.89,12.07
X$2773 \$30 VIA_L1M1_PR_MR
* cell instance $2774 r0 *1 186.07,19.89
X$2774 \$30 VIA_L1M1_PR_MR
* cell instance $2775 r0 *1 175.95,18.53
X$2775 \$30 VIA_L1M1_PR_MR
* cell instance $2776 r0 *1 176.21,22.95
X$2776 \$30 VIA_L1M1_PR_MR
* cell instance $2777 r0 *1 179.17,50.15
X$2777 \$30 VIA_L1M1_PR_MR
* cell instance $2778 r0 *1 184.69,33.15
X$2778 \$30 VIA_L1M1_PR_MR
* cell instance $2779 r0 *1 176.87,26.86
X$2779 \$31 VIA_M2M3_PR
* cell instance $2780 r0 *1 159.85,26.86
X$2780 \$31 VIA_M2M3_PR
* cell instance $2781 r0 *1 163.99,12.58
X$2781 \$31 VIA_M2M3_PR
* cell instance $2782 r0 *1 171.35,12.58
X$2782 \$31 VIA_M2M3_PR
* cell instance $2783 r0 *1 183.77,55.93
X$2783 \$31 VIA_M1M2_PR
* cell instance $2784 r0 *1 182.39,18.53
X$2784 \$31 VIA_M1M2_PR
* cell instance $2785 r0 *1 179.17,12.41
X$2785 \$31 VIA_M1M2_PR
* cell instance $2786 r0 *1 182.85,15.81
X$2786 \$31 VIA_M1M2_PR
* cell instance $2787 r0 *1 184.69,17.51
X$2787 \$31 VIA_M1M2_PR
* cell instance $2788 r0 *1 184.69,15.47
X$2788 \$31 VIA_M1M2_PR
* cell instance $2789 r0 *1 184.69,18.53
X$2789 \$31 VIA_M1M2_PR
* cell instance $2790 r0 *1 182.39,20.57
X$2790 \$31 VIA_M1M2_PR
* cell instance $2791 r0 *1 176.87,26.35
X$2791 \$31 VIA_M1M2_PR
* cell instance $2792 r0 *1 179.17,15.47
X$2792 \$31 VIA_M1M2_PR
* cell instance $2793 r0 *1 182.39,22.27
X$2793 \$31 VIA_M1M2_PR
* cell instance $2794 r0 *1 183.77,28.73
X$2794 \$31 VIA_M1M2_PR
* cell instance $2795 r0 *1 176.87,28.73
X$2795 \$31 VIA_M1M2_PR
* cell instance $2796 r0 *1 151.57,25.33
X$2796 \$31 VIA_M1M2_PR
* cell instance $2797 r0 *1 159.85,28.39
X$2797 \$31 VIA_M1M2_PR
* cell instance $2798 r0 *1 151.57,17.85
X$2798 \$31 VIA_M1M2_PR
* cell instance $2799 r0 *1 171.35,11.73
X$2799 \$31 VIA_M1M2_PR
* cell instance $2800 r0 *1 163.99,17.85
X$2800 \$31 VIA_M1M2_PR
* cell instance $2801 r0 *1 148.81,31.45
X$2801 \$31 VIA_M1M2_PR
* cell instance $2802 r0 *1 148.81,25.67
X$2802 \$31 VIA_M1M2_PR
* cell instance $2803 r0 *1 181.01,22.95
X$2803 \$31 VIA_L1M1_PR_MR
* cell instance $2804 r0 *1 163.07,17.85
X$2804 \$31 VIA_L1M1_PR_MR
* cell instance $2805 r0 *1 182.39,20.57
X$2805 \$31 VIA_L1M1_PR_MR
* cell instance $2806 r0 *1 185.15,18.53
X$2806 \$31 VIA_L1M1_PR_MR
* cell instance $2807 r0 *1 152.95,17.51
X$2807 \$31 VIA_L1M1_PR_MR
* cell instance $2808 r0 *1 151.11,31.45
X$2808 \$31 VIA_L1M1_PR_MR
* cell instance $2809 r0 *1 151.57,26.01
X$2809 \$31 VIA_L1M1_PR_MR
* cell instance $2810 r0 *1 172.27,12.07
X$2810 \$31 VIA_L1M1_PR_MR
* cell instance $2811 r0 *1 160.31,28.39
X$2811 \$31 VIA_L1M1_PR_MR
* cell instance $2812 r0 *1 184.69,17.51
X$2812 \$31 VIA_L1M1_PR_MR
* cell instance $2813 r0 *1 182.85,15.81
X$2813 \$31 VIA_L1M1_PR_MR
* cell instance $2814 r0 *1 186.53,15.13
X$2814 \$31 VIA_L1M1_PR_MR
* cell instance $2815 r0 *1 175.49,26.35
X$2815 \$31 VIA_L1M1_PR_MR
* cell instance $2816 r0 *1 179.17,28.73
X$2816 \$31 VIA_L1M1_PR_MR
* cell instance $2817 r0 *1 176.87,55.93
X$2817 \$31 VIA_L1M1_PR_MR
* cell instance $2818 r0 *1 151.11,28.22
X$2818 \$35 VIA_M2M3_PR
* cell instance $2819 r0 *1 183.31,22.78
X$2819 \$35 VIA_M2M3_PR
* cell instance $2820 r0 *1 174.11,22.78
X$2820 \$35 VIA_M2M3_PR
* cell instance $2821 r0 *1 174.11,28.22
X$2821 \$35 VIA_M2M3_PR
* cell instance $2822 r0 *1 173.19,16.66
X$2822 \$35 VIA_M2M3_PR
* cell instance $2823 r0 *1 176.87,16.66
X$2823 \$35 VIA_M2M3_PR
* cell instance $2824 r0 *1 186.07,44.37
X$2824 \$35 VIA_M1M2_PR
* cell instance $2825 r0 *1 174.11,33.83
X$2825 \$35 VIA_M1M2_PR
* cell instance $2826 r0 *1 185.61,33.15
X$2826 \$35 VIA_M1M2_PR
* cell instance $2827 r0 *1 186.07,14.11
X$2827 \$35 VIA_M1M2_PR
* cell instance $2828 r0 *1 183.31,20.91
X$2828 \$35 VIA_M1M2_PR
* cell instance $2829 r0 *1 176.87,15.13
X$2829 \$35 VIA_M1M2_PR
* cell instance $2830 r0 *1 186.07,12.07
X$2830 \$35 VIA_M1M2_PR
* cell instance $2831 r0 *1 186.07,20.91
X$2831 \$35 VIA_M1M2_PR
* cell instance $2832 r0 *1 174.11,22.95
X$2832 \$35 VIA_M1M2_PR
* cell instance $2833 r0 *1 185.61,25.33
X$2833 \$35 VIA_M1M2_PR
* cell instance $2834 r0 *1 183.31,26.01
X$2834 \$35 VIA_M1M2_PR
* cell instance $2835 r0 *1 185.61,31.79
X$2835 \$35 VIA_M1M2_PR
* cell instance $2836 r0 *1 185.61,28.39
X$2836 \$35 VIA_M1M2_PR
* cell instance $2837 r0 *1 183.31,25.33
X$2837 \$35 VIA_M1M2_PR
* cell instance $2838 r0 *1 151.11,28.39
X$2838 \$35 VIA_M1M2_PR
* cell instance $2839 r0 *1 173.19,20.91
X$2839 \$35 VIA_M1M2_PR
* cell instance $2840 r0 *1 173.19,15.47
X$2840 \$35 VIA_M1M2_PR
* cell instance $2841 r0 *1 174.11,20.91
X$2841 \$35 VIA_M1M2_PR
* cell instance $2842 r0 *1 174.11,22.95
X$2842 \$35 VIA_L1M1_PR_MR
* cell instance $2843 r0 *1 186.99,20.57
X$2843 \$35 VIA_L1M1_PR_MR
* cell instance $2844 r0 *1 151.11,28.39
X$2844 \$35 VIA_L1M1_PR_MR
* cell instance $2845 r0 *1 173.65,15.47
X$2845 \$35 VIA_L1M1_PR_MR
* cell instance $2846 r0 *1 185.61,28.39
X$2846 \$35 VIA_L1M1_PR_MR
* cell instance $2847 r0 *1 182.85,31.79
X$2847 \$35 VIA_L1M1_PR_MR
* cell instance $2848 r0 *1 184.69,31.45
X$2848 \$35 VIA_L1M1_PR_MR
* cell instance $2849 r0 *1 183.31,26.01
X$2849 \$35 VIA_L1M1_PR_MR
* cell instance $2850 r0 *1 182.85,12.07
X$2850 \$35 VIA_L1M1_PR_MR
* cell instance $2851 r0 *1 184.69,11.73
X$2851 \$35 VIA_L1M1_PR_MR
* cell instance $2852 r0 *1 186.07,12.07
X$2852 \$35 VIA_L1M1_PR_MR
* cell instance $2853 r0 *1 185.15,15.13
X$2853 \$35 VIA_L1M1_PR_MR
* cell instance $2854 r0 *1 176.41,15.13
X$2854 \$35 VIA_L1M1_PR_MR
* cell instance $2855 r0 *1 178.71,15.13
X$2855 \$35 VIA_L1M1_PR_MR
* cell instance $2856 r0 *1 185.61,44.37
X$2856 \$35 VIA_L1M1_PR_MR
* cell instance $2857 r0 *1 185.15,33.15
X$2857 \$35 VIA_L1M1_PR_MR
* cell instance $2858 r0 *1 178.71,33.83
X$2858 \$35 VIA_L1M1_PR_MR
* cell instance $2859 r0 *1 183.77,26.18
X$2859 \$37 VIA_M2M3_PR
* cell instance $2860 r0 *1 191.13,26.18
X$2860 \$37 VIA_M2M3_PR
* cell instance $2861 r0 *1 191.13,55.59
X$2861 \$37 VIA_M1M2_PR
* cell instance $2862 r0 *1 183.77,25.67
X$2862 \$37 VIA_M1M2_PR
* cell instance $2863 r0 *1 191.13,11.39
X$2863 \$37 VIA_M1M2_PR
* cell instance $2864 r0 *1 181.93,26.01
X$2864 \$37 VIA_L1M1_PR_MR
* cell instance $2865 r0 *1 176.41,11.39
X$2865 \$37 VIA_L1M1_PR_MR
* cell instance $2866 r0 *1 175.95,55.59
X$2866 \$37 VIA_L1M1_PR_MR
* cell instance $2867 r0 *1 181.47,11.73
X$2867 \$38 VIA_M1M2_PR
* cell instance $2868 r0 *1 181.47,20.23
X$2868 \$38 VIA_M1M2_PR
* cell instance $2869 r0 *1 180.465,20.23
X$2869 \$38 VIA_L1M1_PR_MR
* cell instance $2870 r0 *1 175.03,11.73
X$2870 \$38 VIA_L1M1_PR_MR
* cell instance $2871 r0 *1 181.01,20.57
X$2871 \$46 VIA_M1M2_PR
* cell instance $2872 r0 *1 181.01,17.85
X$2872 \$46 VIA_M1M2_PR
* cell instance $2873 r0 *1 158.47,23.97
X$2873 \$46 VIA_M1M2_PR
* cell instance $2874 r0 *1 159.85,14.11
X$2874 \$46 VIA_M1M2_PR
* cell instance $2875 r0 *1 159.85,17.17
X$2875 \$46 VIA_M1M2_PR
* cell instance $2876 r0 *1 158.47,17.51
X$2876 \$46 VIA_M1M2_PR
* cell instance $2877 r0 *1 162.15,14.45
X$2877 \$46 VIA_M1M2_PR
* cell instance $2878 r0 *1 162.15,12.07
X$2878 \$46 VIA_M1M2_PR
* cell instance $2879 r0 *1 174.57,14.11
X$2879 \$46 VIA_M1M2_PR
* cell instance $2880 r0 *1 174.57,18.19
X$2880 \$46 VIA_M1M2_PR
* cell instance $2881 r0 *1 155.25,15.13
X$2881 \$46 VIA_L1M1_PR_MR
* cell instance $2882 r0 *1 156.63,15.13
X$2882 \$46 VIA_L1M1_PR_MR
* cell instance $2883 r0 *1 162.15,12.07
X$2883 \$46 VIA_L1M1_PR_MR
* cell instance $2884 r0 *1 159.39,17.51
X$2884 \$46 VIA_L1M1_PR_MR
* cell instance $2885 r0 *1 172.73,14.11
X$2885 \$46 VIA_L1M1_PR_MR
* cell instance $2886 r0 *1 158.47,23.97
X$2886 \$46 VIA_L1M1_PR_MR
* cell instance $2887 r0 *1 178.71,17.85
X$2887 \$46 VIA_L1M1_PR_MR
* cell instance $2888 r0 *1 177.79,20.91
X$2888 \$46 VIA_L1M1_PR_MR
* cell instance $2889 r0 *1 158.47,13.94
X$2889 \$47 VIA_M2M3_PR
* cell instance $2890 r0 *1 173.65,13.94
X$2890 \$47 VIA_M2M3_PR
* cell instance $2891 r0 *1 153.41,25.33
X$2891 \$47 VIA_M1M2_PR
* cell instance $2892 r0 *1 158.47,15.13
X$2892 \$47 VIA_M1M2_PR
* cell instance $2893 r0 *1 153.41,15.47
X$2893 \$47 VIA_M1M2_PR
* cell instance $2894 r0 *1 173.65,12.07
X$2894 \$47 VIA_M1M2_PR
* cell instance $2895 r0 *1 153.41,25.33
X$2895 \$47 VIA_L1M1_PR_MR
* cell instance $2896 r0 *1 158.01,15.13
X$2896 \$47 VIA_L1M1_PR_MR
* cell instance $2897 r0 *1 173.65,12.07
X$2897 \$47 VIA_L1M1_PR_MR
* cell instance $2898 r0 *1 163.07,35.7
X$2898 \$49 VIA_M2M3_PR
* cell instance $2899 r0 *1 175.03,44.54
X$2899 \$49 VIA_M2M3_PR
* cell instance $2900 r0 *1 185.15,44.54
X$2900 \$49 VIA_M2M3_PR
* cell instance $2901 r0 *1 181.93,44.54
X$2901 \$49 VIA_M2M3_PR
* cell instance $2902 r0 *1 168.59,18.02
X$2902 \$49 VIA_M2M3_PR
* cell instance $2903 r0 *1 175.95,18.02
X$2903 \$49 VIA_M2M3_PR
* cell instance $2904 r0 *1 174.57,35.7
X$2904 \$49 VIA_M2M3_PR
* cell instance $2905 r0 *1 180.55,18.02
X$2905 \$49 VIA_M2M3_PR
* cell instance $2906 r0 *1 185.15,44.71
X$2906 \$49 VIA_M1M2_PR
* cell instance $2907 r0 *1 181.93,49.81
X$2907 \$49 VIA_M1M2_PR
* cell instance $2908 r0 *1 175.03,35.87
X$2908 \$49 VIA_M1M2_PR
* cell instance $2909 r0 *1 175.03,44.03
X$2909 \$49 VIA_M1M2_PR
* cell instance $2910 r0 *1 163.07,36.89
X$2910 \$49 VIA_M1M2_PR
* cell instance $2911 r0 *1 163.07,34.51
X$2911 \$49 VIA_M1M2_PR
* cell instance $2912 r0 *1 181.93,55.25
X$2912 \$49 VIA_M1M2_PR
* cell instance $2913 r0 *1 181.93,37.57
X$2913 \$49 VIA_M1M2_PR
* cell instance $2914 r0 *1 181.93,39.61
X$2914 \$49 VIA_M1M2_PR
* cell instance $2915 r0 *1 181.93,41.99
X$2915 \$49 VIA_M1M2_PR
* cell instance $2916 r0 *1 168.59,12.41
X$2916 \$49 VIA_M1M2_PR
* cell instance $2917 r0 *1 168.59,17.85
X$2917 \$49 VIA_M1M2_PR
* cell instance $2918 r0 *1 181.93,30.43
X$2918 \$49 VIA_M1M2_PR
* cell instance $2919 r0 *1 181.93,31.11
X$2919 \$49 VIA_M1M2_PR
* cell instance $2920 r0 *1 186.07,29.07
X$2920 \$49 VIA_M1M2_PR
* cell instance $2921 r0 *1 181.01,21.25
X$2921 \$49 VIA_M1M2_PR
* cell instance $2922 r0 *1 182.39,24.99
X$2922 \$49 VIA_M1M2_PR
* cell instance $2923 r0 *1 186.07,30.43
X$2923 \$49 VIA_M1M2_PR
* cell instance $2924 r0 *1 175.95,17.51
X$2924 \$49 VIA_M1M2_PR
* cell instance $2925 r0 *1 182.39,26.35
X$2925 \$49 VIA_M1M2_PR
* cell instance $2926 r0 *1 175.49,31.11
X$2926 \$49 VIA_M1M2_PR
* cell instance $2927 r0 *1 162.15,26.01
X$2927 \$49 VIA_M1M2_PR
* cell instance $2928 r0 *1 162.15,28.39
X$2928 \$49 VIA_M1M2_PR
* cell instance $2929 r0 *1 168.13,14.79
X$2929 \$49 VIA_M1M2_PR
* cell instance $2930 r0 *1 163.53,26.01
X$2930 \$49 VIA_M1M2_PR
* cell instance $2931 r0 *1 164.45,20.23
X$2931 \$49 VIA_M1M2_PR
* cell instance $2932 r0 *1 163.53,20.91
X$2932 \$49 VIA_M1M2_PR
* cell instance $2933 r0 *1 164.45,17.85
X$2933 \$49 VIA_M1M2_PR
* cell instance $2934 r0 *1 181.01,21.25
X$2934 \$49 VIA_L1M1_PR_MR
* cell instance $2935 r0 *1 168.13,14.79
X$2935 \$49 VIA_L1M1_PR_MR
* cell instance $2936 r0 *1 163.07,20.57
X$2936 \$49 VIA_L1M1_PR_MR
* cell instance $2937 r0 *1 163.99,26.01
X$2937 \$49 VIA_L1M1_PR_MR
* cell instance $2938 r0 *1 169.97,12.07
X$2938 \$49 VIA_L1M1_PR_MR
* cell instance $2939 r0 *1 166.29,17.51
X$2939 \$49 VIA_L1M1_PR_MR
* cell instance $2940 r0 *1 162.095,28.39
X$2940 \$49 VIA_L1M1_PR_MR
* cell instance $2941 r0 *1 156.17,28.39
X$2941 \$49 VIA_L1M1_PR_MR
* cell instance $2942 r0 *1 186.99,28.39
X$2942 \$49 VIA_L1M1_PR_MR
* cell instance $2943 r0 *1 185.61,26.01
X$2943 \$49 VIA_L1M1_PR_MR
* cell instance $2944 r0 *1 183.31,31.45
X$2944 \$49 VIA_L1M1_PR_MR
* cell instance $2945 r0 *1 175.95,17.51
X$2945 \$49 VIA_L1M1_PR_MR
* cell instance $2946 r0 *1 180.09,26.35
X$2946 \$49 VIA_L1M1_PR_MR
* cell instance $2947 r0 *1 176.41,31.11
X$2947 \$49 VIA_L1M1_PR_MR
* cell instance $2948 r0 *1 163.07,36.89
X$2948 \$49 VIA_L1M1_PR_MR
* cell instance $2949 r0 *1 185.15,44.71
X$2949 \$49 VIA_L1M1_PR_MR
* cell instance $2950 r0 *1 163.99,34.51
X$2950 \$49 VIA_L1M1_PR_MR
* cell instance $2951 r0 *1 174.11,55.25
X$2951 \$49 VIA_L1M1_PR_MR
* cell instance $2952 r0 *1 175.49,44.37
X$2952 \$49 VIA_L1M1_PR_MR
* cell instance $2953 r0 *1 177.79,36.55
X$2953 \$49 VIA_L1M1_PR_MR
* cell instance $2954 r0 *1 178.25,49.81
X$2954 \$49 VIA_L1M1_PR_MR
* cell instance $2955 r0 *1 183.77,36.89
X$2955 \$49 VIA_L1M1_PR_MR
* cell instance $2956 r0 *1 183.31,39.61
X$2956 \$49 VIA_L1M1_PR_MR
* cell instance $2957 r0 *1 179.63,41.99
X$2957 \$49 VIA_L1M1_PR_MR
* cell instance $2958 r0 *1 174.34,13.26
X$2958 \$50 VIA_M3M4_PR
* cell instance $2959 r0 *1 174.34,39.78
X$2959 \$50 VIA_M3M4_PR
* cell instance $2960 r0 *1 188.37,39.78
X$2960 \$50 VIA_M2M3_PR
* cell instance $2961 r0 *1 171.81,13.26
X$2961 \$50 VIA_M2M3_PR
* cell instance $2962 r0 *1 188.37,50.15
X$2962 \$50 VIA_M1M2_PR
* cell instance $2963 r0 *1 188.37,44.03
X$2963 \$50 VIA_M1M2_PR
* cell instance $2964 r0 *1 171.81,12.07
X$2964 \$50 VIA_M1M2_PR
* cell instance $2965 r0 *1 171.81,12.07
X$2965 \$50 VIA_L1M1_PR_MR
* cell instance $2966 r0 *1 187.45,44.03
X$2966 \$50 VIA_L1M1_PR_MR
* cell instance $2967 r0 *1 180.09,50.15
X$2967 \$50 VIA_L1M1_PR_MR
* cell instance $2968 r0 *1 172.73,12.58
X$2968 \$51 VIA_M2M3_PR
* cell instance $2969 r0 *1 186.53,12.58
X$2969 \$51 VIA_M2M3_PR
* cell instance $2970 r0 *1 188.83,34.17
X$2970 \$51 VIA_M1M2_PR
* cell instance $2971 r0 *1 172.73,12.41
X$2971 \$51 VIA_M1M2_PR
* cell instance $2972 r0 *1 187.45,23.29
X$2972 \$51 VIA_M1M2_PR
* cell instance $2973 r0 *1 188.83,23.29
X$2973 \$51 VIA_M1M2_PR
* cell instance $2974 r0 *1 172.73,12.41
X$2974 \$51 VIA_L1M1_PR_MR
* cell instance $2975 r0 *1 185.15,23.29
X$2975 \$51 VIA_L1M1_PR_MR
* cell instance $2976 r0 *1 186.07,34.17
X$2976 \$51 VIA_L1M1_PR_MR
* cell instance $2977 r0 *1 179.63,12.41
X$2977 \$54 VIA_M1M2_PR
* cell instance $2978 r0 *1 177.33,17.85
X$2978 \$54 VIA_M1M2_PR
* cell instance $2979 r0 *1 179.63,14.45
X$2979 \$54 VIA_M1M2_PR
* cell instance $2980 r0 *1 177.33,14.45
X$2980 \$54 VIA_M1M2_PR
* cell instance $2981 r0 *1 179.63,12.41
X$2981 \$54 VIA_L1M1_PR_MR
* cell instance $2982 r0 *1 184.23,14.45
X$2982 \$54 VIA_L1M1_PR_MR
* cell instance $2983 r0 *1 178.25,17.85
X$2983 \$54 VIA_L1M1_PR_MR
* cell instance $2984 r0 *1 182.62,13.26
X$2984 \$55 VIA_M3M4_PR
* cell instance $2985 r0 *1 182.62,28.22
X$2985 \$55 VIA_M3M4_PR
* cell instance $2986 r0 *1 183.31,28.22
X$2986 \$55 VIA_M2M3_PR
* cell instance $2987 r0 *1 180.09,13.26
X$2987 \$55 VIA_M2M3_PR
* cell instance $2988 r0 *1 183.31,36.21
X$2988 \$55 VIA_M1M2_PR
* cell instance $2989 r0 *1 180.09,14.79
X$2989 \$55 VIA_M1M2_PR
* cell instance $2990 r0 *1 180.09,14.79
X$2990 \$55 VIA_L1M1_PR_MR
* cell instance $2991 r0 *1 182.85,36.55
X$2991 \$55 VIA_L1M1_PR_MR
* cell instance $2992 r0 *1 162.61,17.34
X$2992 \$56 VIA_M2M3_PR
* cell instance $2993 r0 *1 172.73,17.34
X$2993 \$56 VIA_M2M3_PR
* cell instance $2994 r0 *1 174.11,17.34
X$2994 \$56 VIA_M2M3_PR
* cell instance $2995 r0 *1 172.73,23.63
X$2995 \$56 VIA_M1M2_PR
* cell instance $2996 r0 *1 154.79,22.95
X$2996 \$56 VIA_M1M2_PR
* cell instance $2997 r0 *1 154.79,21.25
X$2997 \$56 VIA_M1M2_PR
* cell instance $2998 r0 *1 174.11,12.75
X$2998 \$56 VIA_M1M2_PR
* cell instance $2999 r0 *1 162.61,20.91
X$2999 \$56 VIA_M1M2_PR
* cell instance $3000 r0 *1 162.61,17.51
X$3000 \$56 VIA_M1M2_PR
* cell instance $3001 r0 *1 174.11,15.13
X$3001 \$56 VIA_M1M2_PR
* cell instance $3002 r0 *1 188.83,22.61
X$3002 \$56 VIA_M1M2_PR
* cell instance $3003 r0 *1 188.83,17.85
X$3003 \$56 VIA_M1M2_PR
* cell instance $3004 r0 *1 186.53,22.95
X$3004 \$56 VIA_L1M1_PR_MR
* cell instance $3005 r0 *1 181.01,12.07
X$3005 \$56 VIA_L1M1_PR_MR
* cell instance $3006 r0 *1 185.61,17.85
X$3006 \$56 VIA_L1M1_PR_MR
* cell instance $3007 r0 *1 154.79,21.25
X$3007 \$56 VIA_L1M1_PR_MR
* cell instance $3008 r0 *1 154.79,22.95
X$3008 \$56 VIA_L1M1_PR_MR
* cell instance $3009 r0 *1 161.69,17.51
X$3009 \$56 VIA_L1M1_PR_MR
* cell instance $3010 r0 *1 158.47,23.29
X$3010 \$56 VIA_L1M1_PR_MR
* cell instance $3011 r0 *1 181.47,22.95
X$3011 \$56 VIA_L1M1_PR_MR
* cell instance $3012 r0 *1 175.32,15.13
X$3012 \$56 VIA_L1M1_PR_MR
* cell instance $3013 r0 *1 152.03,20.74
X$3013 \$57 VIA_M2M3_PR
* cell instance $3014 r0 *1 181.93,20.74
X$3014 \$57 VIA_M2M3_PR
* cell instance $3015 r0 *1 181.93,13.09
X$3015 \$57 VIA_M1M2_PR
* cell instance $3016 r0 *1 181.93,20.91
X$3016 \$57 VIA_M1M2_PR
* cell instance $3017 r0 *1 152.03,23.29
X$3017 \$57 VIA_M1M2_PR
* cell instance $3018 r0 *1 152.03,28.05
X$3018 \$57 VIA_M1M2_PR
* cell instance $3019 r0 *1 181.93,13.09
X$3019 \$57 VIA_L1M1_PR_MR
* cell instance $3020 r0 *1 150.65,22.95
X$3020 \$57 VIA_L1M1_PR_MR
* cell instance $3021 r0 *1 154.79,28.39
X$3021 \$57 VIA_L1M1_PR_MR
* cell instance $3022 r0 *1 181.47,20.91
X$3022 \$57 VIA_L1M1_PR_MR
* cell instance $3023 r0 *1 180.55,12.75
X$3023 \$57 VIA_L1M1_PR_MR
* cell instance $3024 r0 *1 181.7,26.18
X$3024 \$58 VIA_M3M4_PR
* cell instance $3025 r0 *1 181.7,14.62
X$3025 \$58 VIA_M3M4_PR
* cell instance $3026 r0 *1 177.33,26.18
X$3026 \$58 VIA_M2M3_PR
* cell instance $3027 r0 *1 159.85,26.18
X$3027 \$58 VIA_M2M3_PR
* cell instance $3028 r0 *1 186.99,13.94
X$3028 \$58 VIA_M2M3_PR
* cell instance $3029 r0 *1 180.55,14.62
X$3029 \$58 VIA_M2M3_PR
* cell instance $3030 r0 *1 180.55,15.13
X$3030 \$58 VIA_M1M2_PR
* cell instance $3031 r0 *1 186.99,12.07
X$3031 \$58 VIA_M1M2_PR
* cell instance $3032 r0 *1 177.33,27.71
X$3032 \$58 VIA_M1M2_PR
* cell instance $3033 r0 *1 159.85,23.97
X$3033 \$58 VIA_M1M2_PR
* cell instance $3034 r0 *1 186.99,12.07
X$3034 \$58 VIA_L1M1_PR_MR
* cell instance $3035 r0 *1 159.85,23.97
X$3035 \$58 VIA_L1M1_PR_MR
* cell instance $3036 r0 *1 180.55,15.13
X$3036 \$58 VIA_L1M1_PR_MR
* cell instance $3037 r0 *1 180.09,27.71
X$3037 \$58 VIA_L1M1_PR_MR
* cell instance $3038 r0 *1 157.09,24.82
X$3038 \$61 VIA_M2M3_PR
* cell instance $3039 r0 *1 183.77,24.82
X$3039 \$61 VIA_M2M3_PR
* cell instance $3040 r0 *1 159.85,36.21
X$3040 \$61 VIA_M1M2_PR
* cell instance $3041 r0 *1 184.69,20.23
X$3041 \$61 VIA_M1M2_PR
* cell instance $3042 r0 *1 185.15,14.45
X$3042 \$61 VIA_M1M2_PR
* cell instance $3043 r0 *1 185.15,12.07
X$3043 \$61 VIA_M1M2_PR
* cell instance $3044 r0 *1 184.69,22.95
X$3044 \$61 VIA_M1M2_PR
* cell instance $3045 r0 *1 183.77,22.95
X$3045 \$61 VIA_M1M2_PR
* cell instance $3046 r0 *1 159.85,30.77
X$3046 \$61 VIA_M1M2_PR
* cell instance $3047 r0 *1 157.09,30.77
X$3047 \$61 VIA_M1M2_PR
* cell instance $3048 r0 *1 157.09,18.53
X$3048 \$61 VIA_M1M2_PR
* cell instance $3049 r0 *1 187.91,15.13
X$3049 \$61 VIA_L1M1_PR_MR
* cell instance $3050 r0 *1 183.77,20.23
X$3050 \$61 VIA_L1M1_PR_MR
* cell instance $3051 r0 *1 185.61,12.07
X$3051 \$61 VIA_L1M1_PR_MR
* cell instance $3052 r0 *1 156.17,18.53
X$3052 \$61 VIA_L1M1_PR_MR
* cell instance $3053 r0 *1 184.69,22.95
X$3053 \$61 VIA_L1M1_PR_MR
* cell instance $3054 r0 *1 162.61,36.89
X$3054 \$61 VIA_L1M1_PR_MR
* cell instance $3055 r0 *1 194.81,13.94
X$3055 O[7] VIA_M2M3_PR
* cell instance $3056 r0 *1 194.81,246.33
X$3056 O[7] VIA_M1M2_PR
* cell instance $3057 r0 *1 177.33,245.99
X$3057 O[7] VIA_L1M1_PR_MR
* cell instance $3058 r0 *1 189.75,41.31
X$3058 \$65 VIA_M1M2_PR
* cell instance $3059 r0 *1 189.75,12.41
X$3059 \$65 VIA_M1M2_PR
* cell instance $3060 r0 *1 187.91,12.41
X$3060 \$65 VIA_L1M1_PR_MR
* cell instance $3061 r0 *1 178.71,41.99
X$3061 \$65 VIA_L1M1_PR_MR
* cell instance $3062 r0 *1 172.27,15.13
X$3062 \$72 VIA_M1M2_PR
* cell instance $3063 r0 *1 172.27,13.09
X$3063 \$72 VIA_M1M2_PR
* cell instance $3064 r0 *1 169.05,15.13
X$3064 \$72 VIA_L1M1_PR_MR
* cell instance $3065 r0 *1 178.71,13.09
X$3065 \$72 VIA_L1M1_PR_MR
* cell instance $3066 r0 *1 167.21,28.05
X$3066 \$78 VIA_M1M2_PR
* cell instance $3067 r0 *1 167.21,22.27
X$3067 \$78 VIA_M1M2_PR
* cell instance $3068 r0 *1 165.83,12.07
X$3068 \$78 VIA_M1M2_PR
* cell instance $3069 r0 *1 167.21,20.57
X$3069 \$78 VIA_M1M2_PR
* cell instance $3070 r0 *1 165.83,20.57
X$3070 \$78 VIA_M1M2_PR
* cell instance $3071 r0 *1 167.67,28.05
X$3071 \$78 VIA_L1M1_PR_MR
* cell instance $3072 r0 *1 167.21,22.27
X$3072 \$78 VIA_L1M1_PR_MR
* cell instance $3073 r0 *1 168.13,20.57
X$3073 \$78 VIA_L1M1_PR_MR
* cell instance $3074 r0 *1 164.45,12.07
X$3074 \$78 VIA_L1M1_PR_MR
* cell instance $3075 r0 *1 169.97,29.07
X$3075 \$80 VIA_M1M2_PR
* cell instance $3076 r0 *1 185.15,31.45
X$3076 \$80 VIA_M1M2_PR
* cell instance $3077 r0 *1 185.15,29.07
X$3077 \$80 VIA_M1M2_PR
* cell instance $3078 r0 *1 169.97,14.11
X$3078 \$80 VIA_M1M2_PR
* cell instance $3079 r0 *1 163.07,14.11
X$3079 \$80 VIA_L1M1_PR_MR
* cell instance $3080 r0 *1 184.69,28.39
X$3080 \$80 VIA_L1M1_PR_MR
* cell instance $3081 r0 *1 185.15,31.45
X$3081 \$80 VIA_L1M1_PR_MR
* cell instance $3082 r0 *1 181.93,42.5
X$3082 \$82 VIA_M2M3_PR
* cell instance $3083 r0 *1 170.89,42.5
X$3083 \$82 VIA_M2M3_PR
* cell instance $3084 r0 *1 181.93,44.03
X$3084 \$82 VIA_M1M2_PR
* cell instance $3085 r0 *1 171.35,14.11
X$3085 \$82 VIA_M1M2_PR
* cell instance $3086 r0 *1 170.89,14.11
X$3086 \$82 VIA_L1M1_PR_MR
* cell instance $3087 r0 *1 180.55,44.03
X$3087 \$82 VIA_L1M1_PR_MR
* cell instance $3088 r0 *1 169.74,25.5
X$3088 \$83 VIA_M3M4_PR
* cell instance $3089 r0 *1 169.74,48.62
X$3089 \$83 VIA_M3M4_PR
* cell instance $3090 r0 *1 172.27,48.62
X$3090 \$83 VIA_M2M3_PR
* cell instance $3091 r0 *1 169.05,25.5
X$3091 \$83 VIA_M2M3_PR
* cell instance $3092 r0 *1 172.27,56.61
X$3092 \$83 VIA_M1M2_PR
* cell instance $3093 r0 *1 169.05,13.09
X$3093 \$83 VIA_M1M2_PR
* cell instance $3094 r0 *1 168.59,13.09
X$3094 \$83 VIA_L1M1_PR_MR
* cell instance $3095 r0 *1 172.27,56.61
X$3095 \$83 VIA_L1M1_PR_MR
* cell instance $3096 r0 *1 153.87,15.3
X$3096 \$89 VIA_M2M3_PR
* cell instance $3097 r0 *1 182.39,15.3
X$3097 \$89 VIA_M2M3_PR
* cell instance $3098 r0 *1 165.37,15.3
X$3098 \$89 VIA_M2M3_PR
* cell instance $3099 r0 *1 182.39,15.81
X$3099 \$89 VIA_M1M2_PR
* cell instance $3100 r0 *1 153.87,29.41
X$3100 \$89 VIA_M1M2_PR
* cell instance $3101 r0 *1 153.87,30.77
X$3101 \$89 VIA_M1M2_PR
* cell instance $3102 r0 *1 165.37,12.41
X$3102 \$89 VIA_M1M2_PR
* cell instance $3103 r0 *1 152.03,31.45
X$3103 \$89 VIA_L1M1_PR_MR
* cell instance $3104 r0 *1 153.87,29.41
X$3104 \$89 VIA_L1M1_PR_MR
* cell instance $3105 r0 *1 165.37,12.41
X$3105 \$89 VIA_L1M1_PR_MR
* cell instance $3106 r0 *1 182.39,15.81
X$3106 \$89 VIA_L1M1_PR_MR
* cell instance $3107 r0 *1 155.25,24.99
X$3107 \$93 VIA_M1M2_PR
* cell instance $3108 r0 *1 157.09,15.81
X$3108 \$93 VIA_M1M2_PR
* cell instance $3109 r0 *1 157.09,17.85
X$3109 \$93 VIA_M1M2_PR
* cell instance $3110 r0 *1 155.71,17.85
X$3110 \$93 VIA_M1M2_PR
* cell instance $3111 r0 *1 155.71,24.99
X$3111 \$93 VIA_L1M1_PR_MR
* cell instance $3112 r0 *1 158.01,17.51
X$3112 \$93 VIA_L1M1_PR_MR
* cell instance $3113 r0 *1 160.31,15.13
X$3113 \$93 VIA_L1M1_PR_MR
* cell instance $3114 r0 *1 158.93,15.98
X$3114 \$94 VIA_M2M3_PR
* cell instance $3115 r0 *1 175.49,15.98
X$3115 \$94 VIA_M2M3_PR
* cell instance $3116 r0 *1 175.95,15.24
X$3116 \$94 VIA_M1M2_PR
* cell instance $3117 r0 *1 174.57,23.29
X$3117 \$94 VIA_M1M2_PR
* cell instance $3118 r0 *1 175.49,17.85
X$3118 \$94 VIA_M1M2_PR
* cell instance $3119 r0 *1 158.93,17.17
X$3119 \$94 VIA_M1M2_PR
* cell instance $3120 r0 *1 158.93,12.07
X$3120 \$94 VIA_M1M2_PR
* cell instance $3121 r0 *1 174.11,17.85
X$3121 \$94 VIA_M1M2_PR
* cell instance $3122 r0 *1 155.71,17.17
X$3122 \$94 VIA_L1M1_PR_MR
* cell instance $3123 r0 *1 158.93,12.07
X$3123 \$94 VIA_L1M1_PR_MR
* cell instance $3124 r0 *1 174.11,17.85
X$3124 \$94 VIA_L1M1_PR_MR
* cell instance $3125 r0 *1 175.95,15.13
X$3125 \$94 VIA_L1M1_PR_MR
* cell instance $3126 r0 *1 179.63,22.95
X$3126 \$94 VIA_L1M1_PR_MR
* cell instance $3127 r0 *1 176.41,33.83
X$3127 \$97 VIA_M1M2_PR
* cell instance $3128 r0 *1 184.23,20.57
X$3128 \$97 VIA_M1M2_PR
* cell instance $3129 r0 *1 184.23,32.13
X$3129 \$97 VIA_M1M2_PR
* cell instance $3130 r0 *1 176.41,32.13
X$3130 \$97 VIA_M1M2_PR
* cell instance $3131 r0 *1 160.77,22.27
X$3131 \$97 VIA_M1M2_PR
* cell instance $3132 r0 *1 161.23,17.51
X$3132 \$97 VIA_M1M2_PR
* cell instance $3133 r0 *1 161.23,15.81
X$3133 \$97 VIA_M1M2_PR
* cell instance $3134 r0 *1 167.21,14.79
X$3134 \$97 VIA_M1M2_PR
* cell instance $3135 r0 *1 167.21,19.89
X$3135 \$97 VIA_M1M2_PR
* cell instance $3136 r0 *1 163.07,15.13
X$3136 \$97 VIA_L1M1_PR_MR
* cell instance $3137 r0 *1 182.85,19.89
X$3137 \$97 VIA_L1M1_PR_MR
* cell instance $3138 r0 *1 182.85,20.57
X$3138 \$97 VIA_L1M1_PR_MR
* cell instance $3139 r0 *1 160.31,17.51
X$3139 \$97 VIA_L1M1_PR_MR
* cell instance $3140 r0 *1 157.09,22.27
X$3140 \$97 VIA_L1M1_PR_MR
* cell instance $3141 r0 *1 176.41,33.83
X$3141 \$97 VIA_L1M1_PR_MR
* cell instance $3142 r0 *1 152.95,23.46
X$3142 \$98 VIA_M2M3_PR
* cell instance $3143 r0 *1 165.37,23.46
X$3143 \$98 VIA_M2M3_PR
* cell instance $3144 r0 *1 152.95,23.63
X$3144 \$98 VIA_M1M2_PR
* cell instance $3145 r0 *1 152.95,28.39
X$3145 \$98 VIA_M1M2_PR
* cell instance $3146 r0 *1 165.37,23.29
X$3146 \$98 VIA_M1M2_PR
* cell instance $3147 r0 *1 166.29,23.29
X$3147 \$98 VIA_M1M2_PR
* cell instance $3148 r0 *1 166.29,15.13
X$3148 \$98 VIA_M1M2_PR
* cell instance $3149 r0 *1 173.65,23.29
X$3149 \$98 VIA_M1M2_PR
* cell instance $3150 r0 *1 170.43,12.07
X$3150 \$98 VIA_M1M2_PR
* cell instance $3151 r0 *1 173.65,17.85
X$3151 \$98 VIA_M1M2_PR
* cell instance $3152 r0 *1 173.65,20.57
X$3152 \$98 VIA_M1M2_PR
* cell instance $3153 r0 *1 170.43,14.79
X$3153 \$98 VIA_M1M2_PR
* cell instance $3154 r0 *1 166.19,23.29
X$3154 \$98 VIA_L1M1_PR_MR
* cell instance $3155 r0 *1 163.99,15.13
X$3155 \$98 VIA_L1M1_PR_MR
* cell instance $3156 r0 *1 173.65,23.29
X$3156 \$98 VIA_L1M1_PR_MR
* cell instance $3157 r0 *1 152.95,28.39
X$3157 \$98 VIA_L1M1_PR_MR
* cell instance $3158 r0 *1 153.87,22.95
X$3158 \$98 VIA_L1M1_PR_MR
* cell instance $3159 r0 *1 170.43,12.07
X$3159 \$98 VIA_L1M1_PR_MR
* cell instance $3160 r0 *1 170.43,17.85
X$3160 \$98 VIA_L1M1_PR_MR
* cell instance $3161 r0 *1 173.65,20.57
X$3161 \$98 VIA_L1M1_PR_MR
* cell instance $3162 r0 *1 183.31,14.79
X$3162 \$100 VIA_M1M2_PR
* cell instance $3163 r0 *1 183.31,14.11
X$3163 \$100 VIA_M1M2_PR
* cell instance $3164 r0 *1 182.85,22.95
X$3164 \$100 VIA_M1M2_PR
* cell instance $3165 r0 *1 163.53,15.47
X$3165 \$100 VIA_M1M2_PR
* cell instance $3166 r0 *1 163.53,20.23
X$3166 \$100 VIA_M1M2_PR
* cell instance $3167 r0 *1 183.31,22.95
X$3167 \$100 VIA_L1M1_PR_MR
* cell instance $3168 r0 *1 160.77,20.23
X$3168 \$100 VIA_L1M1_PR_MR
* cell instance $3169 r0 *1 172.73,15.47
X$3169 \$100 VIA_L1M1_PR_MR
* cell instance $3170 r0 *1 177.79,14.79
X$3170 \$100 VIA_L1M1_PR_MR
* cell instance $3171 r0 *1 183.77,15.13
X$3171 \$100 VIA_L1M1_PR_MR
* cell instance $3172 r0 *1 178.25,15.13
X$3172 \$105 VIA_M1M2_PR
* cell instance $3173 r0 *1 178.71,22.61
X$3173 \$105 VIA_M1M2_PR
* cell instance $3174 r0 *1 151.11,23.97
X$3174 \$105 VIA_M1M2_PR
* cell instance $3175 r0 *1 151.11,26.01
X$3175 \$105 VIA_M1M2_PR
* cell instance $3176 r0 *1 151.57,28.05
X$3176 \$105 VIA_M1M2_PR
* cell instance $3177 r0 *1 160.31,22.61
X$3177 \$105 VIA_M1M2_PR
* cell instance $3178 r0 *1 159.39,23.63
X$3178 \$105 VIA_M1M2_PR
* cell instance $3179 r0 *1 154.79,23.63
X$3179 \$105 VIA_L1M1_PR_MR
* cell instance $3180 r0 *1 151.11,26.01
X$3180 \$105 VIA_L1M1_PR_MR
* cell instance $3181 r0 *1 150.19,28.39
X$3181 \$105 VIA_L1M1_PR_MR
* cell instance $3182 r0 *1 178.25,22.61
X$3182 \$105 VIA_L1M1_PR_MR
* cell instance $3183 r0 *1 177.33,15.13
X$3183 \$105 VIA_L1M1_PR_MR
* cell instance $3184 r0 *1 190.21,23.46
X$3184 \$115 VIA_M2M3_PR
* cell instance $3185 r0 *1 164.45,24.14
X$3185 \$115 VIA_M2M3_PR
* cell instance $3186 r0 *1 190.21,39.27
X$3186 \$115 VIA_M1M2_PR
* cell instance $3187 r0 *1 164.45,26.01
X$3187 \$115 VIA_M1M2_PR
* cell instance $3188 r0 *1 190.21,15.47
X$3188 \$115 VIA_M1M2_PR
* cell instance $3189 r0 *1 188.37,15.47
X$3189 \$115 VIA_L1M1_PR_MR
* cell instance $3190 r0 *1 164.45,26.01
X$3190 \$115 VIA_L1M1_PR_MR
* cell instance $3191 r0 *1 187.45,39.27
X$3191 \$115 VIA_L1M1_PR_MR
* cell instance $3192 r0 *1 168.59,15.81
X$3192 \$120 VIA_L1M1_PR_MR
* cell instance $3193 r0 *1 181.47,15.81
X$3193 \$120 VIA_L1M1_PR_MR
* cell instance $3194 r0 *1 154.79,19.89
X$3194 \$126 VIA_M1M2_PR
* cell instance $3195 r0 *1 154.79,20.57
X$3195 \$126 VIA_M1M2_PR
* cell instance $3196 r0 *1 154.79,15.13
X$3196 \$126 VIA_M1M2_PR
* cell instance $3197 r0 *1 154.79,20.57
X$3197 \$126 VIA_L1M1_PR_MR
* cell instance $3198 r0 *1 154.33,15.13
X$3198 \$126 VIA_L1M1_PR_MR
* cell instance $3199 r0 *1 156.63,19.89
X$3199 \$126 VIA_L1M1_PR_MR
* cell instance $3200 r0 *1 157.09,19.55
X$3200 \$126 VIA_L1M1_PR_MR
* cell instance $3201 r0 *1 158.93,20.23
X$3201 \$126 VIA_L1M1_PR_MR
* cell instance $3202 r0 *1 173.65,14.45
X$3202 \$131 VIA_M1M2_PR
* cell instance $3203 r0 *1 173.65,17.17
X$3203 \$131 VIA_M1M2_PR
* cell instance $3204 r0 *1 174.11,14.45
X$3204 \$131 VIA_L1M1_PR_MR
* cell instance $3205 r0 *1 175.03,17.51
X$3205 \$131 VIA_L1M1_PR_MR
* cell instance $3206 r0 *1 161.69,18.02
X$3206 \$139 VIA_M2M3_PR
* cell instance $3207 r0 *1 157.55,18.02
X$3207 \$139 VIA_M2M3_PR
* cell instance $3208 r0 *1 161.69,19.89
X$3208 \$139 VIA_M1M2_PR
* cell instance $3209 r0 *1 157.55,19.89
X$3209 \$139 VIA_M1M2_PR
* cell instance $3210 r0 *1 161.69,15.13
X$3210 \$139 VIA_M1M2_PR
* cell instance $3211 r0 *1 157.55,17.51
X$3211 \$139 VIA_M1M2_PR
* cell instance $3212 r0 *1 157.55,17.51
X$3212 \$139 VIA_L1M1_PR_MR
* cell instance $3213 r0 *1 161.69,15.13
X$3213 \$139 VIA_L1M1_PR_MR
* cell instance $3214 r0 *1 166.29,20.23
X$3214 \$139 VIA_L1M1_PR_MR
* cell instance $3215 r0 *1 156.17,20.57
X$3215 \$139 VIA_L1M1_PR_MR
* cell instance $3216 r0 *1 159.85,18.7
X$3216 \$143 VIA_M2M3_PR
* cell instance $3217 r0 *1 172.27,18.7
X$3217 \$143 VIA_M2M3_PR
* cell instance $3218 r0 *1 159.85,22.95
X$3218 \$143 VIA_M1M2_PR
* cell instance $3219 r0 *1 159.85,17.85
X$3219 \$143 VIA_M1M2_PR
* cell instance $3220 r0 *1 172.27,17.51
X$3220 \$143 VIA_M1M2_PR
* cell instance $3221 r0 *1 172.27,20.57
X$3221 \$143 VIA_M1M2_PR
* cell instance $3222 r0 *1 163.53,22.95
X$3222 \$143 VIA_L1M1_PR_MR
* cell instance $3223 r0 *1 164.91,22.95
X$3223 \$143 VIA_L1M1_PR_MR
* cell instance $3224 r0 *1 158.93,17.85
X$3224 \$143 VIA_L1M1_PR_MR
* cell instance $3225 r0 *1 172.73,20.57
X$3225 \$143 VIA_L1M1_PR_MR
* cell instance $3226 r0 *1 163.99,32.98
X$3226 \$147 VIA_M2M3_PR
* cell instance $3227 r0 *1 163.07,32.98
X$3227 \$147 VIA_M2M3_PR
* cell instance $3228 r0 *1 165.83,32.98
X$3228 \$147 VIA_M2M3_PR
* cell instance $3229 r0 *1 175.95,32.98
X$3229 \$147 VIA_M2M3_PR
* cell instance $3230 r0 *1 175.95,34.17
X$3230 \$147 VIA_M1M2_PR
* cell instance $3231 r0 *1 165.83,36.55
X$3231 \$147 VIA_M1M2_PR
* cell instance $3232 r0 *1 168.13,41.99
X$3232 \$147 VIA_M1M2_PR
* cell instance $3233 r0 *1 163.99,33.83
X$3233 \$147 VIA_M1M2_PR
* cell instance $3234 r0 *1 169.05,41.99
X$3234 \$147 VIA_M1M2_PR
* cell instance $3235 r0 *1 185.61,34.85
X$3235 \$147 VIA_M1M2_PR
* cell instance $3236 r0 *1 185.61,36.55
X$3236 \$147 VIA_M1M2_PR
* cell instance $3237 r0 *1 175.95,34.85
X$3237 \$147 VIA_M1M2_PR
* cell instance $3238 r0 *1 169.05,54.91
X$3238 \$147 VIA_M1M2_PR
* cell instance $3239 r0 *1 168.13,36.21
X$3239 \$147 VIA_M1M2_PR
* cell instance $3240 r0 *1 163.53,31.45
X$3240 \$147 VIA_M1M2_PR
* cell instance $3241 r0 *1 163.07,19.55
X$3241 \$147 VIA_M1M2_PR
* cell instance $3242 r0 *1 163.07,17.17
X$3242 \$147 VIA_M1M2_PR
* cell instance $3243 r0 *1 163.07,19.55
X$3243 \$147 VIA_L1M1_PR_MR
* cell instance $3244 r0 *1 163.53,31.45
X$3244 \$147 VIA_L1M1_PR_MR
* cell instance $3245 r0 *1 164.91,17.51
X$3245 \$147 VIA_L1M1_PR_MR
* cell instance $3246 r0 *1 164.91,33.83
X$3246 \$147 VIA_L1M1_PR_MR
* cell instance $3247 r0 *1 164.45,36.89
X$3247 \$147 VIA_L1M1_PR_MR
* cell instance $3248 r0 *1 171.35,55.25
X$3248 \$147 VIA_L1M1_PR_MR
* cell instance $3249 r0 *1 185.61,36.55
X$3249 \$147 VIA_L1M1_PR_MR
* cell instance $3250 r0 *1 175.95,34.17
X$3250 \$147 VIA_L1M1_PR_MR
* cell instance $3251 r0 *1 165.825,17.495
X$3251 \$148 VIA_L1M1_PR_MR
* cell instance $3252 r0 *1 182.39,17.17
X$3252 \$148 VIA_L1M1_PR_MR
* cell instance $3253 r0 *1 167.9,18.02
X$3253 \$150 VIA_M3M4_PR
* cell instance $3254 r0 *1 167.9,55.42
X$3254 \$150 VIA_M3M4_PR
* cell instance $3255 r0 *1 168.13,55.42
X$3255 \$150 VIA_M2M3_PR
* cell instance $3256 r0 *1 166.75,18.02
X$3256 \$150 VIA_M2M3_PR
* cell instance $3257 r0 *1 168.13,55.93
X$3257 \$150 VIA_M1M2_PR
* cell instance $3258 r0 *1 166.75,17.85
X$3258 \$150 VIA_M1M2_PR
* cell instance $3259 r0 *1 166.75,17.85
X$3259 \$150 VIA_L1M1_PR_MR
* cell instance $3260 r0 *1 174.57,55.93
X$3260 \$150 VIA_L1M1_PR_MR
* cell instance $3261 r0 *1 186.07,26.35
X$3261 \$151 VIA_M1M2_PR
* cell instance $3262 r0 *1 186.07,22.95
X$3262 \$151 VIA_M1M2_PR
* cell instance $3263 r0 *1 167.67,26.69
X$3263 \$151 VIA_M1M2_PR
* cell instance $3264 r0 *1 167.67,16.83
X$3264 \$151 VIA_M1M2_PR
* cell instance $3265 r0 *1 167.67,17.51
X$3265 \$151 VIA_M1M2_PR
* cell instance $3266 r0 *1 167.67,17.51
X$3266 \$151 VIA_L1M1_PR_MR
* cell instance $3267 r0 *1 160.77,16.83
X$3267 \$151 VIA_L1M1_PR_MR
* cell instance $3268 r0 *1 186.07,22.95
X$3268 \$151 VIA_L1M1_PR_MR
* cell instance $3269 r0 *1 182.85,26.01
X$3269 \$151 VIA_L1M1_PR_MR
* cell instance $3270 r0 *1 178.02,35.02
X$3270 \$157 VIA_M3M4_PR
* cell instance $3271 r0 *1 179.17,35.02
X$3271 \$157 VIA_M2M3_PR
* cell instance $3272 r0 *1 178.25,18.7
X$3272 \$157 VIA_M2M3_PR
* cell instance $3273 r0 *1 178.02,18.7
X$3273 \$157 VIA_M3M4_PR
* cell instance $3274 r0 *1 179.17,35.87
X$3274 \$157 VIA_M1M2_PR
* cell instance $3275 r0 *1 178.25,18.53
X$3275 \$157 VIA_M1M2_PR
* cell instance $3276 r0 *1 176.87,18.53
X$3276 \$157 VIA_L1M1_PR_MR
* cell instance $3277 r0 *1 188.37,36.55
X$3277 \$157 VIA_L1M1_PR_MR
* cell instance $3278 r0 *1 186.53,48.45
X$3278 \$166 VIA_M1M2_PR
* cell instance $3279 r0 *1 186.53,18.19
X$3279 \$166 VIA_M1M2_PR
* cell instance $3280 r0 *1 181.47,18.19
X$3280 \$166 VIA_L1M1_PR_MR
* cell instance $3281 r0 *1 181.465,48.45
X$3281 \$166 VIA_L1M1_PR_MR
* cell instance $3282 r0 *1 179.17,21.25
X$3282 \$169 VIA_M1M2_PR
* cell instance $3283 r0 *1 180.09,17.51
X$3283 \$169 VIA_M1M2_PR
* cell instance $3284 r0 *1 179.63,20.57
X$3284 \$169 VIA_M1M2_PR
* cell instance $3285 r0 *1 161.69,27.71
X$3285 \$169 VIA_M1M2_PR
* cell instance $3286 r0 *1 161.69,21.25
X$3286 \$169 VIA_M1M2_PR
* cell instance $3287 r0 *1 161.69,27.71
X$3287 \$169 VIA_L1M1_PR_MR
* cell instance $3288 r0 *1 180.26,17.51
X$3288 \$169 VIA_L1M1_PR_MR
* cell instance $3289 r0 *1 179.17,20.57
X$3289 \$169 VIA_L1M1_PR_MR
* cell instance $3290 r0 *1 152.95,37.06
X$3290 \$179 VIA_M2M3_PR
* cell instance $3291 r0 *1 179.63,37.06
X$3291 \$179 VIA_M2M3_PR
* cell instance $3292 r0 *1 179.63,36.21
X$3292 \$179 VIA_M1M2_PR
* cell instance $3293 r0 *1 152.49,18.19
X$3293 \$179 VIA_M1M2_PR
* cell instance $3294 r0 *1 153.87,18.19
X$3294 \$179 VIA_L1M1_PR_MR
* cell instance $3295 r0 *1 182.39,36.55
X$3295 \$179 VIA_L1M1_PR_MR
* cell instance $3296 r0 *1 170.43,47.26
X$3296 \$180 VIA_M2M3_PR
* cell instance $3297 r0 *1 176.87,47.26
X$3297 \$180 VIA_M2M3_PR
* cell instance $3298 r0 *1 176.87,47.77
X$3298 \$180 VIA_M1M2_PR
* cell instance $3299 r0 *1 170.43,17.17
X$3299 \$180 VIA_M1M2_PR
* cell instance $3300 r0 *1 168.59,17.17
X$3300 \$180 VIA_L1M1_PR_MR
* cell instance $3301 r0 *1 176.87,47.77
X$3301 \$180 VIA_L1M1_PR_MR
* cell instance $3302 r0 *1 160.31,20.06
X$3302 \$181 VIA_M2M3_PR
* cell instance $3303 r0 *1 158.93,20.06
X$3303 \$181 VIA_M2M3_PR
* cell instance $3304 r0 *1 155.25,20.06
X$3304 \$181 VIA_M2M3_PR
* cell instance $3305 r0 *1 184.23,20.06
X$3305 \$181 VIA_M2M3_PR
* cell instance $3306 r0 *1 184.23,19.89
X$3306 \$181 VIA_M1M2_PR
* cell instance $3307 r0 *1 158.93,28.39
X$3307 \$181 VIA_M1M2_PR
* cell instance $3308 r0 *1 160.31,12.41
X$3308 \$181 VIA_M1M2_PR
* cell instance $3309 r0 *1 155.25,22.61
X$3309 \$181 VIA_M1M2_PR
* cell instance $3310 r0 *1 155.25,17.51
X$3310 \$181 VIA_M1M2_PR
* cell instance $3311 r0 *1 186.53,20.57
X$3311 \$181 VIA_L1M1_PR_MR
* cell instance $3312 r0 *1 153.87,17.51
X$3312 \$181 VIA_L1M1_PR_MR
* cell instance $3313 r0 *1 151.57,22.95
X$3313 \$181 VIA_L1M1_PR_MR
* cell instance $3314 r0 *1 160.31,12.41
X$3314 \$181 VIA_L1M1_PR_MR
* cell instance $3315 r0 *1 159.39,28.39
X$3315 \$181 VIA_L1M1_PR_MR
* cell instance $3316 r0 *1 94.99,112.03
X$3316 \$194 VIA_M1M2_PR
* cell instance $3317 r0 *1 81.19,20.91
X$3317 \$194 VIA_M1M2_PR
* cell instance $3318 r0 *1 94.99,71.23
X$3318 \$194 VIA_M1M2_PR
* cell instance $3319 r0 *1 81.65,71.23
X$3319 \$194 VIA_M1M2_PR
* cell instance $3320 r0 *1 81.65,20.57
X$3320 \$194 VIA_L1M1_PR_MR
* cell instance $3321 r0 *1 116.61,112.03
X$3321 \$194 VIA_L1M1_PR_MR
* cell instance $3322 r0 *1 100.51,20.23
X$3322 \$195 VIA_M1M2_PR
* cell instance $3323 r0 *1 100.51,120.19
X$3323 \$195 VIA_M1M2_PR
* cell instance $3324 r0 *1 82.11,20.57
X$3324 \$195 VIA_L1M1_PR_MR
* cell instance $3325 r0 *1 120.29,120.19
X$3325 \$195 VIA_L1M1_PR_MR
* cell instance $3326 r0 *1 166.06,49.3
X$3326 \$205 VIA_M3M4_PR
* cell instance $3327 r0 *1 166.06,19.38
X$3327 \$205 VIA_M3M4_PR
* cell instance $3328 r0 *1 170.89,49.3
X$3328 \$205 VIA_M2M3_PR
* cell instance $3329 r0 *1 161.23,19.38
X$3329 \$205 VIA_M2M3_PR
* cell instance $3330 r0 *1 170.89,53.89
X$3330 \$205 VIA_M1M2_PR
* cell instance $3331 r0 *1 161.23,19.55
X$3331 \$205 VIA_M1M2_PR
* cell instance $3332 r0 *1 162.15,19.55
X$3332 \$205 VIA_L1M1_PR_MR
* cell instance $3333 r0 *1 176.87,53.55
X$3333 \$205 VIA_L1M1_PR_MR
* cell instance $3334 r0 *1 165.83,30.43
X$3334 \$209 VIA_M1M2_PR
* cell instance $3335 r0 *1 165.37,18.53
X$3335 \$209 VIA_M1M2_PR
* cell instance $3336 r0 *1 165.37,20.91
X$3336 \$209 VIA_M1M2_PR
* cell instance $3337 r0 *1 164.45,20.91
X$3337 \$209 VIA_L1M1_PR_MR
* cell instance $3338 r0 *1 163.99,18.53
X$3338 \$209 VIA_L1M1_PR_MR
* cell instance $3339 r0 *1 183.77,31.45
X$3339 \$209 VIA_L1M1_PR_MR
* cell instance $3340 r0 *1 188.37,33.83
X$3340 \$227 VIA_M1M2_PR
* cell instance $3341 r0 *1 188.37,18.53
X$3341 \$227 VIA_M1M2_PR
* cell instance $3342 r0 *1 186.99,18.53
X$3342 \$227 VIA_L1M1_PR_MR
* cell instance $3343 r0 *1 182.39,33.83
X$3343 \$227 VIA_L1M1_PR_MR
* cell instance $3344 r0 *1 107.87,101.49
X$3344 \$233 VIA_M1M2_PR
* cell instance $3345 r0 *1 107.87,20.57
X$3345 \$233 VIA_M1M2_PR
* cell instance $3346 r0 *1 83.49,20.57
X$3346 \$233 VIA_L1M1_PR_MR
* cell instance $3347 r0 *1 121.21,101.49
X$3347 \$233 VIA_L1M1_PR_MR
* cell instance $3348 r0 *1 156.63,20.91
X$3348 \$247 VIA_M1M2_PR
* cell instance $3349 r0 *1 156.17,26.69
X$3349 \$247 VIA_M1M2_PR
* cell instance $3350 r0 *1 156.17,22.95
X$3350 \$247 VIA_M1M2_PR
* cell instance $3351 r0 *1 153.87,26.01
X$3351 \$247 VIA_L1M1_PR_MR
* cell instance $3352 r0 *1 158.47,20.91
X$3352 \$247 VIA_L1M1_PR_MR
* cell instance $3353 r0 *1 158.01,26.69
X$3353 \$247 VIA_L1M1_PR_MR
* cell instance $3354 r0 *1 156.17,22.95
X$3354 \$247 VIA_L1M1_PR_MR
* cell instance $3355 r0 *1 162.15,23.63
X$3355 \$288 VIA_M1M2_PR
* cell instance $3356 r0 *1 162.15,15.47
X$3356 \$288 VIA_M1M2_PR
* cell instance $3357 r0 *1 162.15,15.47
X$3357 \$288 VIA_L1M1_PR_MR
* cell instance $3358 r0 *1 157.09,22.95
X$3358 \$288 VIA_L1M1_PR_MR
* cell instance $3359 r0 *1 162.15,23.63
X$3359 \$288 VIA_L1M1_PR_MR
* cell instance $3360 r0 *1 168.59,25.33
X$3360 \$291 VIA_M1M2_PR
* cell instance $3361 r0 *1 168.59,23.97
X$3361 \$291 VIA_M1M2_PR
* cell instance $3362 r0 *1 174.57,25.67
X$3362 \$291 VIA_M1M2_PR
* cell instance $3363 r0 *1 174.57,31.79
X$3363 \$291 VIA_M1M2_PR
* cell instance $3364 r0 *1 160.31,31.79
X$3364 \$291 VIA_M1M2_PR
* cell instance $3365 r0 *1 160.31,23.97
X$3365 \$291 VIA_M1M2_PR
* cell instance $3366 r0 *1 163.99,23.97
X$3366 \$291 VIA_L1M1_PR_MR
* cell instance $3367 r0 *1 160.31,31.79
X$3367 \$291 VIA_L1M1_PR_MR
* cell instance $3368 r0 *1 178.71,31.45
X$3368 \$291 VIA_L1M1_PR_MR
* cell instance $3369 r0 *1 178.25,25.67
X$3369 \$291 VIA_L1M1_PR_MR
* cell instance $3370 r0 *1 179.63,28.22
X$3370 \$306 VIA_M2M3_PR
* cell instance $3371 r0 *1 185.15,27.54
X$3371 \$306 VIA_M2M3_PR
* cell instance $3372 r0 *1 163.99,27.54
X$3372 \$306 VIA_M2M3_PR
* cell instance $3373 r0 *1 185.15,23.97
X$3373 \$306 VIA_M1M2_PR
* cell instance $3374 r0 *1 179.63,28.05
X$3374 \$306 VIA_M1M2_PR
* cell instance $3375 r0 *1 163.99,20.23
X$3375 \$306 VIA_M1M2_PR
* cell instance $3376 r0 *1 187.91,23.63
X$3376 \$306 VIA_L1M1_PR_MR
* cell instance $3377 r0 *1 163.99,20.23
X$3377 \$306 VIA_L1M1_PR_MR
* cell instance $3378 r0 *1 179.63,28.05
X$3378 \$306 VIA_L1M1_PR_MR
* cell instance $3379 r0 *1 186.99,38.93
X$3379 \$311 VIA_M1M2_PR
* cell instance $3380 r0 *1 186.99,21.25
X$3380 \$311 VIA_M1M2_PR
* cell instance $3381 r0 *1 184.69,21.25
X$3381 \$311 VIA_L1M1_PR_MR
* cell instance $3382 r0 *1 186.53,38.93
X$3382 \$311 VIA_L1M1_PR_MR
* cell instance $3383 r0 *1 184.69,23.63
X$3383 \$313 VIA_M1M2_PR
* cell instance $3384 r0 *1 184.69,26.01
X$3384 \$313 VIA_M1M2_PR
* cell instance $3385 r0 *1 184.69,26.01
X$3385 \$313 VIA_L1M1_PR_MR
* cell instance $3386 r0 *1 180.09,23.63
X$3386 \$313 VIA_L1M1_PR_MR
* cell instance $3387 r0 *1 81.65,26.35
X$3387 \$314 VIA_M1M2_PR
* cell instance $3388 r0 *1 81.65,21.25
X$3388 \$314 VIA_M1M2_PR
* cell instance $3389 r0 *1 80.73,21.25
X$3389 \$314 VIA_L1M1_PR_MR
* cell instance $3390 r0 *1 81.65,26.35
X$3390 \$314 VIA_L1M1_PR_MR
* cell instance $3391 r0 *1 109.71,98.43
X$3391 \$315 VIA_M1M2_PR
* cell instance $3392 r0 *1 109.71,41.65
X$3392 \$315 VIA_M1M2_PR
* cell instance $3393 r0 *1 92.23,41.65
X$3393 \$315 VIA_M1M2_PR
* cell instance $3394 r0 *1 92.23,21.25
X$3394 \$315 VIA_M1M2_PR
* cell instance $3395 r0 *1 82.57,21.25
X$3395 \$315 VIA_L1M1_PR_MR
* cell instance $3396 r0 *1 109.71,98.43
X$3396 \$315 VIA_L1M1_PR_MR
* cell instance $3397 r0 *1 178.71,36.21
X$3397 \$317 VIA_M1M2_PR
* cell instance $3398 r0 *1 178.71,23.97
X$3398 \$317 VIA_M1M2_PR
* cell instance $3399 r0 *1 176.87,23.97
X$3399 \$317 VIA_L1M1_PR_MR
* cell instance $3400 r0 *1 178.71,36.89
X$3400 \$317 VIA_L1M1_PR_MR
* cell instance $3401 r0 *1 173.19,25.67
X$3401 \$330 VIA_M1M2_PR
* cell instance $3402 r0 *1 173.19,22.95
X$3402 \$330 VIA_M1M2_PR
* cell instance $3403 r0 *1 167.67,22.95
X$3403 \$330 VIA_L1M1_PR_MR
* cell instance $3404 r0 *1 168.59,22.95
X$3404 \$330 VIA_L1M1_PR_MR
* cell instance $3405 r0 *1 173.19,25.67
X$3405 \$330 VIA_L1M1_PR_MR
* cell instance $3406 r0 *1 171.81,22.95
X$3406 \$330 VIA_L1M1_PR_MR
* cell instance $3407 r0 *1 117.99,283.73
X$3407 \$340 VIA_M1M2_PR
* cell instance $3408 r0 *1 122.13,269.79
X$3408 \$340 VIA_M1M2_PR
* cell instance $3409 r0 *1 117.99,284.41
X$3409 \$340 VIA_M1M2_PR
* cell instance $3410 r0 *1 122.59,284.41
X$3410 \$340 VIA_M1M2_PR
* cell instance $3411 r0 *1 113.85,207.91
X$3411 \$340 VIA_M1M2_PR
* cell instance $3412 r0 *1 117.53,222.53
X$3412 \$340 VIA_M1M2_PR
* cell instance $3413 r0 *1 117.53,223.55
X$3413 \$340 VIA_M1M2_PR
* cell instance $3414 r0 *1 117.99,234.77
X$3414 \$340 VIA_M1M2_PR
* cell instance $3415 r0 *1 117.99,226.27
X$3415 \$340 VIA_M1M2_PR
* cell instance $3416 r0 *1 118.45,254.15
X$3416 \$340 VIA_M1M2_PR
* cell instance $3417 r0 *1 122.13,253.81
X$3417 \$340 VIA_M1M2_PR
* cell instance $3418 r0 *1 112.93,207.91
X$3418 \$340 VIA_M1M2_PR
* cell instance $3419 r0 *1 112.93,222.53
X$3419 \$340 VIA_M1M2_PR
* cell instance $3420 r0 *1 100.97,106.59
X$3420 \$340 VIA_M1M2_PR
* cell instance $3421 r0 *1 100.97,26.35
X$3421 \$340 VIA_M1M2_PR
* cell instance $3422 r0 *1 82.11,150.79
X$3422 \$340 VIA_M1M2_PR
* cell instance $3423 r0 *1 82.57,107.95
X$3423 \$340 VIA_M1M2_PR
* cell instance $3424 r0 *1 82.57,104.55
X$3424 \$340 VIA_M1M2_PR
* cell instance $3425 r0 *1 26.45,149.09
X$3425 \$340 VIA_M1M2_PR
* cell instance $3426 r0 *1 26.45,147.39
X$3426 \$340 VIA_M1M2_PR
* cell instance $3427 r0 *1 81.19,194.31
X$3427 \$340 VIA_M1M2_PR
* cell instance $3428 r0 *1 23.69,149.09
X$3428 \$340 VIA_M1M2_PR
* cell instance $3429 r0 *1 23.69,153.51
X$3429 \$340 VIA_M1M2_PR
* cell instance $3430 r0 *1 31.05,154.19
X$3430 \$340 VIA_M1M2_PR
* cell instance $3431 r0 *1 31.05,156.57
X$3431 \$340 VIA_M1M2_PR
* cell instance $3432 r0 *1 32.89,153.51
X$3432 \$340 VIA_M1M2_PR
* cell instance $3433 r0 *1 32.89,150.79
X$3433 \$340 VIA_M1M2_PR
* cell instance $3434 r0 *1 113.39,200.09
X$3434 \$340 VIA_M1M2_PR
* cell instance $3435 r0 *1 113.39,194.99
X$3435 \$340 VIA_M1M2_PR
* cell instance $3436 r0 *1 113.39,194.31
X$3436 \$340 VIA_M1M2_PR
* cell instance $3437 r0 *1 82.57,106.59
X$3437 \$340 VIA_M1M2_PR
* cell instance $3438 r0 *1 28.29,147.39
X$3438 \$340 VIA_L1M1_PR_MR
* cell instance $3439 r0 *1 165.37,25.67
X$3439 \$340 VIA_L1M1_PR_MR
* cell instance $3440 r0 *1 156.17,26.01
X$3440 \$340 VIA_L1M1_PR_MR
* cell instance $3441 r0 *1 159.39,26.01
X$3441 \$340 VIA_L1M1_PR_MR
* cell instance $3442 r0 *1 23.69,153.51
X$3442 \$340 VIA_L1M1_PR_MR
* cell instance $3443 r0 *1 38.41,151.13
X$3443 \$340 VIA_L1M1_PR_MR
* cell instance $3444 r0 *1 31.51,153.51
X$3444 \$340 VIA_L1M1_PR_MR
* cell instance $3445 r0 *1 31.05,156.57
X$3445 \$340 VIA_L1M1_PR_MR
* cell instance $3446 r0 *1 35.19,150.45
X$3446 \$340 VIA_L1M1_PR_MR
* cell instance $3447 r0 *1 25.99,149.09
X$3447 \$340 VIA_L1M1_PR_MR
* cell instance $3448 r0 *1 117.53,194.65
X$3448 \$340 VIA_L1M1_PR_MR
* cell instance $3449 r0 *1 113.85,200.09
X$3449 \$340 VIA_L1M1_PR_MR
* cell instance $3450 r0 *1 120.75,254.15
X$3450 \$340 VIA_L1M1_PR_MR
* cell instance $3451 r0 *1 116.15,269.79
X$3451 \$340 VIA_L1M1_PR_MR
* cell instance $3452 r0 *1 112.47,283.73
X$3452 \$340 VIA_L1M1_PR_MR
* cell instance $3453 r0 *1 117.53,223.55
X$3453 \$340 VIA_L1M1_PR_MR
* cell instance $3454 r0 *1 113.85,207.91
X$3454 \$340 VIA_L1M1_PR_MR
* cell instance $3455 r0 *1 117.99,226.27
X$3455 \$340 VIA_L1M1_PR_MR
* cell instance $3456 r0 *1 120.29,234.77
X$3456 \$340 VIA_L1M1_PR_MR
* cell instance $3457 r0 *1 126.73,284.41
X$3457 \$340 VIA_L1M1_PR_MR
* cell instance $3458 r0 *1 127.19,254.15
X$3458 \$340 VIA_L1M1_PR_MR
* cell instance $3459 r0 *1 80.27,107.61
X$3459 \$340 VIA_L1M1_PR_MR
* cell instance $3460 r0 *1 82.57,104.55
X$3460 \$340 VIA_L1M1_PR_MR
* cell instance $3461 r0 *1 156.63,29.58
X$3461 \$345 VIA_M2M3_PR
* cell instance $3462 r0 *1 182.85,28.9
X$3462 \$345 VIA_M2M3_PR
* cell instance $3463 r0 *1 156.63,26.18
X$3463 \$345 VIA_M2M3_PR
* cell instance $3464 r0 *1 153.41,26.18
X$3464 \$345 VIA_M2M3_PR
* cell instance $3465 r0 *1 182.85,39.27
X$3465 \$345 VIA_M1M2_PR
* cell instance $3466 r0 *1 182.85,28.39
X$3466 \$345 VIA_M1M2_PR
* cell instance $3467 r0 *1 153.41,26.01
X$3467 \$345 VIA_M1M2_PR
* cell instance $3468 r0 *1 182.85,28.39
X$3468 \$345 VIA_L1M1_PR_MR
* cell instance $3469 r0 *1 152.49,26.01
X$3469 \$345 VIA_L1M1_PR_MR
* cell instance $3470 r0 *1 182.85,39.27
X$3470 \$345 VIA_L1M1_PR_MR
* cell instance $3471 r0 *1 157.55,26.35
X$3471 \$347 VIA_M1M2_PR
* cell instance $3472 r0 *1 157.55,20.57
X$3472 \$347 VIA_M1M2_PR
* cell instance $3473 r0 *1 167.21,26.35
X$3473 \$347 VIA_L1M1_PR_MR
* cell instance $3474 r0 *1 154.79,26.01
X$3474 \$347 VIA_L1M1_PR_MR
* cell instance $3475 r0 *1 157.55,20.57
X$3475 \$347 VIA_L1M1_PR_MR
* cell instance $3476 r0 *1 158.01,25.5
X$3476 \$348 VIA_M2M3_PR
* cell instance $3477 r0 *1 166.29,25.5
X$3477 \$348 VIA_M2M3_PR
* cell instance $3478 r0 *1 135.01,95.71
X$3478 \$348 VIA_M1M2_PR
* cell instance $3479 r0 *1 154.33,33.15
X$3479 \$348 VIA_M1M2_PR
* cell instance $3480 r0 *1 169.51,29.41
X$3480 \$348 VIA_M1M2_PR
* cell instance $3481 r0 *1 155.25,26.01
X$3481 \$348 VIA_M1M2_PR
* cell instance $3482 r0 *1 154.79,29.07
X$3482 \$348 VIA_M1M2_PR
* cell instance $3483 r0 *1 158.01,26.01
X$3483 \$348 VIA_M1M2_PR
* cell instance $3484 r0 *1 158.01,28.39
X$3484 \$348 VIA_M1M2_PR
* cell instance $3485 r0 *1 158.01,29.07
X$3485 \$348 VIA_M1M2_PR
* cell instance $3486 r0 *1 154.33,31.45
X$3486 \$348 VIA_M1M2_PR
* cell instance $3487 r0 *1 166.75,29.41
X$3487 \$348 VIA_M1M2_PR
* cell instance $3488 r0 *1 169.51,28.73
X$3488 \$348 VIA_M1M2_PR
* cell instance $3489 r0 *1 169.51,31.11
X$3489 \$348 VIA_M1M2_PR
* cell instance $3490 r0 *1 166.75,28.39
X$3490 \$348 VIA_M1M2_PR
* cell instance $3491 r0 *1 166.29,26.01
X$3491 \$348 VIA_M1M2_PR
* cell instance $3492 r0 *1 135.01,33.15
X$3492 \$348 VIA_M1M2_PR
* cell instance $3493 r0 *1 33.35,96.73
X$3493 \$348 VIA_M1M2_PR
* cell instance $3494 r0 *1 29.21,102.17
X$3494 \$348 VIA_M1M2_PR
* cell instance $3495 r0 *1 28.75,98.77
X$3495 \$348 VIA_M1M2_PR
* cell instance $3496 r0 *1 33.35,96.05
X$3496 \$348 VIA_M1M2_PR
* cell instance $3497 r0 *1 28.75,94.35
X$3497 \$348 VIA_M1M2_PR
* cell instance $3498 r0 *1 33.35,94.69
X$3498 \$348 VIA_M1M2_PR
* cell instance $3499 r0 *1 164.62,28.39
X$3499 \$348 VIA_L1M1_PR_MR
* cell instance $3500 r0 *1 169.51,31.11
X$3500 \$348 VIA_L1M1_PR_MR
* cell instance $3501 r0 *1 170.43,28.73
X$3501 \$348 VIA_L1M1_PR_MR
* cell instance $3502 r0 *1 166.29,26.01
X$3502 \$348 VIA_L1M1_PR_MR
* cell instance $3503 r0 *1 155.25,26.01
X$3503 \$348 VIA_L1M1_PR_MR
* cell instance $3504 r0 *1 154.33,31.45
X$3504 \$348 VIA_L1M1_PR_MR
* cell instance $3505 r0 *1 158.01,28.39
X$3505 \$348 VIA_L1M1_PR_MR
* cell instance $3506 r0 *1 158.01,26.01
X$3506 \$348 VIA_L1M1_PR_MR
* cell instance $3507 r0 *1 176.41,28.73
X$3507 \$348 VIA_L1M1_PR_MR
* cell instance $3508 r0 *1 37.49,96.39
X$3508 \$348 VIA_L1M1_PR_MR
* cell instance $3509 r0 *1 33.35,96.73
X$3509 \$348 VIA_L1M1_PR_MR
* cell instance $3510 r0 *1 32.89,94.69
X$3510 \$348 VIA_L1M1_PR_MR
* cell instance $3511 r0 *1 30.59,93.67
X$3511 \$348 VIA_L1M1_PR_MR
* cell instance $3512 r0 *1 28.29,102.17
X$3512 \$348 VIA_L1M1_PR_MR
* cell instance $3513 r0 *1 27.83,98.77
X$3513 \$348 VIA_L1M1_PR_MR
* cell instance $3514 r0 *1 158.47,33.83
X$3514 \$351 VIA_M1M2_PR
* cell instance $3515 r0 *1 158.47,26.01
X$3515 \$351 VIA_M1M2_PR
* cell instance $3516 r0 *1 159.85,26.35
X$3516 \$351 VIA_L1M1_PR_MR
* cell instance $3517 r0 *1 158.47,33.83
X$3517 \$351 VIA_L1M1_PR_MR
* cell instance $3518 r0 *1 182.39,47.77
X$3518 \$368 VIA_M1M2_PR
* cell instance $3519 r0 *1 182.39,45.73
X$3519 \$368 VIA_M1M2_PR
* cell instance $3520 r0 *1 187.45,45.39
X$3520 \$368 VIA_M1M2_PR
* cell instance $3521 r0 *1 187.45,26.35
X$3521 \$368 VIA_M1M2_PR
* cell instance $3522 r0 *1 186.53,26.35
X$3522 \$368 VIA_L1M1_PR_MR
* cell instance $3523 r0 *1 181.93,47.77
X$3523 \$368 VIA_L1M1_PR_MR
* cell instance $3524 r0 *1 80.73,26.69
X$3524 \$373 VIA_L1M1_PR_MR
* cell instance $3525 r0 *1 77.05,26.69
X$3525 \$373 VIA_L1M1_PR_MR
* cell instance $3526 r0 *1 97.29,128.35
X$3526 \$374 VIA_M1M2_PR
* cell instance $3527 r0 *1 80.27,24.99
X$3527 \$374 VIA_M1M2_PR
* cell instance $3528 r0 *1 80.27,86.19
X$3528 \$374 VIA_M1M2_PR
* cell instance $3529 r0 *1 97.29,86.19
X$3529 \$374 VIA_M1M2_PR
* cell instance $3530 r0 *1 77.97,24.99
X$3530 \$374 VIA_L1M1_PR_MR
* cell instance $3531 r0 *1 111.09,128.35
X$3531 \$374 VIA_L1M1_PR_MR
* cell instance $3532 r0 *1 168.59,286.11
X$3532 \$375 VIA_M1M2_PR
* cell instance $3533 r0 *1 169.05,275.23
X$3533 \$375 VIA_M1M2_PR
* cell instance $3534 r0 *1 169.05,269.79
X$3534 \$375 VIA_M1M2_PR
* cell instance $3535 r0 *1 168.59,279.65
X$3535 \$375 VIA_M1M2_PR
* cell instance $3536 r0 *1 169.05,266.05
X$3536 \$375 VIA_M1M2_PR
* cell instance $3537 r0 *1 77.97,111.01
X$3537 \$375 VIA_M1M2_PR
* cell instance $3538 r0 *1 81.19,111.01
X$3538 \$375 VIA_M1M2_PR
* cell instance $3539 r0 *1 79.81,266.05
X$3539 \$375 VIA_M1M2_PR
* cell instance $3540 r0 *1 82.11,26.01
X$3540 \$375 VIA_M1M2_PR
* cell instance $3541 r0 *1 169.05,275.23
X$3541 \$375 VIA_L1M1_PR_MR
* cell instance $3542 r0 *1 168.59,278.63
X$3542 \$375 VIA_L1M1_PR_MR
* cell instance $3543 r0 *1 168.59,279.65
X$3543 \$375 VIA_L1M1_PR_MR
* cell instance $3544 r0 *1 169.05,286.11
X$3544 \$375 VIA_L1M1_PR_MR
* cell instance $3545 r0 *1 169.05,269.79
X$3545 \$375 VIA_L1M1_PR_MR
* cell instance $3546 r0 *1 170.89,278.63
X$3546 \$375 VIA_L1M1_PR_MR
* cell instance $3547 r0 *1 79.35,26.01
X$3547 \$375 VIA_L1M1_PR_MR
* cell instance $3548 r0 *1 82.57,24.99
X$3548 \$376 VIA_L1M1_PR_MR
* cell instance $3549 r0 *1 80.73,24.99
X$3549 \$376 VIA_L1M1_PR_MR
* cell instance $3550 r0 *1 97.75,52.53
X$3550 \$378 VIA_M1M2_PR
* cell instance $3551 r0 *1 97.75,26.69
X$3551 \$378 VIA_M1M2_PR
* cell instance $3552 r0 *1 121.21,52.53
X$3552 \$378 VIA_L1M1_PR_MR
* cell instance $3553 r0 *1 84.41,26.69
X$3553 \$378 VIA_L1M1_PR_MR
* cell instance $3554 r0 *1 182.62,35.02
X$3554 \$380 VIA_M3M4_PR
* cell instance $3555 r0 *1 182.62,41.14
X$3555 \$380 VIA_M3M4_PR
* cell instance $3556 r0 *1 180.09,41.14
X$3556 \$380 VIA_M2M3_PR
* cell instance $3557 r0 *1 181.47,35.02
X$3557 \$380 VIA_M2M3_PR
* cell instance $3558 r0 *1 180.09,41.31
X$3558 \$380 VIA_M1M2_PR
* cell instance $3559 r0 *1 181.47,36.89
X$3559 \$380 VIA_M1M2_PR
* cell instance $3560 r0 *1 181.47,26.01
X$3560 \$380 VIA_M1M2_PR
* cell instance $3561 r0 *1 180.55,26.01
X$3561 \$380 VIA_L1M1_PR_MR
* cell instance $3562 r0 *1 178.25,41.99
X$3562 \$380 VIA_L1M1_PR_MR
* cell instance $3563 r0 *1 181.47,36.89
X$3563 \$380 VIA_L1M1_PR_MR
* cell instance $3564 r0 *1 108.33,26.01
X$3564 \$381 VIA_M1M2_PR
* cell instance $3565 r0 *1 108.33,63.07
X$3565 \$381 VIA_M1M2_PR
* cell instance $3566 r0 *1 111.09,63.07
X$3566 \$381 VIA_L1M1_PR_MR
* cell instance $3567 r0 *1 85.33,26.01
X$3567 \$381 VIA_L1M1_PR_MR
* cell instance $3568 r0 *1 168.59,33.15
X$3568 \$383 VIA_M1M2_PR
* cell instance $3569 r0 *1 168.59,26.01
X$3569 \$383 VIA_M1M2_PR
* cell instance $3570 r0 *1 168.59,33.15
X$3570 \$383 VIA_L1M1_PR_MR
* cell instance $3571 r0 *1 158.01,34.17
X$3571 \$383 VIA_L1M1_PR_MR
* cell instance $3572 r0 *1 164.45,31.45
X$3572 \$386 VIA_M1M2_PR
* cell instance $3573 r0 *1 164.45,26.69
X$3573 \$386 VIA_M1M2_PR
* cell instance $3574 r0 *1 162.61,26.69
X$3574 \$386 VIA_L1M1_PR_MR
* cell instance $3575 r0 *1 164.45,31.45
X$3575 \$386 VIA_L1M1_PR_MR
* cell instance $3576 r0 *1 162.15,41.82
X$3576 \$389 VIA_M2M3_PR
* cell instance $3577 r0 *1 153.87,41.82
X$3577 \$389 VIA_M2M3_PR
* cell instance $3578 r0 *1 162.15,41.65
X$3578 \$389 VIA_M1M2_PR
* cell instance $3579 r0 *1 150.19,23.63
X$3579 \$389 VIA_M1M2_PR
* cell instance $3580 r0 *1 150.19,26.69
X$3580 \$389 VIA_M1M2_PR
* cell instance $3581 r0 *1 153.41,26.69
X$3581 \$389 VIA_M1M2_PR
* cell instance $3582 r0 *1 150.19,23.63
X$3582 \$389 VIA_L1M1_PR_MR
* cell instance $3583 r0 *1 177.33,42.33
X$3583 \$389 VIA_L1M1_PR_MR
* cell instance $3584 r0 *1 155.25,30.94
X$3584 \$392 VIA_M2M3_PR
* cell instance $3585 r0 *1 164.91,30.94
X$3585 \$392 VIA_M2M3_PR
* cell instance $3586 r0 *1 165.37,46.75
X$3586 \$392 VIA_M1M2_PR
* cell instance $3587 r0 *1 155.25,31.11
X$3587 \$392 VIA_M1M2_PR
* cell instance $3588 r0 *1 164.91,24.99
X$3588 \$392 VIA_M1M2_PR
* cell instance $3589 r0 *1 164.45,24.99
X$3589 \$392 VIA_L1M1_PR_MR
* cell instance $3590 r0 *1 152.95,31.11
X$3590 \$392 VIA_L1M1_PR_MR
* cell instance $3591 r0 *1 183.31,47.77
X$3591 \$392 VIA_L1M1_PR_MR
* cell instance $3592 r0 *1 152.03,32.3
X$3592 \$407 VIA_M2M3_PR
* cell instance $3593 r0 *1 163.53,32.3
X$3593 \$407 VIA_M2M3_PR
* cell instance $3594 r0 *1 163.53,33.83
X$3594 \$407 VIA_M1M2_PR
* cell instance $3595 r0 *1 152.03,29.41
X$3595 \$407 VIA_M1M2_PR
* cell instance $3596 r0 *1 151.11,29.07
X$3596 \$407 VIA_L1M1_PR_MR
* cell instance $3597 r0 *1 163.53,33.83
X$3597 \$407 VIA_L1M1_PR_MR
* cell instance $3598 r0 *1 162.15,36.38
X$3598 \$413 VIA_M2M3_PR
* cell instance $3599 r0 *1 162.15,30.26
X$3599 \$413 VIA_M2M3_PR
* cell instance $3600 r0 *1 155.25,30.26
X$3600 \$413 VIA_M2M3_PR
* cell instance $3601 r0 *1 185.61,37.06
X$3601 \$413 VIA_M2M3_PR
* cell instance $3602 r0 *1 185.61,37.23
X$3602 \$413 VIA_M1M2_PR
* cell instance $3603 r0 *1 155.25,29.41
X$3603 \$413 VIA_M1M2_PR
* cell instance $3604 r0 *1 162.15,31.45
X$3604 \$413 VIA_M1M2_PR
* cell instance $3605 r0 *1 162.605,31.45
X$3605 \$413 VIA_L1M1_PR_MR
* cell instance $3606 r0 *1 155.25,29.41
X$3606 \$413 VIA_L1M1_PR_MR
* cell instance $3607 r0 *1 187.45,36.89
X$3607 \$413 VIA_L1M1_PR_MR
* cell instance $3608 r0 *1 33.81,72.42
X$3608 \$416 VIA_M2M3_PR
* cell instance $3609 r0 *1 33.81,102.34
X$3609 \$416 VIA_M2M3_PR
* cell instance $3610 r0 *1 31.51,102.34
X$3610 \$416 VIA_M2M3_PR
* cell instance $3611 r0 *1 153.41,72.42
X$3611 \$416 VIA_M2M3_PR
* cell instance $3612 r0 *1 165.83,37.23
X$3612 \$416 VIA_M1M2_PR
* cell instance $3613 r0 *1 165.83,39.27
X$3613 \$416 VIA_M1M2_PR
* cell instance $3614 r0 *1 153.41,36.89
X$3614 \$416 VIA_M1M2_PR
* cell instance $3615 r0 *1 153.41,34.17
X$3615 \$416 VIA_M1M2_PR
* cell instance $3616 r0 *1 157.55,33.83
X$3616 \$416 VIA_M1M2_PR
* cell instance $3617 r0 *1 157.55,33.15
X$3617 \$416 VIA_M1M2_PR
* cell instance $3618 r0 *1 161.23,28.73
X$3618 \$416 VIA_M1M2_PR
* cell instance $3619 r0 *1 157.55,28.39
X$3619 \$416 VIA_M1M2_PR
* cell instance $3620 r0 *1 157.55,31.11
X$3620 \$416 VIA_M1M2_PR
* cell instance $3621 r0 *1 161.23,26.01
X$3621 \$416 VIA_M1M2_PR
* cell instance $3622 r0 *1 31.51,102.17
X$3622 \$416 VIA_M1M2_PR
* cell instance $3623 r0 *1 33.81,103.87
X$3623 \$416 VIA_M1M2_PR
* cell instance $3624 r0 *1 25.07,101.83
X$3624 \$416 VIA_M1M2_PR
* cell instance $3625 r0 *1 25.07,99.11
X$3625 \$416 VIA_M1M2_PR
* cell instance $3626 r0 *1 163.99,28.39
X$3626 \$416 VIA_L1M1_PR_MR
* cell instance $3627 r0 *1 172.73,28.39
X$3627 \$416 VIA_L1M1_PR_MR
* cell instance $3628 r0 *1 161.23,26.01
X$3628 \$416 VIA_L1M1_PR_MR
* cell instance $3629 r0 *1 156.17,31.45
X$3629 \$416 VIA_L1M1_PR_MR
* cell instance $3630 r0 *1 157.55,28.39
X$3630 \$416 VIA_L1M1_PR_MR
* cell instance $3631 r0 *1 164.45,39.27
X$3631 \$416 VIA_L1M1_PR_MR
* cell instance $3632 r0 *1 33.81,103.87
X$3632 \$416 VIA_L1M1_PR_MR
* cell instance $3633 r0 *1 156.63,33.83
X$3633 \$416 VIA_L1M1_PR_MR
* cell instance $3634 r0 *1 159.85,33.15
X$3634 \$416 VIA_L1M1_PR_MR
* cell instance $3635 r0 *1 168.59,39.27
X$3635 \$416 VIA_L1M1_PR_MR
* cell instance $3636 r0 *1 158.93,36.89
X$3636 \$416 VIA_L1M1_PR_MR
* cell instance $3637 r0 *1 25.99,99.11
X$3637 \$416 VIA_L1M1_PR_MR
* cell instance $3638 r0 *1 27.83,102.17
X$3638 \$416 VIA_L1M1_PR_MR
* cell instance $3639 r0 *1 31.51,102.17
X$3639 \$416 VIA_L1M1_PR_MR
* cell instance $3640 r0 *1 153.41,36.89
X$3640 \$416 VIA_L1M1_PR_MR
* cell instance $3641 r0 *1 167.21,31.45
X$3641 \$417 VIA_M1M2_PR_MR
* cell instance $3642 r0 *1 30.59,99.62
X$3642 \$417 VIA_M2M3_PR
* cell instance $3643 r0 *1 37.95,99.62
X$3643 \$417 VIA_M2M3_PR
* cell instance $3644 r0 *1 152.49,99.62
X$3644 \$417 VIA_M2M3_PR
* cell instance $3645 r0 *1 152.49,32.98
X$3645 \$417 VIA_M2M3_PR
* cell instance $3646 r0 *1 160.31,32.98
X$3646 \$417 VIA_M2M3_PR
* cell instance $3647 r0 *1 167.21,34.51
X$3647 \$417 VIA_M1M2_PR
* cell instance $3648 r0 *1 161.69,33.15
X$3648 \$417 VIA_M1M2_PR
* cell instance $3649 r0 *1 160.31,33.15
X$3649 \$417 VIA_M1M2_PR
* cell instance $3650 r0 *1 152.49,36.89
X$3650 \$417 VIA_M1M2_PR
* cell instance $3651 r0 *1 161.69,36.55
X$3651 \$417 VIA_M1M2_PR
* cell instance $3652 r0 *1 171.35,28.05
X$3652 \$417 VIA_M1M2_PR
* cell instance $3653 r0 *1 152.49,31.45
X$3653 \$417 VIA_M1M2_PR
* cell instance $3654 r0 *1 161.69,30.77
X$3654 \$417 VIA_M1M2_PR
* cell instance $3655 r0 *1 160.77,26.01
X$3655 \$417 VIA_M1M2_PR
* cell instance $3656 r0 *1 163.53,28.39
X$3656 \$417 VIA_M1M2_PR
* cell instance $3657 r0 *1 171.35,31.45
X$3657 \$417 VIA_M1M2_PR
* cell instance $3658 r0 *1 163.53,30.77
X$3658 \$417 VIA_M1M2_PR
* cell instance $3659 r0 *1 30.59,102.17
X$3659 \$417 VIA_M1M2_PR
* cell instance $3660 r0 *1 29.21,104.89
X$3660 \$417 VIA_M1M2_PR
* cell instance $3661 r0 *1 37.95,109.31
X$3661 \$417 VIA_M1M2_PR
* cell instance $3662 r0 *1 37.95,107.27
X$3662 \$417 VIA_M1M2_PR
* cell instance $3663 r0 *1 29.21,106.93
X$3663 \$417 VIA_M1M2_PR
* cell instance $3664 r0 *1 163.53,28.39
X$3664 \$417 VIA_L1M1_PR_MR
* cell instance $3665 r0 *1 173.65,28.05
X$3665 \$417 VIA_L1M1_PR_MR
* cell instance $3666 r0 *1 153.41,31.45
X$3666 \$417 VIA_L1M1_PR_MR
* cell instance $3667 r0 *1 160.77,26.01
X$3667 \$417 VIA_L1M1_PR_MR
* cell instance $3668 r0 *1 160.77,36.55
X$3668 \$417 VIA_L1M1_PR_MR
* cell instance $3669 r0 *1 30.59,102.17
X$3669 \$417 VIA_L1M1_PR_MR
* cell instance $3670 r0 *1 27.83,104.55
X$3670 \$417 VIA_L1M1_PR_MR
* cell instance $3671 r0 *1 166.75,34.51
X$3671 \$417 VIA_L1M1_PR_MR
* cell instance $3672 r0 *1 37.95,109.31
X$3672 \$417 VIA_L1M1_PR_MR
* cell instance $3673 r0 *1 33.35,107.61
X$3673 \$417 VIA_L1M1_PR_MR
* cell instance $3674 r0 *1 29.21,107.61
X$3674 \$417 VIA_L1M1_PR_MR
* cell instance $3675 r0 *1 160.31,33.15
X$3675 \$417 VIA_L1M1_PR_MR
* cell instance $3676 r0 *1 152.49,36.89
X$3676 \$417 VIA_L1M1_PR_MR
* cell instance $3677 r0 *1 162.61,33.15
X$3677 \$418 VIA_M1M2_PR
* cell instance $3678 r0 *1 169.51,38.59
X$3678 \$418 VIA_M1M2_PR
* cell instance $3679 r0 *1 169.51,36.55
X$3679 \$418 VIA_M1M2_PR
* cell instance $3680 r0 *1 160.77,34.51
X$3680 \$418 VIA_M1M2_PR
* cell instance $3681 r0 *1 164.45,38.59
X$3681 \$418 VIA_M1M2_PR
* cell instance $3682 r0 *1 164.45,33.15
X$3682 \$418 VIA_M1M2_PR
* cell instance $3683 r0 *1 154.79,33.83
X$3683 \$418 VIA_M1M2_PR
* cell instance $3684 r0 *1 160.77,33.49
X$3684 \$418 VIA_M1M2_PR
* cell instance $3685 r0 *1 158.47,34.51
X$3685 \$418 VIA_M1M2_PR
* cell instance $3686 r0 *1 154.79,36.55
X$3686 \$418 VIA_M1M2_PR
* cell instance $3687 r0 *1 154.79,40.29
X$3687 \$418 VIA_M1M2_PR
* cell instance $3688 r0 *1 158.47,39.27
X$3688 \$418 VIA_M1M2_PR
* cell instance $3689 r0 *1 158.47,36.55
X$3689 \$418 VIA_M1M2_PR
* cell instance $3690 r0 *1 162.61,28.39
X$3690 \$418 VIA_M1M2_PR
* cell instance $3691 r0 *1 162.61,27.71
X$3691 \$418 VIA_M1M2_PR
* cell instance $3692 r0 *1 32.89,108.29
X$3692 \$418 VIA_M1M2_PR
* cell instance $3693 r0 *1 32.89,107.61
X$3693 \$418 VIA_M1M2_PR
* cell instance $3694 r0 *1 32.43,102.17
X$3694 \$418 VIA_M1M2_PR
* cell instance $3695 r0 *1 34.27,102.17
X$3695 \$418 VIA_M1M2_PR
* cell instance $3696 r0 *1 34.27,99.45
X$3696 \$418 VIA_M1M2_PR
* cell instance $3697 r0 *1 73.83,41.31
X$3697 \$418 VIA_M1M2_PR
* cell instance $3698 r0 *1 58.65,41.31
X$3698 \$418 VIA_M1M2_PR
* cell instance $3699 r0 *1 73.83,39.95
X$3699 \$418 VIA_M1M2_PR
* cell instance $3700 r0 *1 58.65,98.43
X$3700 \$418 VIA_M1M2_PR
* cell instance $3701 r0 *1 162.61,28.39
X$3701 \$418 VIA_L1M1_PR_MR
* cell instance $3702 r0 *1 173.19,27.71
X$3702 \$418 VIA_L1M1_PR_MR
* cell instance $3703 r0 *1 37.95,99.45
X$3703 \$418 VIA_L1M1_PR_MR
* cell instance $3704 r0 *1 158.01,36.55
X$3704 \$418 VIA_L1M1_PR_MR
* cell instance $3705 r0 *1 169.51,36.55
X$3705 \$418 VIA_L1M1_PR_MR
* cell instance $3706 r0 *1 37.95,98.43
X$3706 \$418 VIA_L1M1_PR_MR
* cell instance $3707 r0 *1 32.43,102.17
X$3707 \$418 VIA_L1M1_PR_MR
* cell instance $3708 r0 *1 32.43,107.61
X$3708 \$418 VIA_L1M1_PR_MR
* cell instance $3709 r0 *1 28.29,107.61
X$3709 \$418 VIA_L1M1_PR_MR
* cell instance $3710 r0 *1 167.21,39.27
X$3710 \$418 VIA_L1M1_PR_MR
* cell instance $3711 r0 *1 160.77,33.49
X$3711 \$418 VIA_L1M1_PR_MR
* cell instance $3712 r0 *1 158.47,39.27
X$3712 \$418 VIA_L1M1_PR_MR
* cell instance $3713 r0 *1 154.33,33.83
X$3713 \$418 VIA_L1M1_PR_MR
* cell instance $3714 r0 *1 165.14,28.9
X$3714 \$421 VIA_M3M4_PR
* cell instance $3715 r0 *1 165.14,55.42
X$3715 \$421 VIA_M3M4_PR
* cell instance $3716 r0 *1 165.37,55.42
X$3716 \$421 VIA_M2M3_PR
* cell instance $3717 r0 *1 165.37,28.9
X$3717 \$421 VIA_M2M3_PR
* cell instance $3718 r0 *1 165.37,55.25
X$3718 \$421 VIA_M1M2_PR
* cell instance $3719 r0 *1 165.37,28.05
X$3719 \$421 VIA_M1M2_PR
* cell instance $3720 r0 *1 165.83,28.05
X$3720 \$421 VIA_L1M1_PR_MR
* cell instance $3721 r0 *1 169.97,55.59
X$3721 \$421 VIA_L1M1_PR_MR
* cell instance $3722 r0 *1 170.43,49.47
X$3722 \$423 VIA_M1M2_PR
* cell instance $3723 r0 *1 168.59,49.47
X$3723 \$423 VIA_M1M2_PR
* cell instance $3724 r0 *1 170.43,53.21
X$3724 \$423 VIA_M1M2_PR
* cell instance $3725 r0 *1 168.13,31.79
X$3725 \$423 VIA_M1M2_PR
* cell instance $3726 r0 *1 165.83,32.13
X$3726 \$423 VIA_M1M2_PR
* cell instance $3727 r0 *1 165.37,30.43
X$3727 \$423 VIA_M1M2_PR
* cell instance $3728 r0 *1 171.81,31.45
X$3728 \$423 VIA_L1M1_PR_MR
* cell instance $3729 r0 *1 158.47,30.43
X$3729 \$423 VIA_L1M1_PR_MR
* cell instance $3730 r0 *1 170.43,53.21
X$3730 \$423 VIA_L1M1_PR_MR
* cell instance $3731 r0 *1 168.59,34.34
X$3731 \$425 VIA_M2M3_PR
* cell instance $3732 r0 *1 134.55,34.34
X$3732 \$425 VIA_M2M3_PR
* cell instance $3733 r0 *1 118.45,241.06
X$3733 \$425 VIA_M2M3_PR
* cell instance $3734 r0 *1 127.65,241.06
X$3734 \$425 VIA_M2M3_PR
* cell instance $3735 r0 *1 117.07,270.81
X$3735 \$425 VIA_M1M2_PR
* cell instance $3736 r0 *1 117.07,270.13
X$3736 \$425 VIA_M1M2_PR
* cell instance $3737 r0 *1 112.01,283.73
X$3737 \$425 VIA_M1M2_PR
* cell instance $3738 r0 *1 112.01,269.79
X$3738 \$425 VIA_M1M2_PR
* cell instance $3739 r0 *1 124.43,270.13
X$3739 \$425 VIA_M1M2_PR
* cell instance $3740 r0 *1 131.33,103.87
X$3740 \$425 VIA_M1M2_PR
* cell instance $3741 r0 *1 131.33,109.65
X$3741 \$425 VIA_M1M2_PR
* cell instance $3742 r0 *1 134.55,103.87
X$3742 \$425 VIA_M1M2_PR
* cell instance $3743 r0 *1 127.65,254.15
X$3743 \$425 VIA_M1M2_PR
* cell instance $3744 r0 *1 124.89,284.07
X$3744 \$425 VIA_M1M2_PR
* cell instance $3745 r0 *1 119.37,224.23
X$3745 \$425 VIA_M1M2_PR
* cell instance $3746 r0 *1 119.37,227.29
X$3746 \$425 VIA_M1M2_PR
* cell instance $3747 r0 *1 118.45,234.43
X$3747 \$425 VIA_M1M2_PR
* cell instance $3748 r0 *1 116.61,221.17
X$3748 \$425 VIA_M1M2_PR
* cell instance $3749 r0 *1 111.55,221.17
X$3749 \$425 VIA_M1M2_PR
* cell instance $3750 r0 *1 111.55,208.25
X$3750 \$425 VIA_M1M2_PR
* cell instance $3751 r0 *1 168.59,33.83
X$3751 \$425 VIA_M1M2_PR
* cell instance $3752 r0 *1 116.61,223.89
X$3752 \$425 VIA_M1M2_PR
* cell instance $3753 r0 *1 124.43,255.17
X$3753 \$425 VIA_M1M2_PR
* cell instance $3754 r0 *1 169.51,25.67
X$3754 \$425 VIA_M1M2_PR
* cell instance $3755 r0 *1 94.53,105.57
X$3755 \$425 VIA_M1M2_PR
* cell instance $3756 r0 *1 94.53,109.31
X$3756 \$425 VIA_M1M2_PR
* cell instance $3757 r0 *1 79.81,107.61
X$3757 \$425 VIA_M1M2_PR
* cell instance $3758 r0 *1 79.81,105.23
X$3758 \$425 VIA_M1M2_PR
* cell instance $3759 r0 *1 27.37,153.17
X$3759 \$425 VIA_M1M2_PR
* cell instance $3760 r0 *1 31.97,152.83
X$3760 \$425 VIA_M1M2_PR
* cell instance $3761 r0 *1 30.59,142.97
X$3761 \$425 VIA_M1M2_PR
* cell instance $3762 r0 *1 27.83,147.73
X$3762 \$425 VIA_M1M2_PR
* cell instance $3763 r0 *1 30.59,145.35
X$3763 \$425 VIA_M1M2_PR
* cell instance $3764 r0 *1 27.83,145.35
X$3764 \$425 VIA_M1M2_PR
* cell instance $3765 r0 *1 32.43,142.97
X$3765 \$425 VIA_M1M2_PR
* cell instance $3766 r0 *1 31.97,156.57
X$3766 \$425 VIA_M1M2_PR
* cell instance $3767 r0 *1 112.01,199.41
X$3767 \$425 VIA_M1M2_PR
* cell instance $3768 r0 *1 32.43,105.57
X$3768 \$425 VIA_M1M2_PR
* cell instance $3769 r0 *1 131.33,194.65
X$3769 \$425 VIA_M1M2_PR
* cell instance $3770 r0 *1 114.31,195.33
X$3770 \$425 VIA_M1M2_PR
* cell instance $3771 r0 *1 114.31,199.41
X$3771 \$425 VIA_M1M2_PR
* cell instance $3772 r0 *1 26.91,145.35
X$3772 \$425 VIA_L1M1_PR_MR
* cell instance $3773 r0 *1 28.75,147.73
X$3773 \$425 VIA_L1M1_PR_MR
* cell instance $3774 r0 *1 169.51,25.67
X$3774 \$425 VIA_L1M1_PR_MR
* cell instance $3775 r0 *1 31.97,156.57
X$3775 \$425 VIA_L1M1_PR_MR
* cell instance $3776 r0 *1 30.59,142.97
X$3776 \$425 VIA_L1M1_PR_MR
* cell instance $3777 r0 *1 27.37,153.17
X$3777 \$425 VIA_L1M1_PR_MR
* cell instance $3778 r0 *1 116.61,200.09
X$3778 \$425 VIA_L1M1_PR_MR
* cell instance $3779 r0 *1 168.6,33.83
X$3779 \$425 VIA_L1M1_PR_MR
* cell instance $3780 r0 *1 123.51,254.49
X$3780 \$425 VIA_L1M1_PR_MR
* cell instance $3781 r0 *1 119.83,194.65
X$3781 \$425 VIA_L1M1_PR_MR
* cell instance $3782 r0 *1 112.01,283.73
X$3782 \$425 VIA_L1M1_PR_MR
* cell instance $3783 r0 *1 112.47,207.91
X$3783 \$425 VIA_L1M1_PR_MR
* cell instance $3784 r0 *1 116.61,223.89
X$3784 \$425 VIA_L1M1_PR_MR
* cell instance $3785 r0 *1 119.83,234.43
X$3785 \$425 VIA_L1M1_PR_MR
* cell instance $3786 r0 *1 120.29,227.29
X$3786 \$425 VIA_L1M1_PR_MR
* cell instance $3787 r0 *1 130.41,284.07
X$3787 \$425 VIA_L1M1_PR_MR
* cell instance $3788 r0 *1 127.65,255.17
X$3788 \$425 VIA_L1M1_PR_MR
* cell instance $3789 r0 *1 79.81,107.61
X$3789 \$425 VIA_L1M1_PR_MR
* cell instance $3790 r0 *1 82.57,105.57
X$3790 \$425 VIA_L1M1_PR_MR
* cell instance $3791 r0 *1 127.65,254.15
X$3791 \$425 VIA_L1M1_PR_MR
* cell instance $3792 r0 *1 117.07,270.81
X$3792 \$425 VIA_L1M1_PR_MR
* cell instance $3793 r0 *1 172.27,34.85
X$3793 \$427 VIA_M1M2_PR
* cell instance $3794 r0 *1 157.55,41.99
X$3794 \$427 VIA_M1M2_PR
* cell instance $3795 r0 *1 157.55,34.85
X$3795 \$427 VIA_M1M2_PR
* cell instance $3796 r0 *1 157.55,37.23
X$3796 \$427 VIA_M1M2_PR
* cell instance $3797 r0 *1 173.19,28.39
X$3797 \$427 VIA_M1M2_PR
* cell instance $3798 r0 *1 175.49,28.39
X$3798 \$427 VIA_L1M1_PR_MR
* cell instance $3799 r0 *1 157.55,37.23
X$3799 \$427 VIA_L1M1_PR_MR
* cell instance $3800 r0 *1 158.47,41.99
X$3800 \$427 VIA_L1M1_PR_MR
* cell instance $3801 r0 *1 186.07,28.39
X$3801 \$430 VIA_L1M1_PR_MR
* cell instance $3802 r0 *1 181.93,27.71
X$3802 \$430 VIA_L1M1_PR_MR
* cell instance $3803 r0 *1 175.03,33.49
X$3803 \$439 VIA_M1M2_PR
* cell instance $3804 r0 *1 175.03,29.41
X$3804 \$439 VIA_M1M2_PR
* cell instance $3805 r0 *1 186.53,29.41
X$3805 \$439 VIA_L1M1_PR_MR
* cell instance $3806 r0 *1 165.83,33.83
X$3806 \$439 VIA_L1M1_PR_MR
* cell instance $3807 r0 *1 101.89,76.67
X$3807 \$441 VIA_M1M2_PR
* cell instance $3808 r0 *1 101.89,27.71
X$3808 \$441 VIA_M1M2_PR
* cell instance $3809 r0 *1 83.95,26.69
X$3809 \$441 VIA_M1M2_PR
* cell instance $3810 r0 *1 83.95,27.71
X$3810 \$441 VIA_M1M2_PR
* cell instance $3811 r0 *1 83.95,26.69
X$3811 \$441 VIA_L1M1_PR_MR
* cell instance $3812 r0 *1 108.79,76.67
X$3812 \$441 VIA_L1M1_PR_MR
* cell instance $3813 r0 *1 106.95,83.13
X$3813 \$442 VIA_M1M2_PR
* cell instance $3814 r0 *1 106.95,28.05
X$3814 \$442 VIA_M1M2_PR
* cell instance $3815 r0 *1 83.49,26.69
X$3815 \$442 VIA_M1M2_PR
* cell instance $3816 r0 *1 83.49,28.05
X$3816 \$442 VIA_M1M2_PR
* cell instance $3817 r0 *1 83.49,26.69
X$3817 \$442 VIA_L1M1_PR_MR
* cell instance $3818 r0 *1 112.93,83.13
X$3818 \$442 VIA_L1M1_PR_MR
* cell instance $3819 r0 *1 182.39,44.71
X$3819 \$443 VIA_M1M2_PR
* cell instance $3820 r0 *1 182.39,27.71
X$3820 \$443 VIA_M1M2_PR
* cell instance $3821 r0 *1 183.31,27.71
X$3821 \$443 VIA_L1M1_PR_MR
* cell instance $3822 r0 *1 182.39,44.71
X$3822 \$443 VIA_L1M1_PR_MR
* cell instance $3823 r0 *1 166.29,33.83
X$3823 \$476 VIA_M1M2_PR
* cell instance $3824 r0 *1 166.29,29.41
X$3824 \$476 VIA_M1M2_PR
* cell instance $3825 r0 *1 157.55,29.41
X$3825 \$476 VIA_L1M1_PR_MR
* cell instance $3826 r0 *1 166.29,33.83
X$3826 \$476 VIA_L1M1_PR_MR
* cell instance $3827 r0 *1 166.75,36.55
X$3827 \$486 VIA_M1M2_PR
* cell instance $3828 r0 *1 158.01,33.49
X$3828 \$486 VIA_M1M2_PR
* cell instance $3829 r0 *1 158.01,31.11
X$3829 \$486 VIA_M1M2_PR
* cell instance $3830 r0 *1 166.75,31.79
X$3830 \$486 VIA_M1M2_PR
* cell instance $3831 r0 *1 166.75,31.79
X$3831 \$486 VIA_L1M1_PR_MR
* cell instance $3832 r0 *1 165.37,31.11
X$3832 \$486 VIA_L1M1_PR_MR
* cell instance $3833 r0 *1 155.25,33.83
X$3833 \$486 VIA_L1M1_PR_MR
* cell instance $3834 r0 *1 155.71,33.83
X$3834 \$486 VIA_L1M1_PR_MR
* cell instance $3835 r0 *1 156.63,41.65
X$3835 \$489 VIA_M1M2_PR
* cell instance $3836 r0 *1 156.63,31.79
X$3836 \$489 VIA_M1M2_PR
* cell instance $3837 r0 *1 159.39,31.45
X$3837 \$489 VIA_L1M1_PR_MR
* cell instance $3838 r0 *1 156.63,41.65
X$3838 \$489 VIA_L1M1_PR_MR
* cell instance $3839 r0 *1 163.99,52.87
X$3839 \$490 VIA_M1M2_PR
* cell instance $3840 r0 *1 163.99,35.87
X$3840 \$490 VIA_M1M2_PR
* cell instance $3841 r0 *1 161.23,35.87
X$3841 \$490 VIA_M1M2_PR
* cell instance $3842 r0 *1 160.77,31.79
X$3842 \$490 VIA_M1M2_PR
* cell instance $3843 r0 *1 160.77,31.79
X$3843 \$490 VIA_L1M1_PR_MR
* cell instance $3844 r0 *1 165.37,52.87
X$3844 \$490 VIA_L1M1_PR_MR
* cell instance $3845 r0 *1 181.7,41.82
X$3845 \$492 VIA_M3M4_PR
* cell instance $3846 r0 *1 181.7,33.66
X$3846 \$492 VIA_M3M4_PR
* cell instance $3847 r0 *1 162.61,33.66
X$3847 \$492 VIA_M2M3_PR
* cell instance $3848 r0 *1 182.85,41.82
X$3848 \$492 VIA_M2M3_PR
* cell instance $3849 r0 *1 162.61,33.83
X$3849 \$492 VIA_M1M2_PR
* cell instance $3850 r0 *1 182.85,41.65
X$3850 \$492 VIA_M1M2_PR
* cell instance $3851 r0 *1 162.61,33.83
X$3851 \$492 VIA_L1M1_PR_MR
* cell instance $3852 r0 *1 183.315,42.28
X$3852 \$492 VIA_L1M1_PR_MR
* cell instance $3853 r0 *1 173.65,32.3
X$3853 \$501 VIA_M2M3_PR
* cell instance $3854 r0 *1 177.33,32.3
X$3854 \$501 VIA_M2M3_PR
* cell instance $3855 r0 *1 177.33,34.17
X$3855 \$501 VIA_M1M2_PR
* cell instance $3856 r0 *1 173.65,44.71
X$3856 \$501 VIA_M1M2_PR
* cell instance $3857 r0 *1 174.8,44.71
X$3857 \$501 VIA_L1M1_PR_MR
* cell instance $3858 r0 *1 180.09,34.17
X$3858 \$501 VIA_L1M1_PR_MR
* cell instance $3859 r0 *1 177.79,38.59
X$3859 \$504 VIA_M1M2_PR
* cell instance $3860 r0 *1 177.79,26.01
X$3860 \$504 VIA_M1M2_PR
* cell instance $3861 r0 *1 177.79,31.45
X$3861 \$504 VIA_M1M2_PR
* cell instance $3862 r0 *1 177.79,31.45
X$3862 \$504 VIA_L1M1_PR_MR
* cell instance $3863 r0 *1 176.87,38.59
X$3863 \$504 VIA_L1M1_PR_MR
* cell instance $3864 r0 *1 179.17,41.99
X$3864 \$519 VIA_M1M2_PR
* cell instance $3865 r0 *1 169.51,34.17
X$3865 \$519 VIA_M1M2_PR
* cell instance $3866 r0 *1 169.51,35.87
X$3866 \$519 VIA_M1M2_PR
* cell instance $3867 r0 *1 179.17,40.29
X$3867 \$519 VIA_M1M2_PR
* cell instance $3868 r0 *1 176.87,37.57
X$3868 \$519 VIA_M1M2_PR
* cell instance $3869 r0 *1 176.87,40.29
X$3869 \$519 VIA_M1M2_PR
* cell instance $3870 r0 *1 169.51,32.13
X$3870 \$519 VIA_M1M2_PR
* cell instance $3871 r0 *1 171.81,32.13
X$3871 \$519 VIA_M1M2_PR
* cell instance $3872 r0 *1 171.81,14.11
X$3872 \$519 VIA_M1M2_PR
* cell instance $3873 r0 *1 171.81,14.11
X$3873 \$519 VIA_L1M1_PR_MR
* cell instance $3874 r0 *1 164.45,34.51
X$3874 \$519 VIA_L1M1_PR_MR
* cell instance $3875 r0 *1 179.17,41.99
X$3875 \$519 VIA_L1M1_PR_MR
* cell instance $3876 r0 *1 183.31,36.89
X$3876 \$519 VIA_L1M1_PR_MR
* cell instance $3877 r0 *1 171.81,39.27
X$3877 \$521 VIA_M1M2_PR
* cell instance $3878 r0 *1 169.97,37.57
X$3878 \$521 VIA_M1M2_PR
* cell instance $3879 r0 *1 169.97,33.15
X$3879 \$521 VIA_M1M2_PR
* cell instance $3880 r0 *1 169.51,39.27
X$3880 \$521 VIA_M1M2_PR
* cell instance $3881 r0 *1 171.81,37.57
X$3881 \$521 VIA_M1M2_PR
* cell instance $3882 r0 *1 157.09,44.37
X$3882 \$521 VIA_M1M2_PR
* cell instance $3883 r0 *1 169.51,44.37
X$3883 \$521 VIA_M1M2_PR
* cell instance $3884 r0 *1 167.21,53.21
X$3884 \$521 VIA_M1M2_PR
* cell instance $3885 r0 *1 168.13,44.37
X$3885 \$521 VIA_M1M2_PR
* cell instance $3886 r0 *1 157.09,42.33
X$3886 \$521 VIA_M1M2_PR
* cell instance $3887 r0 *1 167.21,53.21
X$3887 \$521 VIA_L1M1_PR_MR
* cell instance $3888 r0 *1 157.09,42.33
X$3888 \$521 VIA_L1M1_PR_MR
* cell instance $3889 r0 *1 171.81,39.27
X$3889 \$521 VIA_L1M1_PR_MR
* cell instance $3890 r0 *1 169.51,33.15
X$3890 \$521 VIA_L1M1_PR_MR
* cell instance $3891 r0 *1 164.91,51.17
X$3891 \$532 VIA_M1M2_PR
* cell instance $3892 r0 *1 161.23,32.13
X$3892 \$532 VIA_M1M2_PR
* cell instance $3893 r0 *1 161.23,31.45
X$3893 \$532 VIA_M1M2_PR
* cell instance $3894 r0 *1 164.91,32.13
X$3894 \$532 VIA_M1M2_PR
* cell instance $3895 r0 *1 161.23,31.45
X$3895 \$532 VIA_L1M1_PR_MR
* cell instance $3896 r0 *1 175.03,51.17
X$3896 \$532 VIA_L1M1_PR_MR
* cell instance $3897 r0 *1 87.63,34.17
X$3897 \$549 VIA_M1M2_PR
* cell instance $3898 r0 *1 87.63,46.75
X$3898 \$549 VIA_M1M2_PR
* cell instance $3899 r0 *1 94.53,47.09
X$3899 \$549 VIA_L1M1_PR_MR
* cell instance $3900 r0 *1 83.95,34.51
X$3900 \$549 VIA_L1M1_PR_MR
* cell instance $3901 r0 *1 172.27,36.89
X$3901 \$554 VIA_M1M2_PR_MR
* cell instance $3902 r0 *1 155.71,35.02
X$3902 \$554 VIA_M2M3_PR
* cell instance $3903 r0 *1 171.81,35.02
X$3903 \$554 VIA_M2M3_PR
* cell instance $3904 r0 *1 171.81,34.17
X$3904 \$554 VIA_M1M2_PR
* cell instance $3905 r0 *1 155.71,36.21
X$3905 \$554 VIA_M1M2_PR
* cell instance $3906 r0 *1 171.81,34.17
X$3906 \$554 VIA_L1M1_PR_MR
* cell instance $3907 r0 *1 155.25,36.21
X$3907 \$554 VIA_L1M1_PR_MR
* cell instance $3908 r0 *1 155.71,41.31
X$3908 \$556 VIA_M1M2_PR
* cell instance $3909 r0 *1 155.71,40.29
X$3909 \$556 VIA_M1M2_PR
* cell instance $3910 r0 *1 157.09,41.31
X$3910 \$556 VIA_M1M2_PR
* cell instance $3911 r0 *1 157.09,34.85
X$3911 \$556 VIA_M1M2_PR
* cell instance $3912 r0 *1 157.09,38.59
X$3912 \$556 VIA_M1M2_PR
* cell instance $3913 r0 *1 157.09,31.45
X$3913 \$556 VIA_M1M2_PR
* cell instance $3914 r0 *1 157.09,31.45
X$3914 \$556 VIA_L1M1_PR_MR
* cell instance $3915 r0 *1 163.53,39.27
X$3915 \$556 VIA_L1M1_PR_MR
* cell instance $3916 r0 *1 155.71,40.29
X$3916 \$556 VIA_L1M1_PR_MR
* cell instance $3917 r0 *1 154.79,34.85
X$3917 \$556 VIA_L1M1_PR_MR
* cell instance $3918 r0 *1 169.05,34.51
X$3918 \$558 VIA_M1M2_PR
* cell instance $3919 r0 *1 169.05,35.87
X$3919 \$558 VIA_M1M2_PR
* cell instance $3920 r0 *1 163.99,36.89
X$3920 \$558 VIA_L1M1_PR_MR
* cell instance $3921 r0 *1 182.85,34.51
X$3921 \$558 VIA_L1M1_PR_MR
* cell instance $3922 r0 *1 170.66,34.34
X$3922 \$563 VIA_M3M4_PR
* cell instance $3923 r0 *1 170.66,52.7
X$3923 \$563 VIA_M3M4_PR
* cell instance $3924 r0 *1 169.97,52.7
X$3924 \$563 VIA_M2M3_PR
* cell instance $3925 r0 *1 173.19,34.34
X$3925 \$563 VIA_M2M3_PR
* cell instance $3926 r0 *1 169.97,53.21
X$3926 \$563 VIA_M1M2_PR
* cell instance $3927 r0 *1 173.19,31.45
X$3927 \$563 VIA_M1M2_PR
* cell instance $3928 r0 *1 169.97,53.21
X$3928 \$563 VIA_L1M1_PR_MR
* cell instance $3929 r0 *1 169.51,53.21
X$3929 \$563 VIA_L1M1_PR_MR
* cell instance $3930 r0 *1 189.29,34.34
X$3930 \$569 VIA_M2M3_PR
* cell instance $3931 r0 *1 176.87,34.34
X$3931 \$569 VIA_M2M3_PR
* cell instance $3932 r0 *1 176.87,34.17
X$3932 \$569 VIA_M1M2_PR
* cell instance $3933 r0 *1 189.29,45.73
X$3933 \$569 VIA_M1M2_PR
* cell instance $3934 r0 *1 186.53,45.73
X$3934 \$569 VIA_L1M1_PR_MR
* cell instance $3935 r0 *1 176.87,34.17
X$3935 \$569 VIA_L1M1_PR_MR
* cell instance $3936 r0 *1 184.23,47.77
X$3936 \$572 VIA_M1M2_PR
* cell instance $3937 r0 *1 184.23,44.71
X$3937 \$572 VIA_M1M2_PR
* cell instance $3938 r0 *1 177.33,38.93
X$3938 \$572 VIA_M1M2_PR
* cell instance $3939 r0 *1 177.33,36.89
X$3939 \$572 VIA_M1M2_PR
* cell instance $3940 r0 *1 177.79,47.77
X$3940 \$572 VIA_M1M2_PR
* cell instance $3941 r0 *1 177.79,48.45
X$3941 \$572 VIA_M1M2_PR
* cell instance $3942 r0 *1 177.79,52.87
X$3942 \$572 VIA_M1M2_PR
* cell instance $3943 r0 *1 184.23,34.17
X$3943 \$572 VIA_M1M2_PR
* cell instance $3944 r0 *1 184.23,38.93
X$3944 \$572 VIA_M1M2_PR
* cell instance $3945 r0 *1 184.23,43.01
X$3945 \$572 VIA_M1M2_PR
* cell instance $3946 r0 *1 181.01,33.83
X$3946 \$572 VIA_L1M1_PR_MR
* cell instance $3947 r0 *1 180.92,48.11
X$3947 \$572 VIA_L1M1_PR_MR
* cell instance $3948 r0 *1 183.31,44.71
X$3948 \$572 VIA_L1M1_PR_MR
* cell instance $3949 r0 *1 182.39,38.93
X$3949 \$572 VIA_L1M1_PR_MR
* cell instance $3950 r0 *1 185.61,43.01
X$3950 \$572 VIA_L1M1_PR_MR
* cell instance $3951 r0 *1 177.79,47.77
X$3951 \$572 VIA_L1M1_PR_MR
* cell instance $3952 r0 *1 177.79,52.87
X$3952 \$572 VIA_L1M1_PR_MR
* cell instance $3953 r0 *1 184.23,47.77
X$3953 \$572 VIA_L1M1_PR_MR
* cell instance $3954 r0 *1 181.47,45.05
X$3954 \$572 VIA_L1M1_PR_MR
* cell instance $3955 r0 *1 176.87,36.89
X$3955 \$572 VIA_L1M1_PR_MR
* cell instance $3956 r0 *1 171.35,36.89
X$3956 \$589 VIA_M1M2_PR
* cell instance $3957 r0 *1 171.35,33.83
X$3957 \$589 VIA_M1M2_PR
* cell instance $3958 r0 *1 167.21,41.31
X$3958 \$589 VIA_M1M2_PR
* cell instance $3959 r0 *1 167.67,37.23
X$3959 \$589 VIA_M1M2_PR
* cell instance $3960 r0 *1 171.81,52.19
X$3960 \$589 VIA_M1M2_PR
* cell instance $3961 r0 *1 172.27,52.19
X$3961 \$589 VIA_L1M1_PR_MR
* cell instance $3962 r0 *1 171.81,36.89
X$3962 \$589 VIA_L1M1_PR_MR
* cell instance $3963 r0 *1 172.27,33.83
X$3963 \$589 VIA_L1M1_PR_MR
* cell instance $3964 r0 *1 160.31,42.33
X$3964 \$589 VIA_L1M1_PR_MR
* cell instance $3965 r0 *1 100.05,150.11
X$3965 \$591 VIA_M1M2_PR
* cell instance $3966 r0 *1 100.05,33.83
X$3966 \$591 VIA_M1M2_PR
* cell instance $3967 r0 *1 77.97,33.83
X$3967 \$591 VIA_M1M2_PR
* cell instance $3968 r0 *1 77.97,26.35
X$3968 \$591 VIA_M1M2_PR
* cell instance $3969 r0 *1 77.97,26.35
X$3969 \$591 VIA_L1M1_PR_MR
* cell instance $3970 r0 *1 116.61,150.11
X$3970 \$591 VIA_L1M1_PR_MR
* cell instance $3971 r0 *1 73.37,44.03
X$3971 \$593 VIA_M1M2_PR
* cell instance $3972 r0 *1 73.37,34.17
X$3972 \$593 VIA_M1M2_PR
* cell instance $3973 r0 *1 73.37,44.71
X$3973 \$593 VIA_M1M2_PR
* cell instance $3974 r0 *1 70.61,44.03
X$3974 \$593 VIA_M1M2_PR
* cell instance $3975 r0 *1 70.61,46.75
X$3975 \$593 VIA_M1M2_PR
* cell instance $3976 r0 *1 82.11,34.17
X$3976 \$593 VIA_L1M1_PR_MR
* cell instance $3977 r0 *1 73.83,44.71
X$3977 \$593 VIA_L1M1_PR_MR
* cell instance $3978 r0 *1 70.15,46.75
X$3978 \$593 VIA_L1M1_PR_MR
* cell instance $3979 r0 *1 160.31,33.83
X$3979 \$601 VIA_M1M2_PR
* cell instance $3980 r0 *1 162.15,39.27
X$3980 \$601 VIA_M1M2_PR
* cell instance $3981 r0 *1 162.15,36.89
X$3981 \$601 VIA_M1M2_PR
* cell instance $3982 r0 *1 160.31,36.55
X$3982 \$601 VIA_M1M2_PR
* cell instance $3983 r0 *1 161.69,33.83
X$3983 \$601 VIA_L1M1_PR_MR
* cell instance $3984 r0 *1 162.15,39.27
X$3984 \$601 VIA_L1M1_PR_MR
* cell instance $3985 r0 *1 162.61,41.99
X$3985 \$606 VIA_M1M2_PR
* cell instance $3986 r0 *1 161.23,45.73
X$3986 \$606 VIA_M1M2_PR
* cell instance $3987 r0 *1 162.61,45.73
X$3987 \$606 VIA_M1M2_PR
* cell instance $3988 r0 *1 159.39,33.83
X$3988 \$606 VIA_M1M2_PR
* cell instance $3989 r0 *1 159.39,39.27
X$3989 \$606 VIA_M1M2_PR
* cell instance $3990 r0 *1 161.23,39.61
X$3990 \$606 VIA_M1M2_PR
* cell instance $3991 r0 *1 160.31,39.27
X$3991 \$606 VIA_L1M1_PR_MR
* cell instance $3992 r0 *1 161.23,45.73
X$3992 \$606 VIA_L1M1_PR_MR
* cell instance $3993 r0 *1 158.93,33.83
X$3993 \$606 VIA_L1M1_PR_MR
* cell instance $3994 r0 *1 161.69,42.33
X$3994 \$606 VIA_L1M1_PR_MR
* cell instance $3995 r0 *1 152.95,39.95
X$3995 \$606 VIA_L1M1_PR_MR
* cell instance $3996 r0 *1 78.43,44.54
X$3996 \$609 VIA_M2M3_PR
* cell instance $3997 r0 *1 74.29,44.54
X$3997 \$609 VIA_M2M3_PR
* cell instance $3998 r0 *1 71.07,44.54
X$3998 \$609 VIA_M2M3_PR
* cell instance $3999 r0 *1 88.55,41.99
X$3999 \$609 VIA_M1M2_PR
* cell instance $4000 r0 *1 82.57,38.93
X$4000 \$609 VIA_M1M2_PR
* cell instance $4001 r0 *1 88.55,37.57
X$4001 \$609 VIA_M1M2_PR
* cell instance $4002 r0 *1 76.13,39.27
X$4002 \$609 VIA_M1M2_PR
* cell instance $4003 r0 *1 76.13,38.59
X$4003 \$609 VIA_M1M2_PR
* cell instance $4004 r0 *1 82.57,37.57
X$4004 \$609 VIA_M1M2_PR
* cell instance $4005 r0 *1 78.43,44.71
X$4005 \$609 VIA_M1M2_PR
* cell instance $4006 r0 *1 71.07,49.47
X$4006 \$609 VIA_M1M2_PR
* cell instance $4007 r0 *1 71.07,44.71
X$4007 \$609 VIA_M1M2_PR
* cell instance $4008 r0 *1 74.29,39.61
X$4008 \$609 VIA_M1M2_PR
* cell instance $4009 r0 *1 72.45,49.47
X$4009 \$609 VIA_L1M1_PR_MR
* cell instance $4010 r0 *1 78.43,44.71
X$4010 \$609 VIA_L1M1_PR_MR
* cell instance $4011 r0 *1 89.93,42.33
X$4011 \$609 VIA_L1M1_PR_MR
* cell instance $4012 r0 *1 86.71,37.57
X$4012 \$609 VIA_L1M1_PR_MR
* cell instance $4013 r0 *1 78.89,38.93
X$4013 \$609 VIA_L1M1_PR_MR
* cell instance $4014 r0 *1 76.13,39.27
X$4014 \$609 VIA_L1M1_PR_MR
* cell instance $4015 r0 *1 71.07,44.71
X$4015 \$609 VIA_L1M1_PR_MR
* cell instance $4016 r0 *1 181.01,37.57
X$4016 \$627 VIA_M1M2_PR
* cell instance $4017 r0 *1 181.01,39.27
X$4017 \$627 VIA_M1M2_PR
* cell instance $4018 r0 *1 181.01,37.57
X$4018 \$627 VIA_L1M1_PR_MR
* cell instance $4019 r0 *1 181.01,39.27
X$4019 \$627 VIA_L1M1_PR_MR
* cell instance $4020 r0 *1 188.37,37.74
X$4020 \$631 VIA_M2M3_PR
* cell instance $4021 r0 *1 176.41,39.1
X$4021 \$631 VIA_M2M3_PR
* cell instance $4022 r0 *1 176.41,37.23
X$4022 \$631 VIA_M1M2_PR
* cell instance $4023 r0 *1 188.37,38.93
X$4023 \$631 VIA_M1M2_PR
* cell instance $4024 r0 *1 188.37,38.93
X$4024 \$631 VIA_L1M1_PR_MR
* cell instance $4025 r0 *1 179.17,37.23
X$4025 \$631 VIA_L1M1_PR_MR
* cell instance $4026 r0 *1 184.69,50.49
X$4026 \$635 VIA_M1M2_PR
* cell instance $4027 r0 *1 184.69,36.21
X$4027 \$635 VIA_M1M2_PR
* cell instance $4028 r0 *1 175.03,50.15
X$4028 \$635 VIA_L1M1_PR_MR
* cell instance $4029 r0 *1 186.07,36.21
X$4029 \$635 VIA_L1M1_PR_MR
* cell instance $4030 r0 *1 79.81,37.23
X$4030 \$643 VIA_M1M2_PR
* cell instance $4031 r0 *1 79.81,44.03
X$4031 \$643 VIA_M1M2_PR
* cell instance $4032 r0 *1 82.57,44.03
X$4032 \$643 VIA_L1M1_PR_MR
* cell instance $4033 r0 *1 79.35,37.23
X$4033 \$643 VIA_L1M1_PR_MR
* cell instance $4034 r0 *1 166.29,41.99
X$4034 \$645 VIA_M1M2_PR
* cell instance $4035 r0 *1 166.29,37.23
X$4035 \$645 VIA_M1M2_PR
* cell instance $4036 r0 *1 166.29,44.71
X$4036 \$645 VIA_M1M2_PR
* cell instance $4037 r0 *1 166.29,44.71
X$4037 \$645 VIA_L1M1_PR_MR
* cell instance $4038 r0 *1 166.75,37.23
X$4038 \$645 VIA_L1M1_PR_MR
* cell instance $4039 r0 *1 166.29,41.99
X$4039 \$645 VIA_L1M1_PR_MR
* cell instance $4040 r0 *1 160.77,39.95
X$4040 \$653 VIA_M1M2_PR
* cell instance $4041 r0 *1 160.77,41.99
X$4041 \$653 VIA_M1M2_PR
* cell instance $4042 r0 *1 158.93,36.21
X$4042 \$653 VIA_M1M2_PR
* cell instance $4043 r0 *1 161.23,41.99
X$4043 \$653 VIA_L1M1_PR_MR
* cell instance $4044 r0 *1 162.61,39.61
X$4044 \$653 VIA_L1M1_PR_MR
* cell instance $4045 r0 *1 156.17,36.21
X$4045 \$653 VIA_L1M1_PR_MR
* cell instance $4046 r0 *1 161.69,41.14
X$4046 \$654 VIA_M2M3_PR
* cell instance $4047 r0 *1 158.01,41.14
X$4047 \$654 VIA_M2M3_PR
* cell instance $4048 r0 *1 164.45,42.33
X$4048 \$654 VIA_M1M2_PR
* cell instance $4049 r0 *1 162.15,44.71
X$4049 \$654 VIA_M1M2_PR
* cell instance $4050 r0 *1 164.45,44.71
X$4050 \$654 VIA_M1M2_PR
* cell instance $4051 r0 *1 158.01,39.27
X$4051 \$654 VIA_M1M2_PR
* cell instance $4052 r0 *1 158.01,35.87
X$4052 \$654 VIA_M1M2_PR
* cell instance $4053 r0 *1 162.15,42.33
X$4053 \$654 VIA_M1M2_PR
* cell instance $4054 r0 *1 166.75,42.33
X$4054 \$654 VIA_L1M1_PR_MR
* cell instance $4055 r0 *1 157.55,39.27
X$4055 \$654 VIA_L1M1_PR_MR
* cell instance $4056 r0 *1 162.15,42.33
X$4056 \$654 VIA_L1M1_PR_MR
* cell instance $4057 r0 *1 164.45,44.71
X$4057 \$654 VIA_L1M1_PR_MR
* cell instance $4058 r0 *1 152.95,35.87
X$4058 \$654 VIA_L1M1_PR_MR
* cell instance $4059 r0 *1 155.25,38.93
X$4059 \$664 VIA_M1M2_PR
* cell instance $4060 r0 *1 155.25,31.79
X$4060 \$664 VIA_M1M2_PR
* cell instance $4061 r0 *1 155.25,31.79
X$4061 \$664 VIA_L1M1_PR_MR
* cell instance $4062 r0 *1 154.33,39.27
X$4062 \$664 VIA_L1M1_PR_MR
* cell instance $4063 r0 *1 154.79,38.93
X$4063 \$664 VIA_L1M1_PR_MR
* cell instance $4064 r0 *1 165.37,38.93
X$4064 \$665 VIA_L1M1_PR_MR
* cell instance $4065 r0 *1 155.71,38.93
X$4065 \$665 VIA_L1M1_PR_MR
* cell instance $4066 r0 *1 153.41,39.27
X$4066 \$665 VIA_L1M1_PR_MR
* cell instance $4067 r0 *1 169.97,38.93
X$4067 \$668 VIA_M1M2_PR
* cell instance $4068 r0 *1 158.01,44.03
X$4068 \$668 VIA_M1M2_PR
* cell instance $4069 r0 *1 169.51,53.89
X$4069 \$668 VIA_M1M2_PR
* cell instance $4070 r0 *1 169.97,45.05
X$4070 \$668 VIA_M1M2_PR
* cell instance $4071 r0 *1 169.97,44.03
X$4071 \$668 VIA_M1M2_PR
* cell instance $4072 r0 *1 158.01,42.33
X$4072 \$668 VIA_M1M2_PR
* cell instance $4073 r0 *1 166.29,53.21
X$4073 \$668 VIA_L1M1_PR_MR
* cell instance $4074 r0 *1 172.27,45.05
X$4074 \$668 VIA_L1M1_PR_MR
* cell instance $4075 r0 *1 172.73,39.27
X$4075 \$668 VIA_L1M1_PR_MR
* cell instance $4076 r0 *1 158.01,42.33
X$4076 \$668 VIA_L1M1_PR_MR
* cell instance $4077 r0 *1 187.91,37.57
X$4077 \$676 VIA_M1M2_PR
* cell instance $4078 r0 *1 187.91,53.21
X$4078 \$676 VIA_M1M2_PR
* cell instance $4079 r0 *1 184.69,37.57
X$4079 \$676 VIA_L1M1_PR_MR
* cell instance $4080 r0 *1 178.71,53.21
X$4080 \$676 VIA_L1M1_PR_MR
* cell instance $4081 r0 *1 169.05,37.57
X$4081 \$681 VIA_M1M2_PR
* cell instance $4082 r0 *1 169.05,39.61
X$4082 \$681 VIA_M1M2_PR
* cell instance $4083 r0 *1 161.69,37.57
X$4083 \$681 VIA_L1M1_PR_MR
* cell instance $4084 r0 *1 179.17,39.27
X$4084 \$681 VIA_L1M1_PR_MR
* cell instance $4085 r0 *1 160.77,37.57
X$4085 \$684 VIA_M1M2_PR
* cell instance $4086 r0 *1 160.77,39.27
X$4086 \$684 VIA_M1M2_PR
* cell instance $4087 r0 *1 160.31,37.57
X$4087 \$684 VIA_L1M1_PR_MR
* cell instance $4088 r0 *1 160.77,39.27
X$4088 \$684 VIA_L1M1_PR_MR
* cell instance $4089 r0 *1 91.77,46.75
X$4089 \$686 VIA_M1M2_PR
* cell instance $4090 r0 *1 91.77,38.93
X$4090 \$686 VIA_M1M2_PR
* cell instance $4091 r0 *1 89.01,38.93
X$4091 \$686 VIA_L1M1_PR_MR
* cell instance $4092 r0 *1 91.77,46.75
X$4092 \$686 VIA_L1M1_PR_MR
* cell instance $4093 r0 *1 79.81,47.26
X$4093 \$688 VIA_M2M3_PR
* cell instance $4094 r0 *1 74.75,47.26
X$4094 \$688 VIA_M2M3_PR
* cell instance $4095 r0 *1 92.23,42.33
X$4095 \$688 VIA_M1M2_PR
* cell instance $4096 r0 *1 93.61,45.05
X$4096 \$688 VIA_M1M2_PR
* cell instance $4097 r0 *1 93.61,47.77
X$4097 \$688 VIA_M1M2_PR
* cell instance $4098 r0 *1 93.61,51.17
X$4098 \$688 VIA_M1M2_PR
* cell instance $4099 r0 *1 92.23,45.05
X$4099 \$688 VIA_M1M2_PR
* cell instance $4100 r0 *1 79.35,38.59
X$4100 \$688 VIA_M1M2_PR
* cell instance $4101 r0 *1 79.81,50.15
X$4101 \$688 VIA_M1M2_PR
* cell instance $4102 r0 *1 79.81,45.05
X$4102 \$688 VIA_M1M2_PR
* cell instance $4103 r0 *1 74.75,46.75
X$4103 \$688 VIA_M1M2_PR
* cell instance $4104 r0 *1 93.61,47.77
X$4104 \$688 VIA_L1M1_PR_MR
* cell instance $4105 r0 *1 93.15,51.17
X$4105 \$688 VIA_L1M1_PR_MR
* cell instance $4106 r0 *1 91.77,45.05
X$4106 \$688 VIA_L1M1_PR_MR
* cell instance $4107 r0 *1 91.77,42.33
X$4107 \$688 VIA_L1M1_PR_MR
* cell instance $4108 r0 *1 78.43,38.59
X$4108 \$688 VIA_L1M1_PR_MR
* cell instance $4109 r0 *1 81.65,50.15
X$4109 \$688 VIA_L1M1_PR_MR
* cell instance $4110 r0 *1 71.07,46.75
X$4110 \$688 VIA_L1M1_PR_MR
* cell instance $4111 r0 *1 92.69,49.81
X$4111 \$689 VIA_M1M2_PR
* cell instance $4112 r0 *1 92.69,47.77
X$4112 \$689 VIA_M1M2_PR
* cell instance $4113 r0 *1 92.69,42.33
X$4113 \$689 VIA_M1M2_PR
* cell instance $4114 r0 *1 82.11,39.61
X$4114 \$689 VIA_M1M2_PR
* cell instance $4115 r0 *1 82.57,48.45
X$4115 \$689 VIA_M1M2_PR
* cell instance $4116 r0 *1 72.45,48.11
X$4116 \$689 VIA_M1M2_PR
* cell instance $4117 r0 *1 72.45,38.93
X$4117 \$689 VIA_M1M2_PR
* cell instance $4118 r0 *1 83.03,52.87
X$4118 \$689 VIA_M1M2_PR
* cell instance $4119 r0 *1 92.69,47.77
X$4119 \$689 VIA_L1M1_PR_MR
* cell instance $4120 r0 *1 84.41,52.87
X$4120 \$689 VIA_L1M1_PR_MR
* cell instance $4121 r0 *1 94.07,49.81
X$4121 \$689 VIA_L1M1_PR_MR
* cell instance $4122 r0 *1 90.85,48.11
X$4122 \$689 VIA_L1M1_PR_MR
* cell instance $4123 r0 *1 92.69,42.33
X$4123 \$689 VIA_L1M1_PR_MR
* cell instance $4124 r0 *1 81.65,39.61
X$4124 \$689 VIA_L1M1_PR_MR
* cell instance $4125 r0 *1 77.51,38.93
X$4125 \$689 VIA_L1M1_PR_MR
* cell instance $4126 r0 *1 77.51,39.61
X$4126 \$689 VIA_L1M1_PR_MR
* cell instance $4127 r0 *1 71.99,48.11
X$4127 \$689 VIA_L1M1_PR_MR
* cell instance $4128 r0 *1 80.5,120.7
X$4128 \$692 VIA_M3M4_PR
* cell instance $4129 r0 *1 80.5,40.46
X$4129 \$692 VIA_M3M4_PR
* cell instance $4130 r0 *1 93.61,120.7
X$4130 \$692 VIA_M2M3_PR
* cell instance $4131 r0 *1 80.27,40.46
X$4131 \$692 VIA_M2M3_PR
* cell instance $4132 r0 *1 171.35,269.79
X$4132 \$692 VIA_M1M2_PR
* cell instance $4133 r0 *1 171.35,266.05
X$4133 \$692 VIA_M1M2_PR
* cell instance $4134 r0 *1 171.35,267.07
X$4134 \$692 VIA_M1M2_PR
* cell instance $4135 r0 *1 94.99,264.35
X$4135 \$692 VIA_M1M2_PR
* cell instance $4136 r0 *1 80.27,40.29
X$4136 \$692 VIA_M1M2_PR
* cell instance $4137 r0 *1 172.27,270.81
X$4137 \$692 VIA_L1M1_PR_MR
* cell instance $4138 r0 *1 170.89,269.79
X$4138 \$692 VIA_L1M1_PR_MR
* cell instance $4139 r0 *1 171.35,267.07
X$4139 \$692 VIA_L1M1_PR_MR
* cell instance $4140 r0 *1 171.35,266.05
X$4140 \$692 VIA_L1M1_PR_MR
* cell instance $4141 r0 *1 171.35,264.35
X$4141 \$692 VIA_L1M1_PR_MR
* cell instance $4142 r0 *1 170.89,270.81
X$4142 \$692 VIA_L1M1_PR_MR
* cell instance $4143 r0 *1 80.27,40.29
X$4143 \$692 VIA_L1M1_PR_MR
* cell instance $4144 r0 *1 170.43,180.37
X$4144 rst_n VIA_M1M2_PR_MR
* cell instance $4145 r0 *1 175.03,191.25
X$4145 rst_n VIA_M1M2_PR_MR
* cell instance $4146 r0 *1 80.27,150.62
X$4146 rst_n VIA_M2M3_PR
* cell instance $4147 r0 *1 32.43,185.98
X$4147 rst_n VIA_M2M3_PR
* cell instance $4148 r0 *1 69.23,150.62
X$4148 rst_n VIA_M2M3_PR
* cell instance $4149 r0 *1 119.37,272.85
X$4149 rst_n VIA_M1M2_PR
* cell instance $4150 r0 *1 119.37,276.59
X$4150 rst_n VIA_M1M2_PR
* cell instance $4151 r0 *1 123.05,272.85
X$4151 rst_n VIA_M1M2_PR
* cell instance $4152 r0 *1 122.59,109.65
X$4152 rst_n VIA_M1M2_PR
* cell instance $4153 r0 *1 123.97,107.95
X$4153 rst_n VIA_M1M2_PR
* cell instance $4154 r0 *1 127.19,98.77
X$4154 rst_n VIA_M1M2_PR
* cell instance $4155 r0 *1 127.19,97.07
X$4155 rst_n VIA_M1M2_PR
* cell instance $4156 r0 *1 122.59,115.09
X$4156 rst_n VIA_M1M2_PR
* cell instance $4157 r0 *1 122.59,107.95
X$4157 rst_n VIA_M1M2_PR
* cell instance $4158 r0 *1 120.29,283.73
X$4158 rst_n VIA_M1M2_PR
* cell instance $4159 r0 *1 123.05,278.29
X$4159 rst_n VIA_M1M2_PR
* cell instance $4160 r0 *1 123.05,281.69
X$4160 rst_n VIA_M1M2_PR
* cell instance $4161 r0 *1 123.05,284.07
X$4161 rst_n VIA_M1M2_PR
* cell instance $4162 r0 *1 120.29,287.47
X$4162 rst_n VIA_M1M2_PR
* cell instance $4163 r0 *1 123.05,75.31
X$4163 rst_n VIA_M1M2_PR
* cell instance $4164 r0 *1 119.83,75.31
X$4164 rst_n VIA_M1M2_PR
* cell instance $4165 r0 *1 123.05,218.45
X$4165 rst_n VIA_M1M2_PR
* cell instance $4166 r0 *1 123.05,229.67
X$4166 rst_n VIA_M1M2_PR
* cell instance $4167 r0 *1 118.91,216.75
X$4167 rst_n VIA_M1M2_PR
* cell instance $4168 r0 *1 118.91,213.01
X$4168 rst_n VIA_M1M2_PR
* cell instance $4169 r0 *1 118.91,211.31
X$4169 rst_n VIA_M1M2_PR
* cell instance $4170 r0 *1 118.91,207.57
X$4170 rst_n VIA_M1M2_PR
* cell instance $4171 r0 *1 123.05,216.41
X$4171 rst_n VIA_M1M2_PR
* cell instance $4172 r0 *1 118.91,260.27
X$4172 rst_n VIA_M1M2_PR
* cell instance $4173 r0 *1 118.91,256.53
X$4173 rst_n VIA_M1M2_PR
* cell instance $4174 r0 *1 121.21,256.53
X$4174 rst_n VIA_M1M2_PR
* cell instance $4175 r0 *1 118.91,233.07
X$4175 rst_n VIA_M1M2_PR
* cell instance $4176 r0 *1 118.91,238.51
X$4176 rst_n VIA_M1M2_PR
* cell instance $4177 r0 *1 118.91,240.21
X$4177 rst_n VIA_M1M2_PR
* cell instance $4178 r0 *1 118.91,229.33
X$4178 rst_n VIA_M1M2_PR
* cell instance $4179 r0 *1 122.13,245.65
X$4179 rst_n VIA_M1M2_PR
* cell instance $4180 r0 *1 122.13,243.95
X$4180 rst_n VIA_M1M2_PR
* cell instance $4181 r0 *1 121.21,240.21
X$4181 rst_n VIA_M1M2_PR
* cell instance $4182 r0 *1 121.21,243.61
X$4182 rst_n VIA_M1M2_PR
* cell instance $4183 r0 *1 172.73,283.73
X$4183 rst_n VIA_M1M2_PR
* cell instance $4184 r0 *1 172.73,272.85
X$4184 rst_n VIA_M1M2_PR
* cell instance $4185 r0 *1 175.95,282.03
X$4185 rst_n VIA_M1M2_PR
* cell instance $4186 r0 *1 175.95,283.73
X$4186 rst_n VIA_M1M2_PR
* cell instance $4187 r0 *1 120.29,77.01
X$4187 rst_n VIA_M1M2_PR
* cell instance $4188 r0 *1 123.05,77.35
X$4188 rst_n VIA_M1M2_PR
* cell instance $4189 r0 *1 122.13,82.79
X$4189 rst_n VIA_M1M2_PR
* cell instance $4190 r0 *1 123.51,71.23
X$4190 rst_n VIA_M1M2_PR
* cell instance $4191 r0 *1 120.29,80.75
X$4191 rst_n VIA_M1M2_PR
* cell instance $4192 r0 *1 119.83,71.57
X$4192 rst_n VIA_M1M2_PR
* cell instance $4193 r0 *1 123.51,98.77
X$4193 rst_n VIA_M1M2_PR
* cell instance $4194 r0 *1 120.29,97.07
X$4194 rst_n VIA_M1M2_PR
* cell instance $4195 r0 *1 118.91,80.75
X$4195 rst_n VIA_M1M2_PR
* cell instance $4196 r0 *1 118.91,82.45
X$4196 rst_n VIA_M1M2_PR
* cell instance $4197 r0 *1 122.13,92.99
X$4197 rst_n VIA_M1M2_PR
* cell instance $4198 r0 *1 120.29,93.33
X$4198 rst_n VIA_M1M2_PR
* cell instance $4199 r0 *1 123.51,94.01
X$4199 rst_n VIA_M1M2_PR
* cell instance $4200 r0 *1 123.51,49.81
X$4200 rst_n VIA_M1M2_PR
* cell instance $4201 r0 *1 123.51,48.11
X$4201 rst_n VIA_M1M2_PR
* cell instance $4202 r0 *1 118.91,49.81
X$4202 rst_n VIA_M1M2_PR
* cell instance $4203 r0 *1 118.45,44.71
X$4203 rst_n VIA_M1M2_PR
* cell instance $4204 r0 *1 123.51,64.43
X$4204 rst_n VIA_M1M2_PR
* cell instance $4205 r0 *1 93.15,153.17
X$4205 rst_n VIA_M1M2_PR
* cell instance $4206 r0 *1 93.15,151.47
X$4206 rst_n VIA_M1M2_PR
* cell instance $4207 r0 *1 93.15,147.73
X$4207 rst_n VIA_M1M2_PR
* cell instance $4208 r0 *1 93.15,142.29
X$4208 rst_n VIA_M1M2_PR
* cell instance $4209 r0 *1 84.87,151.81
X$4209 rst_n VIA_M1M2_PR
* cell instance $4210 r0 *1 84.87,158.61
X$4210 rst_n VIA_M1M2_PR
* cell instance $4211 r0 *1 84.87,156.57
X$4211 rst_n VIA_M1M2_PR
* cell instance $4212 r0 *1 87.63,158.61
X$4212 rst_n VIA_M1M2_PR
* cell instance $4213 r0 *1 69.23,150.45
X$4213 rst_n VIA_M1M2_PR
* cell instance $4214 r0 *1 174.11,191.25
X$4214 rst_n VIA_M1M2_PR
* cell instance $4215 r0 *1 171.81,189.55
X$4215 rst_n VIA_M1M2_PR
* cell instance $4216 r0 *1 174.11,183.43
X$4216 rst_n VIA_M1M2_PR
* cell instance $4217 r0 *1 178.71,194.99
X$4217 rst_n VIA_M1M2_PR
* cell instance $4218 r0 *1 88.55,98.77
X$4218 rst_n VIA_M1M2_PR
* cell instance $4219 r0 *1 92.69,97.41
X$4219 rst_n VIA_M1M2_PR
* cell instance $4220 r0 *1 92.69,98.77
X$4220 rst_n VIA_M1M2_PR
* cell instance $4221 r0 *1 175.03,197.03
X$4221 rst_n VIA_M1M2_PR
* cell instance $4222 r0 *1 88.55,109.65
X$4222 rst_n VIA_M1M2_PR
* cell instance $4223 r0 *1 175.03,194.99
X$4223 rst_n VIA_M1M2_PR
* cell instance $4224 r0 *1 178.71,200.43
X$4224 rst_n VIA_M1M2_PR
* cell instance $4225 r0 *1 80.27,147.73
X$4225 rst_n VIA_M1M2_PR
* cell instance $4226 r0 *1 82.11,147.73
X$4226 rst_n VIA_M1M2_PR
* cell instance $4227 r0 *1 82.11,145.69
X$4227 rst_n VIA_M1M2_PR
* cell instance $4228 r0 *1 82.11,140.59
X$4228 rst_n VIA_M1M2_PR
* cell instance $4229 r0 *1 80.27,151.13
X$4229 rst_n VIA_M1M2_PR
* cell instance $4230 r0 *1 82.11,135.15
X$4230 rst_n VIA_M1M2_PR
* cell instance $4231 r0 *1 82.11,136.85
X$4231 rst_n VIA_M1M2_PR
* cell instance $4232 r0 *1 32.43,202.47
X$4232 rst_n VIA_M1M2_PR
* cell instance $4233 r0 *1 172.73,178.67
X$4233 rst_n VIA_M1M2_PR
* cell instance $4234 r0 *1 170.43,181.39
X$4234 rst_n VIA_M1M2_PR
* cell instance $4235 r0 *1 172.73,180.37
X$4235 rst_n VIA_M1M2_PR
* cell instance $4236 r0 *1 174.11,180.37
X$4236 rst_n VIA_M1M2_PR
* cell instance $4237 r0 *1 34.73,146.03
X$4237 rst_n VIA_M1M2_PR
* cell instance $4238 r0 *1 160.77,182.75
X$4238 rst_n VIA_M1M2_PR
* cell instance $4239 r0 *1 34.73,147.73
X$4239 rst_n VIA_M1M2_PR
* cell instance $4240 r0 *1 87.63,164.05
X$4240 rst_n VIA_M1M2_PR
* cell instance $4241 r0 *1 171.81,191.25
X$4241 rst_n VIA_M1M2_PR
* cell instance $4242 r0 *1 36.11,158.95
X$4242 rst_n VIA_M1M2_PR
* cell instance $4243 r0 *1 34.73,151.13
X$4243 rst_n VIA_M1M2_PR
* cell instance $4244 r0 *1 36.11,151.13
X$4244 rst_n VIA_M1M2_PR
* cell instance $4245 r0 *1 41.17,147.73
X$4245 rst_n VIA_M1M2_PR
* cell instance $4246 r0 *1 41.17,150.45
X$4246 rst_n VIA_M1M2_PR
* cell instance $4247 r0 *1 160.77,181.39
X$4247 rst_n VIA_M1M2_PR
* cell instance $4248 r0 *1 32.89,158.61
X$4248 rst_n VIA_M1M2_PR
* cell instance $4249 r0 *1 119.37,150.11
X$4249 rst_n VIA_M1M2_PR
* cell instance $4250 r0 *1 88.55,49.81
X$4250 rst_n VIA_M1M2_PR
* cell instance $4251 r0 *1 83.03,39.61
X$4251 rst_n VIA_M1M2_PR
* cell instance $4252 r0 *1 83.03,37.23
X$4252 rst_n VIA_M1M2_PR
* cell instance $4253 r0 *1 83.03,43.01
X$4253 rst_n VIA_M1M2_PR
* cell instance $4254 r0 *1 37.49,109.65
X$4254 rst_n VIA_M1M2_PR
* cell instance $4255 r0 *1 35.65,109.65
X$4255 rst_n VIA_M1M2_PR
* cell instance $4256 r0 *1 119.37,147.73
X$4256 rst_n VIA_M1M2_PR
* cell instance $4257 r0 *1 119.37,140.59
X$4257 rst_n VIA_M1M2_PR
* cell instance $4258 r0 *1 122.59,146.03
X$4258 rst_n VIA_M1M2_PR
* cell instance $4259 r0 *1 122.59,140.59
X$4259 rst_n VIA_M1M2_PR
* cell instance $4260 r0 *1 122.13,148.07
X$4260 rst_n VIA_M1M2_PR
* cell instance $4261 r0 *1 83.03,47.77
X$4261 rst_n VIA_M1M2_PR
* cell instance $4262 r0 *1 85.79,49.81
X$4262 rst_n VIA_M1M2_PR
* cell instance $4263 r0 *1 122.59,207.57
X$4263 rst_n VIA_M1M2_PR
* cell instance $4264 r0 *1 122.59,206.21
X$4264 rst_n VIA_M1M2_PR
* cell instance $4265 r0 *1 123.05,185.81
X$4265 rst_n VIA_M1M2_PR
* cell instance $4266 r0 *1 123.05,183.09
X$4266 rst_n VIA_M1M2_PR
* cell instance $4267 r0 *1 37.49,104.21
X$4267 rst_n VIA_M1M2_PR
* cell instance $4268 r0 *1 37.03,93.33
X$4268 rst_n VIA_M1M2_PR
* cell instance $4269 r0 *1 37.03,98.77
X$4269 rst_n VIA_M1M2_PR
* cell instance $4270 r0 *1 123.05,124.27
X$4270 rst_n VIA_M1M2_PR
* cell instance $4271 r0 *1 119.37,136.85
X$4271 rst_n VIA_M1M2_PR
* cell instance $4272 r0 *1 122.59,136.85
X$4272 rst_n VIA_M1M2_PR
* cell instance $4273 r0 *1 122.59,135.15
X$4273 rst_n VIA_M1M2_PR
* cell instance $4274 r0 *1 83.49,58.99
X$4274 rst_n VIA_M1M2_PR
* cell instance $4275 r0 *1 83.49,55.59
X$4275 rst_n VIA_M1M2_PR
* cell instance $4276 r0 *1 85.79,48.11
X$4276 rst_n VIA_M1M2_PR
* cell instance $4277 r0 *1 88.55,94.01
X$4277 rst_n VIA_M1M2_PR
* cell instance $4278 r0 *1 88.55,55.25
X$4278 rst_n VIA_M1M2_PR
* cell instance $4279 r0 *1 123.05,129.71
X$4279 rst_n VIA_M1M2_PR
* cell instance $4280 r0 *1 88.09,44.37
X$4280 rst_n VIA_M1M2_PR
* cell instance $4281 r0 *1 163.07,40.29
X$4281 \$702 VIA_M1M2_PR
* cell instance $4282 r0 *1 163.07,42.33
X$4282 \$702 VIA_M1M2_PR
* cell instance $4283 r0 *1 159.85,39.95
X$4283 \$702 VIA_L1M1_PR_MR
* cell instance $4284 r0 *1 163.07,42.33
X$4284 \$702 VIA_L1M1_PR_MR
* cell instance $4285 r0 *1 160.31,44.71
X$4285 \$703 VIA_M1M2_PR
* cell instance $4286 r0 *1 159.39,40.29
X$4286 \$703 VIA_M1M2_PR
* cell instance $4287 r0 *1 156.63,40.29
X$4287 \$703 VIA_L1M1_PR_MR
* cell instance $4288 r0 *1 161.23,44.71
X$4288 \$703 VIA_L1M1_PR_MR
* cell instance $4289 r0 *1 186.07,39.27
X$4289 \$710 VIA_M1M2_PR
* cell instance $4290 r0 *1 186.07,32.13
X$4290 \$710 VIA_M1M2_PR
* cell instance $4291 r0 *1 186.07,32.13
X$4291 \$710 VIA_L1M1_PR_MR
* cell instance $4292 r0 *1 185.145,39.27
X$4292 \$710 VIA_L1M1_PR_MR
* cell instance $4293 r0 *1 185.15,42.33
X$4293 \$711 VIA_M1M2_PR
* cell instance $4294 r0 *1 185.15,40.29
X$4294 \$711 VIA_M1M2_PR
* cell instance $4295 r0 *1 185.15,42.33
X$4295 \$711 VIA_L1M1_PR_MR
* cell instance $4296 r0 *1 185.61,40.29
X$4296 \$711 VIA_L1M1_PR_MR
* cell instance $4297 r0 *1 180.09,45.39
X$4297 \$717 VIA_M1M2_PR
* cell instance $4298 r0 *1 176.87,45.39
X$4298 \$717 VIA_M1M2_PR
* cell instance $4299 r0 *1 180.09,47.77
X$4299 \$717 VIA_M1M2_PR
* cell instance $4300 r0 *1 176.87,42.67
X$4300 \$717 VIA_M1M2_PR
* cell instance $4301 r0 *1 177.79,39.95
X$4301 \$717 VIA_M1M2_PR
* cell instance $4302 r0 *1 172.73,45.39
X$4302 \$717 VIA_M1M2_PR
* cell instance $4303 r0 *1 172.73,48.45
X$4303 \$717 VIA_M1M2_PR
* cell instance $4304 r0 *1 174.11,53.21
X$4304 \$717 VIA_M1M2_PR
* cell instance $4305 r0 *1 172.73,50.15
X$4305 \$717 VIA_M1M2_PR
* cell instance $4306 r0 *1 174.11,50.49
X$4306 \$717 VIA_M1M2_PR
* cell instance $4307 r0 *1 168.125,47.8
X$4307 \$717 VIA_L1M1_PR_MR
* cell instance $4308 r0 *1 172.725,50.15
X$4308 \$717 VIA_L1M1_PR_MR
* cell instance $4309 r0 *1 174.565,53.21
X$4309 \$717 VIA_L1M1_PR_MR
* cell instance $4310 r0 *1 176.87,42.67
X$4310 \$717 VIA_L1M1_PR_MR
* cell instance $4311 r0 *1 178.25,39.95
X$4311 \$717 VIA_L1M1_PR_MR
* cell instance $4312 r0 *1 180.09,47.77
X$4312 \$717 VIA_L1M1_PR_MR
* cell instance $4313 r0 *1 174.57,47.94
X$4313 \$718 VIA_M2M3_PR
* cell instance $4314 r0 *1 177.33,47.94
X$4314 \$718 VIA_M2M3_PR
* cell instance $4315 r0 *1 177.33,48.11
X$4315 \$718 VIA_M1M2_PR
* cell instance $4316 r0 *1 174.57,39.27
X$4316 \$718 VIA_M1M2_PR
* cell instance $4317 r0 *1 169.05,47.77
X$4317 \$718 VIA_L1M1_PR_MR
* cell instance $4318 r0 *1 178.71,39.27
X$4318 \$718 VIA_L1M1_PR_MR
* cell instance $4319 r0 *1 115.23,83.13
X$4319 \$729 VIA_M1M2_PR
* cell instance $4320 r0 *1 115.23,68.85
X$4320 \$729 VIA_M1M2_PR
* cell instance $4321 r0 *1 115.23,71.57
X$4321 \$729 VIA_M1M2_PR
* cell instance $4322 r0 *1 115.23,74.97
X$4322 \$729 VIA_M1M2_PR
* cell instance $4323 r0 *1 112.01,68.85
X$4323 \$729 VIA_M1M2_PR
* cell instance $4324 r0 *1 112.01,64.77
X$4324 \$729 VIA_M1M2_PR
* cell instance $4325 r0 *1 91.31,39.61
X$4325 \$729 VIA_M1M2_PR
* cell instance $4326 r0 *1 91.31,58.31
X$4326 \$729 VIA_M1M2_PR
* cell instance $4327 r0 *1 96.37,71.57
X$4327 \$729 VIA_M1M2_PR
* cell instance $4328 r0 *1 91.31,71.57
X$4328 \$729 VIA_M1M2_PR
* cell instance $4329 r0 *1 96.37,74.63
X$4329 \$729 VIA_M1M2_PR
* cell instance $4330 r0 *1 91.31,55.59
X$4330 \$729 VIA_M1M2_PR
* cell instance $4331 r0 *1 115.23,83.13
X$4331 \$729 VIA_L1M1_PR_MR
* cell instance $4332 r0 *1 115.23,74.97
X$4332 \$729 VIA_L1M1_PR_MR
* cell instance $4333 r0 *1 114.31,64.09
X$4333 \$729 VIA_L1M1_PR_MR
* cell instance $4334 r0 *1 90.39,39.61
X$4334 \$729 VIA_L1M1_PR_MR
* cell instance $4335 r0 *1 90.39,55.59
X$4335 \$729 VIA_L1M1_PR_MR
* cell instance $4336 r0 *1 87.17,58.31
X$4336 \$729 VIA_L1M1_PR_MR
* cell instance $4337 r0 *1 98.21,74.63
X$4337 \$729 VIA_L1M1_PR_MR
* cell instance $4338 r0 *1 98.21,71.57
X$4338 \$729 VIA_L1M1_PR_MR
* cell instance $4339 r0 *1 75.67,48.11
X$4339 \$730 VIA_M1M2_PR
* cell instance $4340 r0 *1 76.59,39.27
X$4340 \$730 VIA_M1M2_PR
* cell instance $4341 r0 *1 76.59,41.31
X$4341 \$730 VIA_M1M2_PR
* cell instance $4342 r0 *1 75.67,48.11
X$4342 \$730 VIA_L1M1_PR_MR
* cell instance $4343 r0 *1 79.35,39.27
X$4343 \$730 VIA_L1M1_PR_MR
* cell instance $4344 r0 *1 88.09,41.65
X$4344 \$730 VIA_L1M1_PR_MR
* cell instance $4345 r0 *1 84.87,41.99
X$4345 \$734 VIA_L1M1_PR_MR
* cell instance $4346 r0 *1 74.29,42.33
X$4346 \$734 VIA_L1M1_PR_MR
* cell instance $4347 r0 *1 128.34,237.66
X$4347 \$737 VIA_M3M4_PR
* cell instance $4348 r0 *1 128.34,42.5
X$4348 \$737 VIA_M3M4_PR
* cell instance $4349 r0 *1 163.07,237.66
X$4349 \$737 VIA_M2M3_PR
* cell instance $4350 r0 *1 89.47,42.5
X$4350 \$737 VIA_M2M3_PR
* cell instance $4351 r0 *1 163.07,252.11
X$4351 \$737 VIA_M1M2_PR
* cell instance $4352 r0 *1 164.91,252.11
X$4352 \$737 VIA_M1M2_PR
* cell instance $4353 r0 *1 164.91,256.87
X$4353 \$737 VIA_M1M2_PR
* cell instance $4354 r0 *1 163.07,245.65
X$4354 \$737 VIA_M1M2_PR
* cell instance $4355 r0 *1 89.47,42.33
X$4355 \$737 VIA_M1M2_PR
* cell instance $4356 r0 *1 164.45,245.99
X$4356 \$737 VIA_L1M1_PR_MR
* cell instance $4357 r0 *1 165.83,251.43
X$4357 \$737 VIA_L1M1_PR_MR
* cell instance $4358 r0 *1 165.37,256.87
X$4358 \$737 VIA_L1M1_PR_MR
* cell instance $4359 r0 *1 89.47,42.33
X$4359 \$737 VIA_L1M1_PR_MR
* cell instance $4360 r0 *1 188.83,41.14
X$4360 O[6] VIA_M2M3_PR
* cell instance $4361 r0 *1 108.79,250.75
X$4361 O[6] VIA_M1M2_PR
* cell instance $4362 r0 *1 188.83,58.99
X$4362 O[6] VIA_M1M2_PR
* cell instance $4363 r0 *1 123.05,249.73
X$4363 O[6] VIA_M1M2_PR
* cell instance $4364 r0 *1 123.05,250.75
X$4364 O[6] VIA_M1M2_PR
* cell instance $4365 r0 *1 108.79,57.97
X$4365 O[6] VIA_M1M2_PR
* cell instance $4366 r0 *1 167.21,249.73
X$4366 O[6] VIA_L1M1_PR_MR
* cell instance $4367 r0 *1 185.61,60.35
X$4367 \$760 VIA_M1M2_PR
* cell instance $4368 r0 *1 185.61,41.99
X$4368 \$760 VIA_M1M2_PR
* cell instance $4369 r0 *1 121.67,84.83
X$4369 \$760 VIA_M1M2_PR
* cell instance $4370 r0 *1 121.67,69.53
X$4370 \$760 VIA_M1M2_PR
* cell instance $4371 r0 *1 121.21,72.25
X$4371 \$760 VIA_M1M2_PR
* cell instance $4372 r0 *1 112.47,101.83
X$4372 \$760 VIA_M1M2_PR
* cell instance $4373 r0 *1 121.67,87.55
X$4373 \$760 VIA_M1M2_PR
* cell instance $4374 r0 *1 112.47,84.83
X$4374 \$760 VIA_M1M2_PR
* cell instance $4375 r0 *1 122.13,58.31
X$4375 \$760 VIA_M1M2_PR
* cell instance $4376 r0 *1 122.13,61.71
X$4376 \$760 VIA_M1M2_PR
* cell instance $4377 r0 *1 112.47,125.63
X$4377 \$760 VIA_M1M2_PR
* cell instance $4378 r0 *1 115.23,141.95
X$4378 \$760 VIA_M1M2_PR
* cell instance $4379 r0 *1 115.69,131.07
X$4379 \$760 VIA_M1M2_PR
* cell instance $4380 r0 *1 115.23,125.63
X$4380 \$760 VIA_M1M2_PR
* cell instance $4381 r0 *1 121.67,61.03
X$4381 \$760 VIA_L1M1_PR_MR
* cell instance $4382 r0 *1 122.13,61.03
X$4382 \$760 VIA_L1M1_PR_MR
* cell instance $4383 r0 *1 122.59,60.35
X$4383 \$760 VIA_L1M1_PR_MR
* cell instance $4384 r0 *1 122.13,61.71
X$4384 \$760 VIA_L1M1_PR_MR
* cell instance $4385 r0 *1 118.91,58.65
X$4385 \$760 VIA_L1M1_PR_MR
* cell instance $4386 r0 *1 116.61,84.83
X$4386 \$760 VIA_L1M1_PR_MR
* cell instance $4387 r0 *1 113.39,71.91
X$4387 \$760 VIA_L1M1_PR_MR
* cell instance $4388 r0 *1 119.83,69.53
X$4388 \$760 VIA_L1M1_PR_MR
* cell instance $4389 r0 *1 116.15,101.83
X$4389 \$760 VIA_L1M1_PR_MR
* cell instance $4390 r0 *1 184.69,41.99
X$4390 \$760 VIA_L1M1_PR_MR
* cell instance $4391 r0 *1 119.37,87.55
X$4391 \$760 VIA_L1M1_PR_MR
* cell instance $4392 r0 *1 121.67,143.65
X$4392 \$760 VIA_L1M1_PR_MR
* cell instance $4393 r0 *1 116.15,142.63
X$4393 \$760 VIA_L1M1_PR_MR
* cell instance $4394 r0 *1 117.07,125.63
X$4394 \$760 VIA_L1M1_PR_MR
* cell instance $4395 r0 *1 119.37,131.07
X$4395 \$760 VIA_L1M1_PR_MR
* cell instance $4396 r0 *1 76.13,41.65
X$4396 \$781 VIA_M1M2_PR
* cell instance $4397 r0 *1 76.13,44.37
X$4397 \$781 VIA_M1M2_PR
* cell instance $4398 r0 *1 68.77,45.05
X$4398 \$781 VIA_M1M2_PR
* cell instance $4399 r0 *1 68.77,46.75
X$4399 \$781 VIA_M1M2_PR
* cell instance $4400 r0 *1 77.51,44.71
X$4400 \$781 VIA_L1M1_PR_MR
* cell instance $4401 r0 *1 76.13,41.65
X$4401 \$781 VIA_L1M1_PR_MR
* cell instance $4402 r0 *1 68.77,46.75
X$4402 \$781 VIA_L1M1_PR_MR
* cell instance $4403 r0 *1 72.91,45.05
X$4403 \$781 VIA_L1M1_PR_MR
* cell instance $4404 r0 *1 75.67,39.27
X$4404 \$782 VIA_M1M2_PR
* cell instance $4405 r0 *1 75.67,43.01
X$4405 \$782 VIA_M1M2_PR
* cell instance $4406 r0 *1 72.91,50.15
X$4406 \$782 VIA_M1M2_PR
* cell instance $4407 r0 *1 72.91,47.77
X$4407 \$782 VIA_M1M2_PR
* cell instance $4408 r0 *1 72.91,43.01
X$4408 \$782 VIA_M1M2_PR
* cell instance $4409 r0 *1 70.15,43.01
X$4409 \$782 VIA_M1M2_PR
* cell instance $4410 r0 *1 70.15,44.71
X$4410 \$782 VIA_M1M2_PR
* cell instance $4411 r0 *1 75.67,39.27
X$4411 \$782 VIA_L1M1_PR_MR
* cell instance $4412 r0 *1 77.51,43.01
X$4412 \$782 VIA_L1M1_PR_MR
* cell instance $4413 r0 *1 71.53,50.15
X$4413 \$782 VIA_L1M1_PR_MR
* cell instance $4414 r0 *1 72.91,47.77
X$4414 \$782 VIA_L1M1_PR_MR
* cell instance $4415 r0 *1 70.15,44.71
X$4415 \$782 VIA_L1M1_PR_MR
* cell instance $4416 r0 *1 77.97,44.37
X$4416 \$785 VIA_M1M2_PR
* cell instance $4417 r0 *1 77.97,46.75
X$4417 \$785 VIA_M1M2_PR
* cell instance $4418 r0 *1 83.95,44.37
X$4418 \$785 VIA_M1M2_PR
* cell instance $4419 r0 *1 83.95,50.49
X$4419 \$785 VIA_M1M2_PR
* cell instance $4420 r0 *1 77.97,36.89
X$4420 \$785 VIA_M1M2_PR
* cell instance $4421 r0 *1 83.95,43.01
X$4421 \$785 VIA_M1M2_PR
* cell instance $4422 r0 *1 83.95,92.99
X$4422 \$785 VIA_M1M2_PR
* cell instance $4423 r0 *1 83.95,77.35
X$4423 \$785 VIA_M1M2_PR
* cell instance $4424 r0 *1 41.63,93.67
X$4424 \$785 VIA_L1M1_PR_MR
* cell instance $4425 r0 *1 86.71,77.35
X$4425 \$785 VIA_L1M1_PR_MR
* cell instance $4426 r0 *1 83.95,77.35
X$4426 \$785 VIA_L1M1_PR_MR
* cell instance $4427 r0 *1 82.11,50.49
X$4427 \$785 VIA_L1M1_PR_MR
* cell instance $4428 r0 *1 76.13,47.77
X$4428 \$785 VIA_L1M1_PR_MR
* cell instance $4429 r0 *1 83.03,44.71
X$4429 \$785 VIA_L1M1_PR_MR
* cell instance $4430 r0 *1 77.97,36.89
X$4430 \$785 VIA_L1M1_PR_MR
* cell instance $4431 r0 *1 86.25,42.33
X$4431 \$785 VIA_L1M1_PR_MR
* cell instance $4432 r0 *1 171.81,42.33
X$4432 \$791 VIA_M1M2_PR
* cell instance $4433 r0 *1 167.21,42.33
X$4433 \$791 VIA_M1M2_PR
* cell instance $4434 r0 *1 159.39,44.71
X$4434 \$791 VIA_M1M2_PR
* cell instance $4435 r0 *1 171.81,47.09
X$4435 \$791 VIA_M1M2_PR
* cell instance $4436 r0 *1 167.21,43.01
X$4436 \$791 VIA_M1M2_PR
* cell instance $4437 r0 *1 159.39,43.01
X$4437 \$791 VIA_M1M2_PR
* cell instance $4438 r0 *1 171.81,47.77
X$4438 \$791 VIA_L1M1_PR_MR
* cell instance $4439 r0 *1 171.81,42.33
X$4439 \$791 VIA_L1M1_PR_MR
* cell instance $4440 r0 *1 159.39,44.71
X$4440 \$791 VIA_L1M1_PR_MR
* cell instance $4441 r0 *1 160.31,43.01
X$4441 \$791 VIA_L1M1_PR_MR
* cell instance $4442 r0 *1 173.19,42.33
X$4442 \$792 VIA_M1M2_PR
* cell instance $4443 r0 *1 159.85,44.71
X$4443 \$792 VIA_M1M2_PR
* cell instance $4444 r0 *1 173.19,47.43
X$4444 \$792 VIA_M1M2_PR
* cell instance $4445 r0 *1 159.85,42.67
X$4445 \$792 VIA_M1M2_PR
* cell instance $4446 r0 *1 173.19,47.43
X$4446 \$792 VIA_L1M1_PR_MR
* cell instance $4447 r0 *1 163.99,42.67
X$4447 \$792 VIA_L1M1_PR_MR
* cell instance $4448 r0 *1 159.85,44.71
X$4448 \$792 VIA_L1M1_PR_MR
* cell instance $4449 r0 *1 183.31,44.03
X$4449 \$796 VIA_L1M1_PR_MR
* cell instance $4450 r0 *1 176.865,44.71
X$4450 \$796 VIA_L1M1_PR_MR
* cell instance $4451 r0 *1 171.35,43.01
X$4451 \$797 VIA_M1M2_PR
* cell instance $4452 r0 *1 171.81,55.59
X$4452 \$797 VIA_M1M2_PR
* cell instance $4453 r0 *1 171.35,47.77
X$4453 \$797 VIA_M1M2_PR
* cell instance $4454 r0 *1 171.81,53.55
X$4454 \$797 VIA_M1M2_PR
* cell instance $4455 r0 *1 171.35,49.81
X$4455 \$797 VIA_M1M2_PR
* cell instance $4456 r0 *1 169.97,47.77
X$4456 \$797 VIA_L1M1_PR_MR
* cell instance $4457 r0 *1 174.57,50.15
X$4457 \$797 VIA_L1M1_PR_MR
* cell instance $4458 r0 *1 170.89,55.59
X$4458 \$797 VIA_L1M1_PR_MR
* cell instance $4459 r0 *1 176.41,53.21
X$4459 \$797 VIA_L1M1_PR_MR
* cell instance $4460 r0 *1 182.39,42.33
X$4460 \$797 VIA_L1M1_PR_MR
* cell instance $4461 r0 *1 170.89,45.22
X$4461 \$804 VIA_M2M3_PR
* cell instance $4462 r0 *1 183.31,45.22
X$4462 \$804 VIA_M2M3_PR
* cell instance $4463 r0 *1 183.31,42.67
X$4463 \$804 VIA_M1M2_PR
* cell instance $4464 r0 *1 170.89,47.09
X$4464 \$804 VIA_M1M2_PR
* cell instance $4465 r0 *1 168.59,47.77
X$4465 \$804 VIA_L1M1_PR_MR
* cell instance $4466 r0 *1 187.45,42.67
X$4466 \$804 VIA_L1M1_PR_MR
* cell instance $4467 r0 *1 186.99,56.27
X$4467 \$805 VIA_M1M2_PR
* cell instance $4468 r0 *1 186.99,42.33
X$4468 \$805 VIA_M1M2_PR
* cell instance $4469 r0 *1 173.19,56.27
X$4469 \$805 VIA_L1M1_PR_MR
* cell instance $4470 r0 *1 186.53,42.33
X$4470 \$805 VIA_L1M1_PR_MR
* cell instance $4471 r0 *1 178.71,43.01
X$4471 \$811 VIA_M1M2_PR
* cell instance $4472 r0 *1 178.71,44.03
X$4472 \$811 VIA_M1M2_PR
* cell instance $4473 r0 *1 180.09,44.03
X$4473 \$811 VIA_L1M1_PR_MR
* cell instance $4474 r0 *1 180.55,43.01
X$4474 \$811 VIA_L1M1_PR_MR
* cell instance $4475 r0 *1 84.41,33.15
X$4475 \$827 VIA_M1M2_PR
* cell instance $4476 r0 *1 84.41,44.37
X$4476 \$827 VIA_M1M2_PR
* cell instance $4477 r0 *1 84.41,44.37
X$4477 \$827 VIA_L1M1_PR_MR
* cell instance $4478 r0 *1 84.41,33.15
X$4478 \$827 VIA_L1M1_PR_MR
* cell instance $4479 r0 *1 77.05,42.33
X$4479 \$831 VIA_M1M2_PR
* cell instance $4480 r0 *1 77.05,39.61
X$4480 \$831 VIA_M1M2_PR
* cell instance $4481 r0 *1 77.05,39.61
X$4481 \$831 VIA_L1M1_PR_MR
* cell instance $4482 r0 *1 76.59,42.33
X$4482 \$831 VIA_L1M1_PR_MR
* cell instance $4483 r0 *1 92.23,45.73
X$4483 \$836 VIA_M1M2_PR
* cell instance $4484 r0 *1 92.23,47.77
X$4484 \$836 VIA_M1M2_PR
* cell instance $4485 r0 *1 83.49,45.73
X$4485 \$836 VIA_M1M2_PR
* cell instance $4486 r0 *1 81.65,52.53
X$4486 \$836 VIA_M1M2_PR
* cell instance $4487 r0 *1 75.21,52.87
X$4487 \$836 VIA_M1M2_PR
* cell instance $4488 r0 *1 74.75,44.71
X$4488 \$836 VIA_M1M2_PR
* cell instance $4489 r0 *1 75.21,50.15
X$4489 \$836 VIA_M1M2_PR
* cell instance $4490 r0 *1 73.83,48.45
X$4490 \$836 VIA_M1M2_PR
* cell instance $4491 r0 *1 73.83,50.15
X$4491 \$836 VIA_M1M2_PR
* cell instance $4492 r0 *1 81.65,61.37
X$4492 \$836 VIA_M1M2_PR
* cell instance $4493 r0 *1 83.49,52.53
X$4493 \$836 VIA_M1M2_PR
* cell instance $4494 r0 *1 92.23,47.77
X$4494 \$836 VIA_L1M1_PR_MR
* cell instance $4495 r0 *1 75.21,50.15
X$4495 \$836 VIA_L1M1_PR_MR
* cell instance $4496 r0 *1 75.67,44.71
X$4496 \$836 VIA_L1M1_PR_MR
* cell instance $4497 r0 *1 80.27,61.03
X$4497 \$836 VIA_L1M1_PR_MR
* cell instance $4498 r0 *1 76.59,53.21
X$4498 \$836 VIA_L1M1_PR_MR
* cell instance $4499 r0 *1 68.31,47.77
X$4499 \$836 VIA_L1M1_PR_MR
* cell instance $4500 r0 *1 71.07,48.45
X$4500 \$836 VIA_L1M1_PR_MR
* cell instance $4501 r0 *1 73.14,53.21
X$4501 \$836 VIA_L1M1_PR_MR
* cell instance $4502 r0 *1 72.91,49.47
X$4502 \$836 VIA_L1M1_PR_MR
* cell instance $4503 r0 *1 78.43,45.73
X$4503 \$837 VIA_M1M2_PR
* cell instance $4504 r0 *1 78.43,49.47
X$4504 \$837 VIA_M1M2_PR
* cell instance $4505 r0 *1 77.97,56.61
X$4505 \$837 VIA_M1M2_PR
* cell instance $4506 r0 *1 93.15,49.47
X$4506 \$837 VIA_L1M1_PR_MR
* cell instance $4507 r0 *1 77.51,56.61
X$4507 \$837 VIA_L1M1_PR_MR
* cell instance $4508 r0 *1 90.85,49.47
X$4508 \$837 VIA_L1M1_PR_MR
* cell instance $4509 r0 *1 78.43,49.47
X$4509 \$837 VIA_L1M1_PR_MR
* cell instance $4510 r0 *1 74.29,44.71
X$4510 \$837 VIA_L1M1_PR_MR
* cell instance $4511 r0 *1 179.63,46.75
X$4511 \$846 VIA_M1M2_PR
* cell instance $4512 r0 *1 179.63,45.05
X$4512 \$846 VIA_M1M2_PR
* cell instance $4513 r0 *1 184.69,46.75
X$4513 \$846 VIA_L1M1_PR_MR
* cell instance $4514 r0 *1 175.95,44.71
X$4514 \$846 VIA_L1M1_PR_MR
* cell instance $4515 r0 *1 175.03,53.21
X$4515 \$856 VIA_M1M2_PR
* cell instance $4516 r0 *1 175.03,45.73
X$4516 \$856 VIA_M1M2_PR
* cell instance $4517 r0 *1 175.03,53.21
X$4517 \$856 VIA_L1M1_PR_MR
* cell instance $4518 r0 *1 178.25,45.73
X$4518 \$856 VIA_L1M1_PR_MR
* cell instance $4519 r0 *1 175.95,50.15
X$4519 \$857 VIA_M1M2_PR
* cell instance $4520 r0 *1 175.95,47.43
X$4520 \$857 VIA_M1M2_PR
* cell instance $4521 r0 *1 177.79,47.09
X$4521 \$857 VIA_M1M2_PR
* cell instance $4522 r0 *1 177.79,44.71
X$4522 \$857 VIA_M1M2_PR
* cell instance $4523 r0 *1 175.95,47.43
X$4523 \$857 VIA_L1M1_PR_MR
* cell instance $4524 r0 *1 177.33,44.71
X$4524 \$857 VIA_L1M1_PR_MR
* cell instance $4525 r0 *1 176.41,47.77
X$4525 \$857 VIA_L1M1_PR_MR
* cell instance $4526 r0 *1 175.95,50.15
X$4526 \$857 VIA_L1M1_PR_MR
* cell instance $4527 r0 *1 173.65,50.15
X$4527 \$859 VIA_M1M2_PR
* cell instance $4528 r0 *1 173.65,45.73
X$4528 \$859 VIA_M1M2_PR
* cell instance $4529 r0 *1 173.65,50.15
X$4529 \$859 VIA_L1M1_PR_MR
* cell instance $4530 r0 *1 174.11,45.73
X$4530 \$859 VIA_L1M1_PR_MR
* cell instance $4531 r0 *1 170.89,43.01
X$4531 \$861 VIA_M1M2_PR
* cell instance $4532 r0 *1 170.89,44.71
X$4532 \$861 VIA_M1M2_PR
* cell instance $4533 r0 *1 165.83,50.15
X$4533 \$861 VIA_M1M2_PR
* cell instance $4534 r0 *1 165.83,45.05
X$4534 \$861 VIA_M1M2_PR
* cell instance $4535 r0 *1 165.83,50.15
X$4535 \$861 VIA_L1M1_PR_MR
* cell instance $4536 r0 *1 168.13,45.05
X$4536 \$861 VIA_L1M1_PR_MR
* cell instance $4537 r0 *1 170.89,44.71
X$4537 \$861 VIA_L1M1_PR_MR
* cell instance $4538 r0 *1 170.89,43.01
X$4538 \$861 VIA_L1M1_PR_MR
* cell instance $4539 r0 *1 81.19,158.1
X$4539 \$864 VIA_M2M3_PR
* cell instance $4540 r0 *1 82.57,158.1
X$4540 \$864 VIA_M2M3_PR
* cell instance $4541 r0 *1 78.43,107.1
X$4541 \$864 VIA_M2M3_PR
* cell instance $4542 r0 *1 82.11,107.1
X$4542 \$864 VIA_M2M3_PR
* cell instance $4543 r0 *1 112.47,251.09
X$4543 \$864 VIA_M1M2_PR
* cell instance $4544 r0 *1 112.47,270.81
X$4544 \$864 VIA_M1M2_PR
* cell instance $4545 r0 *1 135.47,101.49
X$4545 \$864 VIA_M1M2_PR
* cell instance $4546 r0 *1 117.07,105.23
X$4546 \$864 VIA_M1M2_PR
* cell instance $4547 r0 *1 117.07,101.83
X$4547 \$864 VIA_M1M2_PR
* cell instance $4548 r0 *1 112.93,283.39
X$4548 \$864 VIA_M1M2_PR
* cell instance $4549 r0 *1 119.83,226.95
X$4549 \$864 VIA_M1M2_PR
* cell instance $4550 r0 *1 122.59,226.95
X$4550 \$864 VIA_M1M2_PR
* cell instance $4551 r0 *1 122.59,234.43
X$4551 \$864 VIA_M1M2_PR
* cell instance $4552 r0 *1 112.47,208.93
X$4552 \$864 VIA_M1M2_PR
* cell instance $4553 r0 *1 111.09,208.93
X$4553 \$864 VIA_M1M2_PR
* cell instance $4554 r0 *1 111.09,227.29
X$4554 \$864 VIA_M1M2_PR
* cell instance $4555 r0 *1 119.83,224.23
X$4555 \$864 VIA_M1M2_PR
* cell instance $4556 r0 *1 117.07,251.09
X$4556 \$864 VIA_M1M2_PR
* cell instance $4557 r0 *1 120.75,249.73
X$4557 \$864 VIA_M1M2_PR
* cell instance $4558 r0 *1 124.43,253.47
X$4558 \$864 VIA_M1M2_PR
* cell instance $4559 r0 *1 117.07,249.73
X$4559 \$864 VIA_M1M2_PR
* cell instance $4560 r0 *1 165.37,50.15
X$4560 \$864 VIA_M1M2_PR
* cell instance $4561 r0 *1 166.75,44.71
X$4561 \$864 VIA_M1M2_PR
* cell instance $4562 r0 *1 120.75,253.47
X$4562 \$864 VIA_M1M2_PR
* cell instance $4563 r0 *1 120.75,251.09
X$4563 \$864 VIA_M1M2_PR
* cell instance $4564 r0 *1 124.43,254.49
X$4564 \$864 VIA_M1M2_PR
* cell instance $4565 r0 *1 135.47,50.15
X$4565 \$864 VIA_M1M2_PR
* cell instance $4566 r0 *1 81.19,159.97
X$4566 \$864 VIA_M1M2_PR
* cell instance $4567 r0 *1 79.81,108.29
X$4567 \$864 VIA_M1M2_PR
* cell instance $4568 r0 *1 78.43,108.29
X$4568 \$864 VIA_M1M2_PR
* cell instance $4569 r0 *1 78.43,107.61
X$4569 \$864 VIA_M1M2_PR
* cell instance $4570 r0 *1 81.19,132.77
X$4570 \$864 VIA_M1M2_PR
* cell instance $4571 r0 *1 79.81,132.77
X$4571 \$864 VIA_M1M2_PR
* cell instance $4572 r0 *1 31.97,161.67
X$4572 \$864 VIA_M1M2_PR
* cell instance $4573 r0 *1 82.57,162.69
X$4573 \$864 VIA_M1M2_PR
* cell instance $4574 r0 *1 32.43,159.97
X$4574 \$864 VIA_M1M2_PR
* cell instance $4575 r0 *1 31.97,157.25
X$4575 \$864 VIA_M1M2_PR
* cell instance $4576 r0 *1 29.21,156.57
X$4576 \$864 VIA_M1M2_PR
* cell instance $4577 r0 *1 29.21,153.51
X$4577 \$864 VIA_M1M2_PR
* cell instance $4578 r0 *1 112.93,193.97
X$4578 \$864 VIA_M1M2_PR
* cell instance $4579 r0 *1 112.93,162.69
X$4579 \$864 VIA_M1M2_PR
* cell instance $4580 r0 *1 112.93,199.07
X$4580 \$864 VIA_M1M2_PR
* cell instance $4581 r0 *1 82.11,104.89
X$4581 \$864 VIA_M1M2_PR
* cell instance $4582 r0 *1 26.45,153.51
X$4582 \$864 VIA_L1M1_PR_MR
* cell instance $4583 r0 *1 29.21,156.57
X$4583 \$864 VIA_L1M1_PR_MR
* cell instance $4584 r0 *1 37.95,159.63
X$4584 \$864 VIA_L1M1_PR_MR
* cell instance $4585 r0 *1 31.97,161.67
X$4585 \$864 VIA_L1M1_PR_MR
* cell instance $4586 r0 *1 118.45,194.65
X$4586 \$864 VIA_L1M1_PR_MR
* cell instance $4587 r0 *1 115.69,199.07
X$4587 \$864 VIA_L1M1_PR_MR
* cell instance $4588 r0 *1 164.91,50.15
X$4588 \$864 VIA_L1M1_PR_MR
* cell instance $4589 r0 *1 124.43,254.49
X$4589 \$864 VIA_L1M1_PR_MR
* cell instance $4590 r0 *1 168.59,44.71
X$4590 \$864 VIA_L1M1_PR_MR
* cell instance $4591 r0 *1 113.39,208.93
X$4591 \$864 VIA_L1M1_PR_MR
* cell instance $4592 r0 *1 120.29,224.23
X$4592 \$864 VIA_L1M1_PR_MR
* cell instance $4593 r0 *1 120.75,234.77
X$4593 \$864 VIA_L1M1_PR_MR
* cell instance $4594 r0 *1 117.53,227.29
X$4594 \$864 VIA_L1M1_PR_MR
* cell instance $4595 r0 *1 84.87,104.89
X$4595 \$864 VIA_L1M1_PR_MR
* cell instance $4596 r0 *1 129.49,283.39
X$4596 \$864 VIA_L1M1_PR_MR
* cell instance $4597 r0 *1 129.03,254.49
X$4597 \$864 VIA_L1M1_PR_MR
* cell instance $4598 r0 *1 78.89,107.61
X$4598 \$864 VIA_L1M1_PR_MR
* cell instance $4599 r0 *1 113.85,270.81
X$4599 \$864 VIA_L1M1_PR_MR
* cell instance $4600 r0 *1 112.93,283.39
X$4600 \$864 VIA_L1M1_PR_MR
* cell instance $4601 r0 *1 166.29,45.73
X$4601 \$865 VIA_M1M2_PR
* cell instance $4602 r0 *1 166.29,47.77
X$4602 \$865 VIA_M1M2_PR
* cell instance $4603 r0 *1 166.29,50.15
X$4603 \$865 VIA_M1M2_PR
* cell instance $4604 r0 *1 166.29,50.15
X$4604 \$865 VIA_L1M1_PR_MR
* cell instance $4605 r0 *1 163.53,48.11
X$4605 \$865 VIA_L1M1_PR_MR
* cell instance $4606 r0 *1 163.07,45.73
X$4606 \$865 VIA_L1M1_PR_MR
* cell instance $4607 r0 *1 167.21,50.15
X$4607 \$866 VIA_M1M2_PR
* cell instance $4608 r0 *1 167.21,48.11
X$4608 \$866 VIA_M1M2_PR
* cell instance $4609 r0 *1 167.21,45.39
X$4609 \$866 VIA_M1M2_PR
* cell instance $4610 r0 *1 165.37,45.39
X$4610 \$866 VIA_L1M1_PR_MR
* cell instance $4611 r0 *1 168.13,50.15
X$4611 \$866 VIA_L1M1_PR_MR
* cell instance $4612 r0 *1 164.45,48.11
X$4612 \$866 VIA_L1M1_PR_MR
* cell instance $4613 r0 *1 156.17,45.05
X$4613 \$874 VIA_M1M2_PR
* cell instance $4614 r0 *1 156.17,32.13
X$4614 \$874 VIA_M1M2_PR
* cell instance $4615 r0 *1 156.17,32.13
X$4615 \$874 VIA_L1M1_PR_MR
* cell instance $4616 r0 *1 161.69,45.05
X$4616 \$874 VIA_L1M1_PR_MR
* cell instance $4617 r0 *1 122.13,46.75
X$4617 \$879 VIA_M1M2_PR
* cell instance $4618 r0 *1 118.91,46.75
X$4618 \$879 VIA_M1M2_PR
* cell instance $4619 r0 *1 118.91,44.71
X$4619 \$879 VIA_M1M2_PR
* cell instance $4620 r0 *1 122.13,47.43
X$4620 \$879 VIA_M1M2_PR
* cell instance $4621 r0 *1 122.13,52.53
X$4621 \$879 VIA_M1M2_PR
* cell instance $4622 r0 *1 127.19,47.43
X$4622 \$879 VIA_L1M1_PR_MR
* cell instance $4623 r0 *1 122.13,52.53
X$4623 \$879 VIA_L1M1_PR_MR
* cell instance $4624 r0 *1 117.99,47.77
X$4624 \$879 VIA_L1M1_PR_MR
* cell instance $4625 r0 *1 119.37,44.71
X$4625 \$879 VIA_L1M1_PR_MR
* cell instance $4626 r0 *1 73.37,53.89
X$4626 \$880 VIA_M1M2_PR
* cell instance $4627 r0 *1 73.37,45.39
X$4627 \$880 VIA_M1M2_PR
* cell instance $4628 r0 *1 69.23,45.39
X$4628 \$880 VIA_L1M1_PR_MR
* cell instance $4629 r0 *1 73.37,53.89
X$4629 \$880 VIA_L1M1_PR_MR
* cell instance $4630 r0 *1 89.01,53.89
X$4630 \$880 VIA_L1M1_PR_MR
* cell instance $4631 r0 *1 77.05,53.89
X$4631 \$880 VIA_L1M1_PR_MR
* cell instance $4632 r0 *1 119.83,45.73
X$4632 \$882 VIA_M1M2_PR
* cell instance $4633 r0 *1 119.83,47.43
X$4633 \$882 VIA_M1M2_PR
* cell instance $4634 r0 *1 119.83,47.43
X$4634 \$882 VIA_L1M1_PR_MR
* cell instance $4635 r0 *1 118.91,45.73
X$4635 \$882 VIA_L1M1_PR_MR
* cell instance $4636 r0 *1 82.57,45.39
X$4636 \$888 VIA_M1M2_PR
* cell instance $4637 r0 *1 82.57,47.09
X$4637 \$888 VIA_M1M2_PR
* cell instance $4638 r0 *1 76.13,45.39
X$4638 \$888 VIA_L1M1_PR_MR
* cell instance $4639 r0 *1 89.55,47.43
X$4639 \$888 VIA_L1M1_PR_MR
* cell instance $4640 r0 *1 117.99,45.05
X$4640 \$895 VIA_M1M2_PR
* cell instance $4641 r0 *1 117.99,52.19
X$4641 \$895 VIA_M1M2_PR
* cell instance $4642 r0 *1 117.99,47.09
X$4642 \$895 VIA_M1M2_PR
* cell instance $4643 r0 *1 117.99,45.05
X$4643 \$895 VIA_L1M1_PR_MR
* cell instance $4644 r0 *1 117.53,47.09
X$4644 \$895 VIA_L1M1_PR_MR
* cell instance $4645 r0 *1 117.99,52.19
X$4645 \$895 VIA_L1M1_PR_MR
* cell instance $4646 r0 *1 118.22,113.22
X$4646 \$899 VIA_M3M4_PR
* cell instance $4647 r0 *1 118.22,89.42
X$4647 \$899 VIA_M3M4_PR
* cell instance $4648 r0 *1 118.22,102.34
X$4648 \$899 VIA_M3M4_PR
* cell instance $4649 r0 *1 118.45,89.42
X$4649 \$899 VIA_M2M3_PR
* cell instance $4650 r0 *1 119.37,102.34
X$4650 \$899 VIA_M2M3_PR
* cell instance $4651 r0 *1 117.99,113.22
X$4651 \$899 VIA_M2M3_PR
* cell instance $4652 r0 *1 118.45,88.23
X$4652 \$899 VIA_M1M2_PR
* cell instance $4653 r0 *1 119.37,72.93
X$4653 \$899 VIA_M1M2_PR
* cell instance $4654 r0 *1 118.91,70.21
X$4654 \$899 VIA_M1M2_PR
* cell instance $4655 r0 *1 119.37,102.17
X$4655 \$899 VIA_M1M2_PR
* cell instance $4656 r0 *1 117.99,85.85
X$4656 \$899 VIA_M1M2_PR
* cell instance $4657 r0 *1 123.05,46.75
X$4657 \$899 VIA_M1M2_PR
* cell instance $4658 r0 *1 118.45,69.19
X$4658 \$899 VIA_M1M2_PR
* cell instance $4659 r0 *1 118.45,61.71
X$4659 \$899 VIA_M1M2_PR
* cell instance $4660 r0 *1 123.05,58.65
X$4660 \$899 VIA_M1M2_PR
* cell instance $4661 r0 *1 123.05,60.69
X$4661 \$899 VIA_M1M2_PR
* cell instance $4662 r0 *1 118.45,142.29
X$4662 \$899 VIA_M1M2_PR
* cell instance $4663 r0 *1 117.53,131.75
X$4663 \$899 VIA_M1M2_PR
* cell instance $4664 r0 *1 117.99,125.97
X$4664 \$899 VIA_M1M2_PR
* cell instance $4665 r0 *1 111.55,71.91
X$4665 \$899 VIA_L1M1_PR_MR
* cell instance $4666 r0 *1 119.83,61.03
X$4666 \$899 VIA_L1M1_PR_MR
* cell instance $4667 r0 *1 120.29,58.65
X$4667 \$899 VIA_L1M1_PR_MR
* cell instance $4668 r0 *1 119.37,69.53
X$4668 \$899 VIA_L1M1_PR_MR
* cell instance $4669 r0 *1 119.37,70.21
X$4669 \$899 VIA_L1M1_PR_MR
* cell instance $4670 r0 *1 166.75,47.09
X$4670 \$899 VIA_L1M1_PR_MR
* cell instance $4671 r0 *1 119.37,102.17
X$4671 \$899 VIA_L1M1_PR_MR
* cell instance $4672 r0 *1 116.61,85.85
X$4672 \$899 VIA_L1M1_PR_MR
* cell instance $4673 r0 *1 116.15,88.23
X$4673 \$899 VIA_L1M1_PR_MR
* cell instance $4674 r0 *1 119.37,141.95
X$4674 \$899 VIA_L1M1_PR_MR
* cell instance $4675 r0 *1 122.13,142.63
X$4675 \$899 VIA_L1M1_PR_MR
* cell instance $4676 r0 *1 116.15,131.75
X$4676 \$899 VIA_L1M1_PR_MR
* cell instance $4677 r0 *1 117.53,125.97
X$4677 \$899 VIA_L1M1_PR_MR
* cell instance $4678 r0 *1 178.71,52.53
X$4678 \$907 VIA_M1M2_PR
* cell instance $4679 r0 *1 178.71,46.75
X$4679 \$907 VIA_M1M2_PR
* cell instance $4680 r0 *1 175.49,53.21
X$4680 \$907 VIA_L1M1_PR_MR
* cell instance $4681 r0 *1 179.17,46.75
X$4681 \$907 VIA_L1M1_PR_MR
* cell instance $4682 r0 *1 74.29,47.09
X$4682 \$920 VIA_M1M2_PR
* cell instance $4683 r0 *1 71.99,47.09
X$4683 \$920 VIA_M1M2_PR
* cell instance $4684 r0 *1 74.29,49.81
X$4684 \$920 VIA_M1M2_PR
* cell instance $4685 r0 *1 71.99,45.73
X$4685 \$920 VIA_M1M2_PR
* cell instance $4686 r0 *1 83.49,49.81
X$4686 \$920 VIA_L1M1_PR_MR
* cell instance $4687 r0 *1 71.99,45.73
X$4687 \$920 VIA_L1M1_PR_MR
* cell instance $4688 r0 *1 79.35,50.15
X$4688 \$929 VIA_M1M2_PR
* cell instance $4689 r0 *1 79.35,48.45
X$4689 \$929 VIA_M1M2_PR
* cell instance $4690 r0 *1 79.81,52.53
X$4690 \$929 VIA_M1M2_PR
* cell instance $4691 r0 *1 79.35,47.43
X$4691 \$929 VIA_M1M2_PR
* cell instance $4692 r0 *1 74.29,52.53
X$4692 \$929 VIA_M1M2_PR
* cell instance $4693 r0 *1 74.29,53.21
X$4693 \$929 VIA_M1M2_PR
* cell instance $4694 r0 *1 84.87,47.43
X$4694 \$929 VIA_L1M1_PR_MR
* cell instance $4695 r0 *1 77.97,52.53
X$4695 \$929 VIA_L1M1_PR_MR
* cell instance $4696 r0 *1 78.89,50.15
X$4696 \$929 VIA_L1M1_PR_MR
* cell instance $4697 r0 *1 74.29,53.21
X$4697 \$929 VIA_L1M1_PR_MR
* cell instance $4698 r0 *1 74.29,47.77
X$4698 \$929 VIA_L1M1_PR_MR
* cell instance $4699 r0 *1 160.31,192.1
X$4699 \$933 VIA_M2M3_PR
* cell instance $4700 r0 *1 154.33,192.1
X$4700 \$933 VIA_M2M3_PR
* cell instance $4701 r0 *1 117.99,276.42
X$4701 \$933 VIA_M2M3_PR
* cell instance $4702 r0 *1 116.61,276.42
X$4702 \$933 VIA_M2M3_PR
* cell instance $4703 r0 *1 127.19,276.42
X$4703 \$933 VIA_M2M3_PR
* cell instance $4704 r0 *1 112.47,278.46
X$4704 \$933 VIA_M2M3_PR
* cell instance $4705 r0 *1 111.55,278.46
X$4705 \$933 VIA_M2M3_PR
* cell instance $4706 r0 *1 116.61,278.29
X$4706 \$933 VIA_M1M2_PR
* cell instance $4707 r0 *1 117.99,267.75
X$4707 \$933 VIA_M1M2_PR
* cell instance $4708 r0 *1 111.55,287.13
X$4708 \$933 VIA_M1M2_PR
* cell instance $4709 r0 *1 118.45,222.53
X$4709 \$933 VIA_M1M2_PR
* cell instance $4710 r0 *1 112.47,277.95
X$4710 \$933 VIA_M1M2_PR
* cell instance $4711 r0 *1 114.77,107.27
X$4711 \$933 VIA_M1M2_PR
* cell instance $4712 r0 *1 125.35,79.39
X$4712 \$933 VIA_M1M2_PR
* cell instance $4713 r0 *1 125.35,75.65
X$4713 \$933 VIA_M1M2_PR
* cell instance $4714 r0 *1 115.69,105.57
X$4714 \$933 VIA_M1M2_PR
* cell instance $4715 r0 *1 114.77,105.57
X$4715 \$933 VIA_M1M2_PR
* cell instance $4716 r0 *1 127.19,282.37
X$4716 \$933 VIA_M1M2_PR
* cell instance $4717 r0 *1 127.65,287.81
X$4717 \$933 VIA_M1M2_PR
* cell instance $4718 r0 *1 122.13,234.77
X$4718 \$933 VIA_M1M2_PR
* cell instance $4719 r0 *1 122.13,216.75
X$4719 \$933 VIA_M1M2_PR
* cell instance $4720 r0 *1 123.51,216.75
X$4720 \$933 VIA_M1M2_PR
* cell instance $4721 r0 *1 118.45,226.27
X$4721 \$933 VIA_M1M2_PR
* cell instance $4722 r0 *1 122.13,222.53
X$4722 \$933 VIA_M1M2_PR
* cell instance $4723 r0 *1 122.13,226.27
X$4723 \$933 VIA_M1M2_PR
* cell instance $4724 r0 *1 117.99,254.49
X$4724 \$933 VIA_M1M2_PR
* cell instance $4725 r0 *1 117.99,256.19
X$4725 \$933 VIA_M1M2_PR
* cell instance $4726 r0 *1 117.99,261.63
X$4726 \$933 VIA_M1M2_PR
* cell instance $4727 r0 *1 124.89,238.85
X$4727 \$933 VIA_M1M2_PR
* cell instance $4728 r0 *1 124.89,235.79
X$4728 \$933 VIA_M1M2_PR
* cell instance $4729 r0 *1 123.97,250.75
X$4729 \$933 VIA_M1M2_PR
* cell instance $4730 r0 *1 123.97,256.19
X$4730 \$933 VIA_M1M2_PR
* cell instance $4731 r0 *1 112.93,69.53
X$4731 \$933 VIA_M1M2_PR
* cell instance $4732 r0 *1 112.93,54.91
X$4732 \$933 VIA_M1M2_PR
* cell instance $4733 r0 *1 112.93,61.03
X$4733 \$933 VIA_M1M2_PR
* cell instance $4734 r0 *1 111.09,107.27
X$4734 \$933 VIA_M1M2_PR
* cell instance $4735 r0 *1 111.55,97.41
X$4735 \$933 VIA_M1M2_PR
* cell instance $4736 r0 *1 111.55,90.61
X$4736 \$933 VIA_M1M2_PR
* cell instance $4737 r0 *1 115.69,103.87
X$4737 \$933 VIA_M1M2_PR
* cell instance $4738 r0 *1 111.55,91.29
X$4738 \$933 VIA_M1M2_PR
* cell instance $4739 r0 *1 111.09,79.39
X$4739 \$933 VIA_M1M2_PR
* cell instance $4740 r0 *1 110.63,91.29
X$4740 \$933 VIA_M1M2_PR
* cell instance $4741 r0 *1 111.09,77.69
X$4741 \$933 VIA_M1M2_PR
* cell instance $4742 r0 *1 116.61,53.21
X$4742 \$933 VIA_M1M2_PR
* cell instance $4743 r0 *1 116.61,54.91
X$4743 \$933 VIA_M1M2_PR
* cell instance $4744 r0 *1 163.53,205.87
X$4744 \$933 VIA_M1M2_PR
* cell instance $4745 r0 *1 111.09,69.19
X$4745 \$933 VIA_M1M2_PR
* cell instance $4746 r0 *1 91.31,145.35
X$4746 \$933 VIA_M1M2_PR
* cell instance $4747 r0 *1 91.31,156.57
X$4747 \$933 VIA_M1M2_PR
* cell instance $4748 r0 *1 187.91,170.17
X$4748 \$933 VIA_M1M2_PR
* cell instance $4749 r0 *1 190.67,180.37
X$4749 \$933 VIA_M1M2_PR
* cell instance $4750 r0 *1 187.91,180.37
X$4750 \$933 VIA_M1M2_PR
* cell instance $4751 r0 *1 91.31,154.53
X$4751 \$933 VIA_M1M2_PR
* cell instance $4752 r0 *1 71.07,153.17
X$4752 \$933 VIA_M1M2_PR
* cell instance $4753 r0 *1 68.77,151.81
X$4753 \$933 VIA_M1M2_PR
* cell instance $4754 r0 *1 71.07,157.25
X$4754 \$933 VIA_M1M2_PR
* cell instance $4755 r0 *1 69.69,142.97
X$4755 \$933 VIA_M1M2_PR
* cell instance $4756 r0 *1 69.69,145.35
X$4756 \$933 VIA_M1M2_PR
* cell instance $4757 r0 *1 69.69,148.41
X$4757 \$933 VIA_M1M2_PR
* cell instance $4758 r0 *1 163.53,200.77
X$4758 \$933 VIA_M1M2_PR
* cell instance $4759 r0 *1 163.53,197.03
X$4759 \$933 VIA_M1M2_PR
* cell instance $4760 r0 *1 76.13,107.27
X$4760 \$933 VIA_M1M2_PR
* cell instance $4761 r0 *1 76.13,97.07
X$4761 \$933 VIA_M1M2_PR
* cell instance $4762 r0 *1 76.13,99.11
X$4762 \$933 VIA_M1M2_PR
* cell instance $4763 r0 *1 76.13,104.55
X$4763 \$933 VIA_M1M2_PR
* cell instance $4764 r0 *1 190.67,184.11
X$4764 \$933 VIA_M1M2_PR
* cell instance $4765 r0 *1 190.67,191.25
X$4765 \$933 VIA_M1M2_PR
* cell instance $4766 r0 *1 78.43,142.97
X$4766 \$933 VIA_M1M2_PR
* cell instance $4767 r0 *1 80.73,159.29
X$4767 \$933 VIA_M1M2_PR
* cell instance $4768 r0 *1 80.73,153.85
X$4768 \$933 VIA_M1M2_PR
* cell instance $4769 r0 *1 76.13,137.53
X$4769 \$933 VIA_M1M2_PR
* cell instance $4770 r0 *1 78.43,137.53
X$4770 \$933 VIA_M1M2_PR
* cell instance $4771 r0 *1 173.65,170.17
X$4771 \$933 VIA_M1M2_PR
* cell instance $4772 r0 *1 172.27,164.39
X$4772 \$933 VIA_M1M2_PR
* cell instance $4773 r0 *1 173.65,167.11
X$4773 \$933 VIA_M1M2_PR
* cell instance $4774 r0 *1 172.27,166.43
X$4774 \$933 VIA_M1M2_PR
* cell instance $4775 r0 *1 172.27,167.11
X$4775 \$933 VIA_M1M2_PR
* cell instance $4776 r0 *1 33.35,205.53
X$4776 \$933 VIA_M1M2_PR
* cell instance $4777 r0 *1 33.35,200.77
X$4777 \$933 VIA_M1M2_PR
* cell instance $4778 r0 *1 33.35,162.01
X$4778 \$933 VIA_M1M2_PR
* cell instance $4779 r0 *1 33.35,149.09
X$4779 \$933 VIA_M1M2_PR
* cell instance $4780 r0 *1 154.33,185.81
X$4780 \$933 VIA_M1M2_PR
* cell instance $4781 r0 *1 154.33,194.65
X$4781 \$933 VIA_M1M2_PR
* cell instance $4782 r0 *1 154.33,200.09
X$4782 \$933 VIA_M1M2_PR
* cell instance $4783 r0 *1 154.33,197.03
X$4783 \$933 VIA_M1M2_PR
* cell instance $4784 r0 *1 80.73,161.33
X$4784 \$933 VIA_M1M2_PR
* cell instance $4785 r0 *1 160.31,194.31
X$4785 \$933 VIA_M1M2_PR
* cell instance $4786 r0 *1 39.33,151.81
X$4786 \$933 VIA_M1M2_PR
* cell instance $4787 r0 *1 39.33,150.79
X$4787 \$933 VIA_M1M2_PR
* cell instance $4788 r0 *1 162.15,166.43
X$4788 \$933 VIA_M1M2_PR
* cell instance $4789 r0 *1 39.33,153.17
X$4789 \$933 VIA_M1M2_PR
* cell instance $4790 r0 *1 162.15,174.59
X$4790 \$933 VIA_M1M2_PR
* cell instance $4791 r0 *1 154.33,174.93
X$4791 \$933 VIA_M1M2_PR
* cell instance $4792 r0 *1 33.35,153.51
X$4792 \$933 VIA_M1M2_PR
* cell instance $4793 r0 *1 160.31,191.59
X$4793 \$933 VIA_M1M2_PR
* cell instance $4794 r0 *1 33.35,156.57
X$4794 \$933 VIA_M1M2_PR
* cell instance $4795 r0 *1 91.77,48.45
X$4795 \$933 VIA_M1M2_PR
* cell instance $4796 r0 *1 118.91,151.81
X$4796 \$933 VIA_M1M2_PR
* cell instance $4797 r0 *1 115.23,151.81
X$4797 \$933 VIA_M1M2_PR
* cell instance $4798 r0 *1 112.93,141.95
X$4798 \$933 VIA_M1M2_PR
* cell instance $4799 r0 *1 112.93,145.01
X$4799 \$933 VIA_M1M2_PR
* cell instance $4800 r0 *1 112.93,137.87
X$4800 \$933 VIA_M1M2_PR
* cell instance $4801 r0 *1 111.09,132.43
X$4801 \$933 VIA_M1M2_PR
* cell instance $4802 r0 *1 111.09,118.49
X$4802 \$933 VIA_M1M2_PR
* cell instance $4803 r0 *1 111.09,137.53
X$4803 \$933 VIA_M1M2_PR
* cell instance $4804 r0 *1 111.09,131.07
X$4804 \$933 VIA_M1M2_PR
* cell instance $4805 r0 *1 115.23,145.69
X$4805 \$933 VIA_M1M2_PR
* cell instance $4806 r0 *1 28.29,102.85
X$4806 \$933 VIA_M1M2_PR
* cell instance $4807 r0 *1 28.29,100.13
X$4807 \$933 VIA_M1M2_PR
* cell instance $4808 r0 *1 123.51,200.09
X$4808 \$933 VIA_M1M2_PR
* cell instance $4809 r0 *1 118.91,191.59
X$4809 \$933 VIA_M1M2_PR
* cell instance $4810 r0 *1 118.91,200.09
X$4810 \$933 VIA_M1M2_PR
* cell instance $4811 r0 *1 28.29,95.71
X$4811 \$933 VIA_M1M2_PR
* cell instance $4812 r0 *1 116.15,137.87
X$4812 \$933 VIA_M1M2_PR
* cell instance $4813 r0 *1 116.15,134.81
X$4813 \$933 VIA_M1M2_PR
* cell instance $4814 r0 *1 114.77,118.49
X$4814 \$933 VIA_M1M2_PR
* cell instance $4815 r0 *1 116.61,120.87
X$4815 \$933 VIA_M1M2_PR
* cell instance $4816 r0 *1 116.61,118.49
X$4816 \$933 VIA_M1M2_PR
* cell instance $4817 r0 *1 120.29,131.07
X$4817 \$933 VIA_M1M2_PR
* cell instance $4818 r0 *1 120.29,132.43
X$4818 \$933 VIA_M1M2_PR
* cell instance $4819 r0 *1 79.35,60.69
X$4819 \$933 VIA_M1M2_PR
* cell instance $4820 r0 *1 79.35,55.59
X$4820 \$933 VIA_M1M2_PR
* cell instance $4821 r0 *1 91.77,61.03
X$4821 \$933 VIA_M1M2_PR
* cell instance $4822 r0 *1 72.45,157.25
X$4822 \$933 VIA_L1M1_PR_MR
* cell instance $4823 r0 *1 162.61,194.65
X$4823 \$933 VIA_L1M1_PR_MR
* cell instance $4824 r0 *1 71.07,142.97
X$4824 \$933 VIA_L1M1_PR_MR
* cell instance $4825 r0 *1 29.21,148.07
X$4825 \$933 VIA_L1M1_PR_MR
* cell instance $4826 r0 *1 71.07,145.35
X$4826 \$933 VIA_L1M1_PR_MR
* cell instance $4827 r0 *1 70.15,148.41
X$4827 \$933 VIA_L1M1_PR_MR
* cell instance $4828 r0 *1 163.99,200.77
X$4828 \$933 VIA_L1M1_PR_MR
* cell instance $4829 r0 *1 161.69,197.03
X$4829 \$933 VIA_L1M1_PR_MR
* cell instance $4830 r0 *1 155.25,185.81
X$4830 \$933 VIA_L1M1_PR_MR
* cell instance $4831 r0 *1 76.13,161.67
X$4831 \$933 VIA_L1M1_PR_MR
* cell instance $4832 r0 *1 155.71,194.65
X$4832 \$933 VIA_L1M1_PR_MR
* cell instance $4833 r0 *1 117.53,53.21
X$4833 \$933 VIA_L1M1_PR_MR
* cell instance $4834 r0 *1 168.59,205.53
X$4834 \$933 VIA_L1M1_PR_MR
* cell instance $4835 r0 *1 82.11,161.67
X$4835 \$933 VIA_L1M1_PR_MR
* cell instance $4836 r0 *1 112.93,61.03
X$4836 \$933 VIA_L1M1_PR_MR
* cell instance $4837 r0 *1 79.35,142.97
X$4837 \$933 VIA_L1M1_PR_MR
* cell instance $4838 r0 *1 112.93,69.53
X$4838 \$933 VIA_L1M1_PR_MR
* cell instance $4839 r0 *1 80.73,153.85
X$4839 \$933 VIA_L1M1_PR_MR
* cell instance $4840 r0 *1 80.73,159.29
X$4840 \$933 VIA_L1M1_PR_MR
* cell instance $4841 r0 *1 186.07,180.37
X$4841 \$933 VIA_L1M1_PR_MR
* cell instance $4842 r0 *1 78.89,153.85
X$4842 \$933 VIA_L1M1_PR_MR
* cell instance $4843 r0 *1 117.53,91.29
X$4843 \$933 VIA_L1M1_PR_MR
* cell instance $4844 r0 *1 78.43,137.53
X$4844 \$933 VIA_L1M1_PR_MR
* cell instance $4845 r0 *1 186.53,184.11
X$4845 \$933 VIA_L1M1_PR_MR
* cell instance $4846 r0 *1 186.07,191.25
X$4846 \$933 VIA_L1M1_PR_MR
* cell instance $4847 r0 *1 116.61,54.91
X$4847 \$933 VIA_L1M1_PR_MR
* cell instance $4848 r0 *1 177.33,169.83
X$4848 \$933 VIA_L1M1_PR_MR
* cell instance $4849 r0 *1 89.01,156.23
X$4849 \$933 VIA_L1M1_PR_MR
* cell instance $4850 r0 *1 91.31,145.35
X$4850 \$933 VIA_L1M1_PR_MR
* cell instance $4851 r0 *1 167.67,205.53
X$4851 \$933 VIA_L1M1_PR_MR
* cell instance $4852 r0 *1 33.35,162.01
X$4852 \$933 VIA_L1M1_PR_MR
* cell instance $4853 r0 *1 160.31,191.59
X$4853 \$933 VIA_L1M1_PR_MR
* cell instance $4854 r0 *1 36.57,153.51
X$4854 \$933 VIA_L1M1_PR_MR
* cell instance $4855 r0 *1 161.23,174.93
X$4855 \$933 VIA_L1M1_PR_MR
* cell instance $4856 r0 *1 39.33,150.79
X$4856 \$933 VIA_L1M1_PR_MR
* cell instance $4857 r0 *1 33.35,156.57
X$4857 \$933 VIA_L1M1_PR_MR
* cell instance $4858 r0 *1 33.35,153.51
X$4858 \$933 VIA_L1M1_PR_MR
* cell instance $4859 r0 *1 25.99,147.73
X$4859 \$933 VIA_L1M1_PR_MR
* cell instance $4860 r0 *1 31.97,205.53
X$4860 \$933 VIA_L1M1_PR_MR
* cell instance $4861 r0 *1 173.19,167.11
X$4861 \$933 VIA_L1M1_PR_MR
* cell instance $4862 r0 *1 30.59,200.77
X$4862 \$933 VIA_L1M1_PR_MR
* cell instance $4863 r0 *1 172.27,164.39
X$4863 \$933 VIA_L1M1_PR_MR
* cell instance $4864 r0 *1 113.39,256.87
X$4864 \$933 VIA_L1M1_PR_MR
* cell instance $4865 r0 *1 122.31,191.59
X$4865 \$933 VIA_L1M1_PR_MR
* cell instance $4866 r0 *1 117.99,191.59
X$4866 \$933 VIA_L1M1_PR_MR
* cell instance $4867 r0 *1 29.21,95.71
X$4867 \$933 VIA_L1M1_PR_MR
* cell instance $4868 r0 *1 123.97,250.75
X$4868 \$933 VIA_L1M1_PR_MR
* cell instance $4869 r0 *1 118.91,200.09
X$4869 \$933 VIA_L1M1_PR_MR
* cell instance $4870 r0 *1 117.99,254.49
X$4870 \$933 VIA_L1M1_PR_MR
* cell instance $4871 r0 *1 40.71,99.11
X$4871 \$933 VIA_L1M1_PR_MR
* cell instance $4872 r0 *1 110.63,287.13
X$4872 \$933 VIA_L1M1_PR_MR
* cell instance $4873 r0 *1 88.55,48.11
X$4873 \$933 VIA_L1M1_PR_MR
* cell instance $4874 r0 *1 27.37,102.85
X$4874 \$933 VIA_L1M1_PR_MR
* cell instance $4875 r0 *1 27.37,98.43
X$4875 \$933 VIA_L1M1_PR_MR
* cell instance $4876 r0 *1 118.91,261.63
X$4876 \$933 VIA_L1M1_PR_MR
* cell instance $4877 r0 *1 117.99,221.85
X$4877 \$933 VIA_L1M1_PR_MR
* cell instance $4878 r0 *1 122.13,222.53
X$4878 \$933 VIA_L1M1_PR_MR
* cell instance $4879 r0 *1 125.35,131.75
X$4879 \$933 VIA_L1M1_PR_MR
* cell instance $4880 r0 *1 124.89,238.85
X$4880 \$933 VIA_L1M1_PR_MR
* cell instance $4881 r0 *1 114.31,235.11
X$4881 \$933 VIA_L1M1_PR_MR
* cell instance $4882 r0 *1 115.23,103.87
X$4882 \$933 VIA_L1M1_PR_MR
* cell instance $4883 r0 *1 115.23,107.61
X$4883 \$933 VIA_L1M1_PR_MR
* cell instance $4884 r0 *1 127.19,282.37
X$4884 \$933 VIA_L1M1_PR_MR
* cell instance $4885 r0 *1 112.93,77.35
X$4885 \$933 VIA_L1M1_PR_MR
* cell instance $4886 r0 *1 125.35,216.41
X$4886 \$933 VIA_L1M1_PR_MR
* cell instance $4887 r0 *1 125.35,235.11
X$4887 \$933 VIA_L1M1_PR_MR
* cell instance $4888 r0 *1 128.11,287.81
X$4888 \$933 VIA_L1M1_PR_MR
* cell instance $4889 r0 *1 126.27,75.65
X$4889 \$933 VIA_L1M1_PR_MR
* cell instance $4890 r0 *1 85.33,107.61
X$4890 \$933 VIA_L1M1_PR_MR
* cell instance $4891 r0 *1 111.55,91.29
X$4891 \$933 VIA_L1M1_PR_MR
* cell instance $4892 r0 *1 111.55,97.41
X$4892 \$933 VIA_L1M1_PR_MR
* cell instance $4893 r0 *1 76.13,104.55
X$4893 \$933 VIA_L1M1_PR_MR
* cell instance $4894 r0 *1 81.65,97.41
X$4894 \$933 VIA_L1M1_PR_MR
* cell instance $4895 r0 *1 111.09,131.07
X$4895 \$933 VIA_L1M1_PR_MR
* cell instance $4896 r0 *1 79.12,55.59
X$4896 \$933 VIA_L1M1_PR_MR
* cell instance $4897 r0 *1 117.99,267.75
X$4897 \$933 VIA_L1M1_PR_MR
* cell instance $4898 r0 *1 115.23,145.69
X$4898 \$933 VIA_L1M1_PR_MR
* cell instance $4899 r0 *1 114.31,141.95
X$4899 \$933 VIA_L1M1_PR_MR
* cell instance $4900 r0 *1 116.15,134.81
X$4900 \$933 VIA_L1M1_PR_MR
* cell instance $4901 r0 *1 116.61,120.87
X$4901 \$933 VIA_L1M1_PR_MR
* cell instance $4902 r0 *1 117.53,119.17
X$4902 \$933 VIA_L1M1_PR_MR
* cell instance $4903 r0 *1 113.39,278.63
X$4903 \$933 VIA_L1M1_PR_MR
* cell instance $4904 r0 *1 81.65,60.69
X$4904 \$933 VIA_L1M1_PR_MR
* cell instance $4905 r0 *1 182.85,47.77
X$4905 \$954 VIA_M1M2_PR
* cell instance $4906 r0 *1 182.85,42.33
X$4906 \$954 VIA_M1M2_PR
* cell instance $4907 r0 *1 182.85,42.33
X$4907 \$954 VIA_L1M1_PR_MR
* cell instance $4908 r0 *1 182.85,47.77
X$4908 \$954 VIA_L1M1_PR_MR
* cell instance $4909 r0 *1 178.25,47.77
X$4909 \$956 VIA_M1M2_PR
* cell instance $4910 r0 *1 178.25,20.57
X$4910 \$956 VIA_M1M2_PR
* cell instance $4911 r0 *1 178.25,20.57
X$4911 \$956 VIA_L1M1_PR_MR
* cell instance $4912 r0 *1 178.25,47.77
X$4912 \$956 VIA_L1M1_PR_MR
* cell instance $4913 r0 *1 116.61,48.45
X$4913 \$966 VIA_M1M2_PR
* cell instance $4914 r0 *1 116.61,49.81
X$4914 \$966 VIA_M1M2_PR
* cell instance $4915 r0 *1 115.69,48.45
X$4915 \$966 VIA_L1M1_PR_MR
* cell instance $4916 r0 *1 116.61,49.81
X$4916 \$966 VIA_L1M1_PR_MR
* cell instance $4917 r0 *1 115.23,47.77
X$4917 \$967 VIA_M1M2_PR
* cell instance $4918 r0 *1 115.23,55.25
X$4918 \$967 VIA_M1M2_PR
* cell instance $4919 r0 *1 116.61,47.77
X$4919 \$967 VIA_L1M1_PR_MR
* cell instance $4920 r0 *1 115.23,55.25
X$4920 \$967 VIA_L1M1_PR_MR
* cell instance $4921 r0 *1 75.67,53.21
X$4921 \$969 VIA_M1M2_PR
* cell instance $4922 r0 *1 75.67,51.17
X$4922 \$969 VIA_M1M2_PR
* cell instance $4923 r0 *1 69.69,47.77
X$4923 \$969 VIA_M1M2_PR
* cell instance $4924 r0 *1 69.69,50.49
X$4924 \$969 VIA_M1M2_PR
* cell instance $4925 r0 *1 73.37,50.15
X$4925 \$969 VIA_L1M1_PR_MR
* cell instance $4926 r0 *1 76.13,53.21
X$4926 \$969 VIA_L1M1_PR_MR
* cell instance $4927 r0 *1 92.23,51.17
X$4927 \$969 VIA_L1M1_PR_MR
* cell instance $4928 r0 *1 68.77,47.77
X$4928 \$969 VIA_L1M1_PR_MR
* cell instance $4929 r0 *1 72.45,53.55
X$4929 \$969 VIA_L1M1_PR_MR
* cell instance $4930 r0 *1 112.47,234.94
X$4930 I VIA_M2M3_PR
* cell instance $4931 r0 *1 124.43,234.94
X$4931 I VIA_M2M3_PR
* cell instance $4932 r0 *1 87.63,53.38
X$4932 I VIA_M2M3_PR
* cell instance $4933 r0 *1 76.59,79.9
X$4933 I VIA_M2M3_PR
* cell instance $4934 r0 *1 83.03,53.38
X$4934 I VIA_M2M3_PR
* cell instance $4935 r0 *1 126.73,75.14
X$4935 I VIA_M2M3_PR
* cell instance $4936 r0 *1 111.55,75.14
X$4936 I VIA_M2M3_PR
* cell instance $4937 r0 *1 114.31,268.09
X$4937 I VIA_M1M2_PR
* cell instance $4938 r0 *1 111.55,254.49
X$4938 I VIA_M1M2_PR
* cell instance $4939 r0 *1 111.55,262.99
X$4939 I VIA_M1M2_PR
* cell instance $4940 r0 *1 111.55,256.87
X$4940 I VIA_M1M2_PR
* cell instance $4941 r0 *1 109.25,268.09
X$4941 I VIA_M1M2_PR
* cell instance $4942 r0 *1 108.79,287.13
X$4942 I VIA_M1M2_PR
* cell instance $4943 r0 *1 108.79,279.31
X$4943 I VIA_M1M2_PR
* cell instance $4944 r0 *1 108.79,281.35
X$4944 I VIA_M1M2_PR
* cell instance $4945 r0 *1 125.35,251.09
X$4945 I VIA_M1M2_PR
* cell instance $4946 r0 *1 125.35,238.85
X$4946 I VIA_M1M2_PR
* cell instance $4947 r0 *1 126.73,75.65
X$4947 I VIA_M1M2_PR
* cell instance $4948 r0 *1 113.85,221.85
X$4948 I VIA_M1M2_PR
* cell instance $4949 r0 *1 128.57,280.67
X$4949 I VIA_M1M2_PR
* cell instance $4950 r0 *1 128.57,287.81
X$4950 I VIA_M1M2_PR
* cell instance $4951 r0 *1 128.57,282.37
X$4951 I VIA_M1M2_PR
* cell instance $4952 r0 *1 118.45,216.07
X$4952 I VIA_M1M2_PR
* cell instance $4953 r0 *1 112.47,235.11
X$4953 I VIA_M1M2_PR
* cell instance $4954 r0 *1 123.97,216.07
X$4954 I VIA_M1M2_PR
* cell instance $4955 r0 *1 123.97,220.83
X$4955 I VIA_M1M2_PR
* cell instance $4956 r0 *1 123.97,222.53
X$4956 I VIA_M1M2_PR
* cell instance $4957 r0 *1 115.23,254.49
X$4957 I VIA_M1M2_PR
* cell instance $4958 r0 *1 115.23,252.45
X$4958 I VIA_M1M2_PR
* cell instance $4959 r0 *1 113.85,220.83
X$4959 I VIA_M1M2_PR
* cell instance $4960 r0 *1 114.31,262.99
X$4960 I VIA_M1M2_PR
* cell instance $4961 r0 *1 124.43,235.11
X$4961 I VIA_M1M2_PR
* cell instance $4962 r0 *1 112.01,103.87
X$4962 I VIA_M1M2_PR
* cell instance $4963 r0 *1 112.01,107.61
X$4963 I VIA_M1M2_PR
* cell instance $4964 r0 *1 110.63,97.41
X$4964 I VIA_M1M2_PR
* cell instance $4965 r0 *1 112.01,98.43
X$4965 I VIA_M1M2_PR
* cell instance $4966 r0 *1 110.63,98.43
X$4966 I VIA_M1M2_PR
* cell instance $4967 r0 *1 110.63,77.35
X$4967 I VIA_M1M2_PR
* cell instance $4968 r0 *1 111.55,77.35
X$4968 I VIA_M1M2_PR
* cell instance $4969 r0 *1 112.01,91.29
X$4969 I VIA_M1M2_PR
* cell instance $4970 r0 *1 115.69,53.21
X$4970 I VIA_M1M2_PR
* cell instance $4971 r0 *1 110.63,60.35
X$4971 I VIA_M1M2_PR
* cell instance $4972 r0 *1 115.69,55.25
X$4972 I VIA_M1M2_PR
* cell instance $4973 r0 *1 113.39,55.59
X$4973 I VIA_M1M2_PR
* cell instance $4974 r0 *1 113.39,60.35
X$4974 I VIA_M1M2_PR
* cell instance $4975 r0 *1 110.63,69.19
X$4975 I VIA_M1M2_PR
* cell instance $4976 r0 *1 177.79,167.79
X$4976 I VIA_M1M2_PR
* cell instance $4977 r0 *1 177.79,169.83
X$4977 I VIA_M1M2_PR
* cell instance $4978 r0 *1 72.91,155.55
X$4978 I VIA_M1M2_PR
* cell instance $4979 r0 *1 72.91,157.25
X$4979 I VIA_M1M2_PR
* cell instance $4980 r0 *1 76.59,109.99
X$4980 I VIA_M1M2_PR
* cell instance $4981 r0 *1 76.59,113.05
X$4981 I VIA_M1M2_PR
* cell instance $4982 r0 *1 122.59,152.83
X$4982 I VIA_M1M2_PR
* cell instance $4983 r0 *1 114.77,141.95
X$4983 I VIA_M1M2_PR
* cell instance $4984 r0 *1 114.77,146.03
X$4984 I VIA_M1M2_PR
* cell instance $4985 r0 *1 114.77,156.23
X$4985 I VIA_M1M2_PR
* cell instance $4986 r0 *1 114.77,152.83
X$4986 I VIA_M1M2_PR
* cell instance $4987 r0 *1 122.59,167.79
X$4987 I VIA_M1M2_PR
* cell instance $4988 r0 *1 112.01,119.17
X$4988 I VIA_M1M2_PR
* cell instance $4989 r0 *1 110.63,119.17
X$4989 I VIA_M1M2_PR
* cell instance $4990 r0 *1 110.63,131.07
X$4990 I VIA_M1M2_PR
* cell instance $4991 r0 *1 122.59,190.91
X$4991 I VIA_M1M2_PR
* cell instance $4992 r0 *1 122.59,192.27
X$4992 I VIA_M1M2_PR
* cell instance $4993 r0 *1 118.45,200.09
X$4993 I VIA_M1M2_PR
* cell instance $4994 r0 *1 118.45,192.27
X$4994 I VIA_M1M2_PR
* cell instance $4995 r0 *1 114.77,135.49
X$4995 I VIA_M1M2_PR
* cell instance $4996 r0 *1 115.23,120.87
X$4996 I VIA_M1M2_PR
* cell instance $4997 r0 *1 115.23,119.17
X$4997 I VIA_M1M2_PR
* cell instance $4998 r0 *1 80.27,60.35
X$4998 I VIA_M1M2_PR
* cell instance $4999 r0 *1 82.57,55.59
X$4999 I VIA_M1M2_PR
* cell instance $5000 r0 *1 123.97,134.47
X$5000 I VIA_M1M2_PR
* cell instance $5001 r0 *1 110.63,133.79
X$5001 I VIA_M1M2_PR
* cell instance $5002 r0 *1 79.81,55.59
X$5002 I VIA_M1M2_PR
* cell instance $5003 r0 *1 76.59,62.05
X$5003 I VIA_M1M2_PR
* cell instance $5004 r0 *1 80.27,61.71
X$5004 I VIA_M1M2_PR
* cell instance $5005 r0 *1 123.97,131.75
X$5005 I VIA_M1M2_PR
* cell instance $5006 r0 *1 87.63,48.45
X$5006 I VIA_M1M2_PR
* cell instance $5007 r0 *1 111.55,69.53
X$5007 I VIA_L1M1_PR_MR
* cell instance $5008 r0 *1 116.15,53.21
X$5008 I VIA_L1M1_PR_MR
* cell instance $5009 r0 *1 117.07,54.91
X$5009 I VIA_L1M1_PR_MR
* cell instance $5010 r0 *1 72.91,157.25
X$5010 I VIA_L1M1_PR_MR
* cell instance $5011 r0 *1 113.85,61.03
X$5011 I VIA_L1M1_PR_MR
* cell instance $5012 r0 *1 179.17,169.83
X$5012 I VIA_L1M1_PR_MR
* cell instance $5013 r0 *1 175.95,167.45
X$5013 I VIA_L1M1_PR_MR
* cell instance $5014 r0 *1 89.47,156.23
X$5014 I VIA_L1M1_PR_MR
* cell instance $5015 r0 *1 118.45,200.09
X$5015 I VIA_L1M1_PR_MR
* cell instance $5016 r0 *1 122.59,190.91
X$5016 I VIA_L1M1_PR_MR
* cell instance $5017 r0 *1 116.15,191.59
X$5017 I VIA_L1M1_PR_MR
* cell instance $5018 r0 *1 119.37,261.63
X$5018 I VIA_L1M1_PR_MR
* cell instance $5019 r0 *1 123.51,250.75
X$5019 I VIA_L1M1_PR_MR
* cell instance $5020 r0 *1 116.15,254.49
X$5020 I VIA_L1M1_PR_MR
* cell instance $5021 r0 *1 108.79,287.13
X$5021 I VIA_L1M1_PR_MR
* cell instance $5022 r0 *1 112.01,278.63
X$5022 I VIA_L1M1_PR_MR
* cell instance $5023 r0 *1 111.55,256.87
X$5023 I VIA_L1M1_PR_MR
* cell instance $5024 r0 *1 122.59,222.53
X$5024 I VIA_L1M1_PR_MR
* cell instance $5025 r0 *1 116.15,221.85
X$5025 I VIA_L1M1_PR_MR
* cell instance $5026 r0 *1 124.43,216.41
X$5026 I VIA_L1M1_PR_MR
* cell instance $5027 r0 *1 124.43,235.11
X$5027 I VIA_L1M1_PR_MR
* cell instance $5028 r0 *1 112.47,235.11
X$5028 I VIA_L1M1_PR_MR
* cell instance $5029 r0 *1 114.77,103.87
X$5029 I VIA_L1M1_PR_MR
* cell instance $5030 r0 *1 113.85,107.61
X$5030 I VIA_L1M1_PR_MR
* cell instance $5031 r0 *1 128.57,287.81
X$5031 I VIA_L1M1_PR_MR
* cell instance $5032 r0 *1 127.65,282.37
X$5032 I VIA_L1M1_PR_MR
* cell instance $5033 r0 *1 125.35,238.85
X$5033 I VIA_L1M1_PR_MR
* cell instance $5034 r0 *1 126.73,75.65
X$5034 I VIA_L1M1_PR_MR
* cell instance $5035 r0 *1 111.55,77.35
X$5035 I VIA_L1M1_PR_MR
* cell instance $5036 r0 *1 112.01,91.29
X$5036 I VIA_L1M1_PR_MR
* cell instance $5037 r0 *1 119.37,91.29
X$5037 I VIA_L1M1_PR_MR
* cell instance $5038 r0 *1 81.19,113.05
X$5038 I VIA_L1M1_PR_MR
* cell instance $5039 r0 *1 76.59,109.99
X$5039 I VIA_L1M1_PR_MR
* cell instance $5040 r0 *1 111.09,97.41
X$5040 I VIA_L1M1_PR_MR
* cell instance $5041 r0 *1 110.63,131.07
X$5041 I VIA_L1M1_PR_MR
* cell instance $5042 r0 *1 79.81,55.59
X$5042 I VIA_L1M1_PR_MR
* cell instance $5043 r0 *1 89.01,48.45
X$5043 I VIA_L1M1_PR_MR
* cell instance $5044 r0 *1 113.85,145.69
X$5044 I VIA_L1M1_PR_MR
* cell instance $5045 r0 *1 114.77,141.95
X$5045 I VIA_L1M1_PR_MR
* cell instance $5046 r0 *1 117.07,267.75
X$5046 I VIA_L1M1_PR_MR
* cell instance $5047 r0 *1 117.99,134.81
X$5047 I VIA_L1M1_PR_MR
* cell instance $5048 r0 *1 117.07,119.17
X$5048 I VIA_L1M1_PR_MR
* cell instance $5049 r0 *1 115.23,120.87
X$5049 I VIA_L1M1_PR_MR
* cell instance $5050 r0 *1 124.43,131.75
X$5050 I VIA_L1M1_PR_MR
* cell instance $5051 r0 *1 81.65,62.05
X$5051 I VIA_L1M1_PR_MR
* cell instance $5052 r0 *1 77.05,48.11
X$5052 \$975 VIA_M1M2_PR
* cell instance $5053 r0 *1 77.05,57.63
X$5053 \$975 VIA_M1M2_PR
* cell instance $5054 r0 *1 77.51,48.11
X$5054 \$975 VIA_L1M1_PR_MR
* cell instance $5055 r0 *1 77.05,57.63
X$5055 \$975 VIA_L1M1_PR_MR
* cell instance $5056 r0 *1 77.51,53.21
X$5056 \$979 VIA_M1M2_PR
* cell instance $5057 r0 *1 77.51,50.83
X$5057 \$979 VIA_M1M2_PR
* cell instance $5058 r0 *1 77.51,55.59
X$5058 \$979 VIA_M1M2_PR
* cell instance $5059 r0 *1 77.51,57.63
X$5059 \$979 VIA_M1M2_PR
* cell instance $5060 r0 *1 77.97,50.15
X$5060 \$979 VIA_L1M1_PR_MR
* cell instance $5061 r0 *1 78.43,57.63
X$5061 \$979 VIA_L1M1_PR_MR
* cell instance $5062 r0 *1 78.89,53.21
X$5062 \$979 VIA_L1M1_PR_MR
* cell instance $5063 r0 *1 77.51,55.59
X$5063 \$979 VIA_L1M1_PR_MR
* cell instance $5064 r0 *1 123.05,85.51
X$5064 \$983 VIA_M1M2_PR
* cell instance $5065 r0 *1 124.43,77.69
X$5065 \$983 VIA_M1M2_PR
* cell instance $5066 r0 *1 124.43,80.07
X$5066 \$983 VIA_M1M2_PR
* cell instance $5067 r0 *1 123.05,80.07
X$5067 \$983 VIA_M1M2_PR
* cell instance $5068 r0 *1 124.43,72.25
X$5068 \$983 VIA_M1M2_PR
* cell instance $5069 r0 *1 124.43,86.19
X$5069 \$983 VIA_M1M2_PR
* cell instance $5070 r0 *1 122.59,94.01
X$5070 \$983 VIA_M1M2_PR
* cell instance $5071 r0 *1 118.45,47.77
X$5071 \$983 VIA_M1M2_PR
* cell instance $5072 r0 *1 124.43,50.49
X$5072 \$983 VIA_M1M2_PR
* cell instance $5073 r0 *1 118.45,50.49
X$5073 \$983 VIA_M1M2_PR
* cell instance $5074 r0 *1 118.45,47.77
X$5074 \$983 VIA_L1M1_PR_MR
* cell instance $5075 r0 *1 115.23,50.49
X$5075 \$983 VIA_L1M1_PR_MR
* cell instance $5076 r0 *1 123.05,80.07
X$5076 \$983 VIA_L1M1_PR_MR
* cell instance $5077 r0 *1 116.15,94.01
X$5077 \$983 VIA_L1M1_PR_MR
* cell instance $5078 r0 *1 123.05,85.51
X$5078 \$983 VIA_L1M1_PR_MR
* cell instance $5079 r0 *1 116.15,77.69
X$5079 \$983 VIA_L1M1_PR_MR
* cell instance $5080 r0 *1 124.43,72.25
X$5080 \$983 VIA_L1M1_PR_MR
* cell instance $5081 r0 *1 124.43,86.19
X$5081 \$983 VIA_L1M1_PR_MR
* cell instance $5082 r0 *1 118.91,102.85
X$5082 \$984 VIA_M1M2_PR
* cell instance $5083 r0 *1 114.77,85.51
X$5083 \$984 VIA_M1M2_PR
* cell instance $5084 r0 *1 118.91,69.53
X$5084 \$984 VIA_M1M2_PR
* cell instance $5085 r0 *1 118.91,61.03
X$5085 \$984 VIA_M1M2_PR
* cell instance $5086 r0 *1 121.67,102.85
X$5086 \$984 VIA_M1M2_PR
* cell instance $5087 r0 *1 118.91,88.23
X$5087 \$984 VIA_M1M2_PR
* cell instance $5088 r0 *1 118.91,85.51
X$5088 \$984 VIA_M1M2_PR
* cell instance $5089 r0 *1 114.77,51.17
X$5089 \$984 VIA_M1M2_PR
* cell instance $5090 r0 *1 117.07,58.65
X$5090 \$984 VIA_M1M2_PR
* cell instance $5091 r0 *1 117.07,61.03
X$5091 \$984 VIA_M1M2_PR
* cell instance $5092 r0 *1 117.07,69.53
X$5092 \$984 VIA_M1M2_PR
* cell instance $5093 r0 *1 114.77,71.91
X$5093 \$984 VIA_M1M2_PR
* cell instance $5094 r0 *1 116.61,71.91
X$5094 \$984 VIA_M1M2_PR
* cell instance $5095 r0 *1 114.77,58.65
X$5095 \$984 VIA_M1M2_PR
* cell instance $5096 r0 *1 121.67,142.29
X$5096 \$984 VIA_M1M2_PR
* cell instance $5097 r0 *1 121.67,126.31
X$5097 \$984 VIA_M1M2_PR
* cell instance $5098 r0 *1 121.67,131.41
X$5098 \$984 VIA_M1M2_PR
* cell instance $5099 r0 *1 118.91,69.53
X$5099 \$984 VIA_L1M1_PR_MR
* cell instance $5100 r0 *1 118.45,85.69
X$5100 \$984 VIA_L1M1_PR_MR
* cell instance $5101 r0 *1 118.45,61.03
X$5101 \$984 VIA_L1M1_PR_MR
* cell instance $5102 r0 *1 114.77,71.91
X$5102 \$984 VIA_L1M1_PR_MR
* cell instance $5103 r0 *1 116.61,58.65
X$5103 \$984 VIA_L1M1_PR_MR
* cell instance $5104 r0 *1 171.35,50.83
X$5104 \$984 VIA_L1M1_PR_MR
* cell instance $5105 r0 *1 118.91,102.85
X$5105 \$984 VIA_L1M1_PR_MR
* cell instance $5106 r0 *1 118.91,88.23
X$5106 \$984 VIA_L1M1_PR_MR
* cell instance $5107 r0 *1 119.83,142.29
X$5107 \$984 VIA_L1M1_PR_MR
* cell instance $5108 r0 *1 120.75,142.63
X$5108 \$984 VIA_L1M1_PR_MR
* cell instance $5109 r0 *1 116.61,126.31
X$5109 \$984 VIA_L1M1_PR_MR
* cell instance $5110 r0 *1 119.83,131.41
X$5110 \$984 VIA_L1M1_PR_MR
* cell instance $5111 r0 *1 163.53,46.75
X$5111 \$986 VIA_M1M2_PR
* cell instance $5112 r0 *1 163.53,49.81
X$5112 \$986 VIA_M1M2_PR
* cell instance $5113 r0 *1 163.99,49.81
X$5113 \$986 VIA_L1M1_PR_MR
* cell instance $5114 r0 *1 163.53,46.75
X$5114 \$986 VIA_L1M1_PR_MR
* cell instance $5115 r0 *1 169.05,50.15
X$5115 \$986 VIA_L1M1_PR_MR
* cell instance $5116 r0 *1 181.47,49.47
X$5116 \$997 VIA_M1M2_PR
* cell instance $5117 r0 *1 181.47,42.33
X$5117 \$997 VIA_M1M2_PR
* cell instance $5118 r0 *1 176.87,49.47
X$5118 \$997 VIA_L1M1_PR_MR
* cell instance $5119 r0 *1 181.47,42.33
X$5119 \$997 VIA_L1M1_PR_MR
* cell instance $5120 r0 *1 172.73,55.25
X$5120 \$1002 VIA_M1M2_PR
* cell instance $5121 r0 *1 172.73,50.83
X$5121 \$1002 VIA_M1M2_PR
* cell instance $5122 r0 *1 172.27,55.25
X$5122 \$1002 VIA_L1M1_PR_MR
* cell instance $5123 r0 *1 178.71,50.83
X$5123 \$1002 VIA_L1M1_PR_MR
* cell instance $5124 r0 *1 167.67,50.49
X$5124 \$1008 VIA_M1M2_PR
* cell instance $5125 r0 *1 167.67,53.21
X$5125 \$1008 VIA_M1M2_PR
* cell instance $5126 r0 *1 167.67,53.21
X$5126 \$1008 VIA_L1M1_PR_MR
* cell instance $5127 r0 *1 166.75,50.49
X$5127 \$1008 VIA_L1M1_PR_MR
* cell instance $5128 r0 *1 171.35,53.21
X$5128 \$1008 VIA_L1M1_PR_MR
* cell instance $5129 r0 *1 75.21,49.47
X$5129 \$1021 VIA_M1M2_PR
* cell instance $5130 r0 *1 75.21,41.99
X$5130 \$1021 VIA_M1M2_PR
* cell instance $5131 r0 *1 75.21,41.99
X$5131 \$1021 VIA_L1M1_PR_MR
* cell instance $5132 r0 *1 73.83,49.47
X$5132 \$1021 VIA_L1M1_PR_MR
* cell instance $5133 r0 *1 76.13,50.83
X$5133 \$1026 VIA_M1M2_PR
* cell instance $5134 r0 *1 76.13,56.27
X$5134 \$1026 VIA_M1M2_PR
* cell instance $5135 r0 *1 76.59,50.83
X$5135 \$1026 VIA_L1M1_PR_MR
* cell instance $5136 r0 *1 89.07,56.61
X$5136 \$1026 VIA_L1M1_PR_MR
* cell instance $5137 r0 *1 75.21,53.55
X$5137 \$1037 VIA_M1M2_PR
* cell instance $5138 r0 *1 75.21,58.31
X$5138 \$1037 VIA_M1M2_PR
* cell instance $5139 r0 *1 75.21,53.55
X$5139 \$1037 VIA_L1M1_PR_MR
* cell instance $5140 r0 *1 74.75,58.31
X$5140 \$1037 VIA_L1M1_PR_MR
* cell instance $5141 r0 *1 80.73,52.87
X$5141 \$1038 VIA_M1M2_PR
* cell instance $5142 r0 *1 80.73,50.49
X$5142 \$1038 VIA_M1M2_PR
* cell instance $5143 r0 *1 80.73,50.49
X$5143 \$1038 VIA_L1M1_PR_MR
* cell instance $5144 r0 *1 88.09,53.55
X$5144 \$1038 VIA_L1M1_PR_MR
* cell instance $5145 r0 *1 118.91,59.33
X$5145 \$1046 VIA_M1M2_PR
* cell instance $5146 r0 *1 118.91,55.59
X$5146 \$1046 VIA_M1M2_PR
* cell instance $5147 r0 *1 118.91,53.55
X$5147 \$1046 VIA_M1M2_PR
* cell instance $5148 r0 *1 119.83,53.21
X$5148 \$1046 VIA_L1M1_PR_MR
* cell instance $5149 r0 *1 118.91,59.33
X$5149 \$1046 VIA_L1M1_PR_MR
* cell instance $5150 r0 *1 116.15,55.59
X$5150 \$1046 VIA_L1M1_PR_MR
* cell instance $5151 r0 *1 117.99,53.21
X$5151 \$1048 VIA_M1M2_PR
* cell instance $5152 r0 *1 123.97,51.17
X$5152 \$1048 VIA_M1M2_PR
* cell instance $5153 r0 *1 123.97,52.87
X$5153 \$1048 VIA_M1M2_PR
* cell instance $5154 r0 *1 117.99,55.25
X$5154 \$1048 VIA_M1M2_PR
* cell instance $5155 r0 *1 119.37,53.21
X$5155 \$1048 VIA_L1M1_PR_MR
* cell instance $5156 r0 *1 123.97,51.17
X$5156 \$1048 VIA_L1M1_PR_MR
* cell instance $5157 r0 *1 123.51,52.87
X$5157 \$1048 VIA_L1M1_PR_MR
* cell instance $5158 r0 *1 117.99,55.25
X$5158 \$1048 VIA_L1M1_PR_MR
* cell instance $5159 r0 *1 122.59,85.17
X$5159 \$1050 VIA_M1M2_PR
* cell instance $5160 r0 *1 117.99,87.89
X$5160 \$1050 VIA_M1M2_PR
* cell instance $5161 r0 *1 117.99,86.53
X$5161 \$1050 VIA_M1M2_PR
* cell instance $5162 r0 *1 122.59,68.85
X$5162 \$1050 VIA_M1M2_PR
* cell instance $5163 r0 *1 122.59,69.53
X$5163 \$1050 VIA_M1M2_PR
* cell instance $5164 r0 *1 123.05,102.17
X$5164 \$1050 VIA_M1M2_PR
* cell instance $5165 r0 *1 121.67,102.17
X$5165 \$1050 VIA_M1M2_PR
* cell instance $5166 r0 *1 121.67,88.23
X$5166 \$1050 VIA_M1M2_PR
* cell instance $5167 r0 *1 122.59,52.53
X$5167 \$1050 VIA_M1M2_PR
* cell instance $5168 r0 *1 113.39,70.21
X$5168 \$1050 VIA_M1M2_PR
* cell instance $5169 r0 *1 113.39,72.93
X$5169 \$1050 VIA_M1M2_PR
* cell instance $5170 r0 *1 122.59,57.63
X$5170 \$1050 VIA_M1M2_PR
* cell instance $5171 r0 *1 122.59,62.05
X$5171 \$1050 VIA_M1M2_PR
* cell instance $5172 r0 *1 118.91,141.95
X$5172 \$1050 VIA_M1M2_PR
* cell instance $5173 r0 *1 123.51,126.65
X$5173 \$1050 VIA_M1M2_PR
* cell instance $5174 r0 *1 118.91,131.07
X$5174 \$1050 VIA_M1M2_PR
* cell instance $5175 r0 *1 118.91,126.65
X$5175 \$1050 VIA_M1M2_PR
* cell instance $5176 r0 *1 117.99,58.65
X$5176 \$1050 VIA_L1M1_PR_MR
* cell instance $5177 r0 *1 113.39,72.93
X$5177 \$1050 VIA_L1M1_PR_MR
* cell instance $5178 r0 *1 119.83,62.05
X$5178 \$1050 VIA_L1M1_PR_MR
* cell instance $5179 r0 *1 122.59,69.53
X$5179 \$1050 VIA_L1M1_PR_MR
* cell instance $5180 r0 *1 173.19,52.87
X$5180 \$1050 VIA_L1M1_PR_MR
* cell instance $5181 r0 *1 118.91,142.63
X$5181 \$1050 VIA_L1M1_PR_MR
* cell instance $5182 r0 *1 118.91,141.95
X$5182 \$1050 VIA_L1M1_PR_MR
* cell instance $5183 r0 *1 119.83,102.17
X$5183 \$1050 VIA_L1M1_PR_MR
* cell instance $5184 r0 *1 115.69,85.85
X$5184 \$1050 VIA_L1M1_PR_MR
* cell instance $5185 r0 *1 119.83,87.89
X$5185 \$1050 VIA_L1M1_PR_MR
* cell instance $5186 r0 *1 123.97,142.63
X$5186 \$1050 VIA_L1M1_PR_MR
* cell instance $5187 r0 *1 118.91,131.07
X$5187 \$1050 VIA_L1M1_PR_MR
* cell instance $5188 r0 *1 115.23,126.65
X$5188 \$1050 VIA_L1M1_PR_MR
* cell instance $5189 r0 *1 162.15,52.53
X$5189 \$1058 VIA_M1M2_PR
* cell instance $5190 r0 *1 162.15,47.77
X$5190 \$1058 VIA_M1M2_PR
* cell instance $5191 r0 *1 168.59,53.21
X$5191 \$1058 VIA_L1M1_PR_MR
* cell instance $5192 r0 *1 162.15,47.77
X$5192 \$1058 VIA_L1M1_PR_MR
* cell instance $5193 r0 *1 173.19,52.19
X$5193 \$1073 VIA_M1M2_PR
* cell instance $5194 r0 *1 173.19,50.15
X$5194 \$1073 VIA_M1M2_PR
* cell instance $5195 r0 *1 173.19,50.15
X$5195 \$1073 VIA_L1M1_PR_MR
* cell instance $5196 r0 *1 177.33,52.19
X$5196 \$1073 VIA_L1M1_PR_MR
* cell instance $5197 r0 *1 76.59,50.15
X$5197 \$1083 VIA_M1M2_PR
* cell instance $5198 r0 *1 76.59,54.91
X$5198 \$1083 VIA_M1M2_PR
* cell instance $5199 r0 *1 76.59,50.15
X$5199 \$1083 VIA_L1M1_PR_MR
* cell instance $5200 r0 *1 78.43,54.91
X$5200 \$1083 VIA_L1M1_PR_MR
* cell instance $5201 r0 *1 84.41,53.55
X$5201 \$1092 VIA_M1M2_PR
* cell instance $5202 r0 *1 84.41,58.99
X$5202 \$1092 VIA_M1M2_PR
* cell instance $5203 r0 *1 83.95,53.55
X$5203 \$1092 VIA_L1M1_PR_MR
* cell instance $5204 r0 *1 85.79,58.99
X$5204 \$1092 VIA_L1M1_PR_MR
* cell instance $5205 r0 *1 88.09,47.77
X$5205 \$1095 VIA_M1M2_PR
* cell instance $5206 r0 *1 88.09,52.19
X$5206 \$1095 VIA_M1M2_PR
* cell instance $5207 r0 *1 86.71,52.19
X$5207 \$1095 VIA_L1M1_PR_MR
* cell instance $5208 r0 *1 89.01,52.19
X$5208 \$1095 VIA_L1M1_PR_MR
* cell instance $5209 r0 *1 88.09,47.77
X$5209 \$1095 VIA_L1M1_PR_MR
* cell instance $5210 r0 *1 134.78,156.06
X$5210 \$1103 VIA_M3M4_PR
* cell instance $5211 r0 *1 134.78,245.82
X$5211 \$1103 VIA_M3M4_PR
* cell instance $5212 r0 *1 164.45,251.26
X$5212 \$1103 VIA_M2M3_PR
* cell instance $5213 r0 *1 92.23,156.06
X$5213 \$1103 VIA_M2M3_PR
* cell instance $5214 r0 *1 165.37,245.82
X$5214 \$1103 VIA_M2M3_PR
* cell instance $5215 r0 *1 161.23,245.82
X$5215 \$1103 VIA_M2M3_PR
* cell instance $5216 r0 *1 161.23,251.26
X$5216 \$1103 VIA_M2M3_PR
* cell instance $5217 r0 *1 161.23,251.43
X$5217 \$1103 VIA_M1M2_PR
* cell instance $5218 r0 *1 164.45,251.43
X$5218 \$1103 VIA_M1M2_PR
* cell instance $5219 r0 *1 165.37,245.99
X$5219 \$1103 VIA_M1M2_PR
* cell instance $5220 r0 *1 92.23,53.89
X$5220 \$1103 VIA_M1M2_PR
* cell instance $5221 r0 *1 165.37,245.99
X$5221 \$1103 VIA_L1M1_PR_MR
* cell instance $5222 r0 *1 164.45,251.43
X$5222 \$1103 VIA_L1M1_PR_MR
* cell instance $5223 r0 *1 161.23,251.43
X$5223 \$1103 VIA_L1M1_PR_MR
* cell instance $5224 r0 *1 89.93,53.89
X$5224 \$1103 VIA_L1M1_PR_MR
* cell instance $5225 r0 *1 85.79,52.53
X$5225 \$1126 VIA_M1M2_PR
* cell instance $5226 r0 *1 85.79,55.93
X$5226 \$1126 VIA_M1M2_PR
* cell instance $5227 r0 *1 83.03,55.93
X$5227 \$1126 VIA_M1M2_PR
* cell instance $5228 r0 *1 83.03,60.69
X$5228 \$1126 VIA_M1M2_PR
* cell instance $5229 r0 *1 85.79,52.53
X$5229 \$1126 VIA_L1M1_PR_MR
* cell instance $5230 r0 *1 81.65,55.93
X$5230 \$1126 VIA_L1M1_PR_MR
* cell instance $5231 r0 *1 82.57,60.69
X$5231 \$1126 VIA_L1M1_PR_MR
* cell instance $5232 r0 *1 77.05,55.93
X$5232 \$1126 VIA_L1M1_PR_MR
* cell instance $5233 r0 *1 77.97,55.93
X$5233 \$1126 VIA_L1M1_PR_MR
* cell instance $5234 r0 *1 101.43,82.79
X$5234 \$1128 VIA_M1M2_PR
* cell instance $5235 r0 *1 101.43,139.23
X$5235 \$1128 VIA_M1M2_PR
* cell instance $5236 r0 *1 78.89,26.35
X$5236 \$1128 VIA_M1M2_PR
* cell instance $5237 r0 *1 79.81,82.79
X$5237 \$1128 VIA_M1M2_PR
* cell instance $5238 r0 *1 110.63,139.23
X$5238 \$1128 VIA_L1M1_PR_MR
* cell instance $5239 r0 *1 78.89,26.35
X$5239 \$1128 VIA_L1M1_PR_MR
* cell instance $5240 r0 *1 113.85,66.47
X$5240 \$1140 VIA_M1M2_PR
* cell instance $5241 r0 *1 113.85,61.71
X$5241 \$1140 VIA_M1M2_PR
* cell instance $5242 r0 *1 113.85,63.75
X$5242 \$1140 VIA_M1M2_PR
* cell instance $5243 r0 *1 112.93,63.75
X$5243 \$1140 VIA_L1M1_PR_MR
* cell instance $5244 r0 *1 116.61,61.03
X$5244 \$1140 VIA_L1M1_PR_MR
* cell instance $5245 r0 *1 123.05,63.75
X$5245 \$1140 VIA_L1M1_PR_MR
* cell instance $5246 r0 *1 113.39,66.47
X$5246 \$1140 VIA_L1M1_PR_MR
* cell instance $5247 r0 *1 121.67,66.47
X$5247 \$1143 VIA_M1M2_PR
* cell instance $5248 r0 *1 121.67,60.35
X$5248 \$1143 VIA_M1M2_PR
* cell instance $5249 r0 *1 120.75,60.35
X$5249 \$1143 VIA_L1M1_PR_MR
* cell instance $5250 r0 *1 121.67,66.47
X$5250 \$1143 VIA_L1M1_PR_MR
* cell instance $5251 r0 *1 116.15,61.03
X$5251 \$1143 VIA_L1M1_PR_MR
* cell instance $5252 r0 *1 74.75,56.27
X$5252 \$1170 VIA_M1M2_PR
* cell instance $5253 r0 *1 74.75,47.77
X$5253 \$1170 VIA_M1M2_PR
* cell instance $5254 r0 *1 75.67,56.27
X$5254 \$1170 VIA_L1M1_PR_MR
* cell instance $5255 r0 *1 74.75,47.77
X$5255 \$1170 VIA_L1M1_PR_MR
* cell instance $5256 r0 *1 71.99,53.89
X$5256 \$1173 VIA_M1M2_PR
* cell instance $5257 r0 *1 71.99,57.97
X$5257 \$1173 VIA_M1M2_PR
* cell instance $5258 r0 *1 71.99,53.89
X$5258 \$1173 VIA_L1M1_PR_MR
* cell instance $5259 r0 *1 76.13,57.97
X$5259 \$1173 VIA_L1M1_PR_MR
* cell instance $5260 r0 *1 160.31,45.39
X$5260 \$1186 VIA_M1M2_PR
* cell instance $5261 r0 *1 160.31,55.59
X$5261 \$1186 VIA_M1M2_PR
* cell instance $5262 r0 *1 160.31,45.39
X$5262 \$1186 VIA_L1M1_PR_MR
* cell instance $5263 r0 *1 169.05,55.59
X$5263 \$1186 VIA_L1M1_PR_MR
* cell instance $5264 r0 *1 115.23,65.79
X$5264 \$1201 VIA_M1M2_PR
* cell instance $5265 r0 *1 115.23,61.03
X$5265 \$1201 VIA_M1M2_PR
* cell instance $5266 r0 *1 122.59,66.47
X$5266 \$1201 VIA_L1M1_PR_MR
* cell instance $5267 r0 *1 115.23,61.03
X$5267 \$1201 VIA_L1M1_PR_MR
* cell instance $5268 r0 *1 114.77,61.03
X$5268 \$1201 VIA_L1M1_PR_MR
* cell instance $5269 r0 *1 113.39,64.09
X$5269 \$1203 VIA_M1M2_PR
* cell instance $5270 r0 *1 113.39,62.05
X$5270 \$1203 VIA_M1M2_PR
* cell instance $5271 r0 *1 113.39,68.51
X$5271 \$1203 VIA_M1M2_PR
* cell instance $5272 r0 *1 112.01,64.09
X$5272 \$1203 VIA_L1M1_PR_MR
* cell instance $5273 r0 *1 115.23,62.05
X$5273 \$1203 VIA_L1M1_PR_MR
* cell instance $5274 r0 *1 114.31,68.51
X$5274 \$1203 VIA_L1M1_PR_MR
* cell instance $5275 r0 *1 117.99,62.05
X$5275 \$1205 VIA_M1M2_PR
* cell instance $5276 r0 *1 117.99,66.81
X$5276 \$1205 VIA_M1M2_PR
* cell instance $5277 r0 *1 117.53,62.05
X$5277 \$1205 VIA_L1M1_PR_MR
* cell instance $5278 r0 *1 119.83,66.81
X$5278 \$1205 VIA_L1M1_PR_MR
* cell instance $5279 r0 *1 107.41,66.98
X$5279 \$1213 VIA_M2M3_PR
* cell instance $5280 r0 *1 116.61,66.98
X$5280 \$1213 VIA_M2M3_PR
* cell instance $5281 r0 *1 116.61,66.81
X$5281 \$1213 VIA_M1M2_PR
* cell instance $5282 r0 *1 107.41,73.95
X$5282 \$1213 VIA_M1M2_PR
* cell instance $5283 r0 *1 107.41,73.95
X$5283 \$1213 VIA_L1M1_PR_MR
* cell instance $5284 r0 *1 116.61,66.81
X$5284 \$1213 VIA_L1M1_PR_MR
* cell instance $5285 r0 *1 116.15,66.47
X$5285 \$1220 VIA_M1M2_PR
* cell instance $5286 r0 *1 114.31,66.47
X$5286 \$1220 VIA_M1M2_PR
* cell instance $5287 r0 *1 114.77,69.53
X$5287 \$1220 VIA_M1M2_PR
* cell instance $5288 r0 *1 114.77,71.23
X$5288 \$1220 VIA_M1M2_PR
* cell instance $5289 r0 *1 114.31,66.47
X$5289 \$1220 VIA_L1M1_PR_MR
* cell instance $5290 r0 *1 118.45,66.47
X$5290 \$1220 VIA_L1M1_PR_MR
* cell instance $5291 r0 *1 115.69,71.23
X$5291 \$1220 VIA_L1M1_PR_MR
* cell instance $5292 r0 *1 114.77,69.53
X$5292 \$1220 VIA_L1M1_PR_MR
* cell instance $5293 r0 *1 124.89,75.65
X$5293 \$1221 VIA_M1M2_PR
* cell instance $5294 r0 *1 124.89,76.67
X$5294 \$1221 VIA_M1M2_PR
* cell instance $5295 r0 *1 112.47,75.65
X$5295 \$1221 VIA_M1M2_PR
* cell instance $5296 r0 *1 112.47,67.15
X$5296 \$1221 VIA_M1M2_PR
* cell instance $5297 r0 *1 124.89,76.67
X$5297 \$1221 VIA_L1M1_PR_MR
* cell instance $5298 r0 *1 115.23,66.64
X$5298 \$1221 VIA_L1M1_PR_MR
* cell instance $5299 r0 *1 114.77,74.97
X$5299 \$1221 VIA_L1M1_PR_MR
* cell instance $5300 r0 *1 112.47,75.65
X$5300 \$1221 VIA_L1M1_PR_MR
* cell instance $5301 r0 *1 112.93,74.97
X$5301 \$1223 VIA_M1M2_PR
* cell instance $5302 r0 *1 112.93,71.23
X$5302 \$1223 VIA_M1M2_PR
* cell instance $5303 r0 *1 111.55,67.49
X$5303 \$1223 VIA_M1M2_PR
* cell instance $5304 r0 *1 111.55,71.23
X$5304 \$1223 VIA_M1M2_PR
* cell instance $5305 r0 *1 110.63,71.23
X$5305 \$1223 VIA_L1M1_PR_MR
* cell instance $5306 r0 *1 112.93,74.97
X$5306 \$1223 VIA_L1M1_PR_MR
* cell instance $5307 r0 *1 115.69,67.15
X$5307 \$1223 VIA_L1M1_PR_MR
* cell instance $5308 r0 *1 112.47,66.13
X$5308 \$1224 VIA_M1M2_PR
* cell instance $5309 r0 *1 112.47,64.77
X$5309 \$1224 VIA_M1M2_PR
* cell instance $5310 r0 *1 112.47,66.13
X$5310 \$1224 VIA_L1M1_PR_MR
* cell instance $5311 r0 *1 115.69,64.43
X$5311 \$1224 VIA_L1M1_PR_MR
* cell instance $5312 r0 *1 118.91,67.15
X$5312 \$1227 VIA_L1M1_PR_MR
* cell instance $5313 r0 *1 118.91,66.47
X$5313 \$1227 VIA_L1M1_PR_MR
* cell instance $5314 r0 *1 114.77,66.13
X$5314 \$1227 VIA_L1M1_PR_MR
* cell instance $5315 r0 *1 123.05,66.81
X$5315 \$1227 VIA_L1M1_PR_MR
* cell instance $5316 r0 *1 198.49,68.34
X$5316 O[5] VIA_M2M3_PR
* cell instance $5317 r0 *1 199.41,237.15
X$5317 O[5] VIA_M1M2_PR
* cell instance $5318 r0 *1 175.95,237.15
X$5318 O[5] VIA_L1M1_PR_MR
* cell instance $5319 r0 *1 123.05,67.49
X$5319 \$1244 VIA_M1M2_PR
* cell instance $5320 r0 *1 123.05,71.57
X$5320 \$1244 VIA_M1M2_PR
* cell instance $5321 r0 *1 120.75,67.49
X$5321 \$1244 VIA_L1M1_PR_MR
* cell instance $5322 r0 *1 123.05,71.57
X$5322 \$1244 VIA_L1M1_PR_MR
* cell instance $5323 r0 *1 117.99,77.01
X$5323 \$1256 VIA_M1M2_PR
* cell instance $5324 r0 *1 117.99,67.49
X$5324 \$1256 VIA_M1M2_PR
* cell instance $5325 r0 *1 117.53,77.01
X$5325 \$1256 VIA_L1M1_PR_MR
* cell instance $5326 r0 *1 117.53,67.49
X$5326 \$1256 VIA_L1M1_PR_MR
* cell instance $5327 r0 *1 113.85,77.69
X$5327 \$1261 VIA_M1M2_PR
* cell instance $5328 r0 *1 113.85,80.41
X$5328 \$1261 VIA_M1M2_PR
* cell instance $5329 r0 *1 113.85,69.19
X$5329 \$1261 VIA_M1M2_PR
* cell instance $5330 r0 *1 113.85,77.69
X$5330 \$1261 VIA_L1M1_PR_MR
* cell instance $5331 r0 *1 115.69,69.19
X$5331 \$1261 VIA_L1M1_PR_MR
* cell instance $5332 r0 *1 112.93,80.41
X$5332 \$1261 VIA_L1M1_PR_MR
* cell instance $5333 r0 *1 65.09,147.9
X$5333 \$1271 VIA_M2M3_PR
* cell instance $5334 r0 *1 72.91,147.9
X$5334 \$1271 VIA_M2M3_PR
* cell instance $5335 r0 *1 94.07,153.34
X$5335 \$1271 VIA_M2M3_PR
* cell instance $5336 r0 *1 75.67,153.34
X$5336 \$1271 VIA_M2M3_PR
* cell instance $5337 r0 *1 125.81,86.02
X$5337 \$1271 VIA_M2M3_PR
* cell instance $5338 r0 *1 73.37,109.82
X$5338 \$1271 VIA_M2M3_PR
* cell instance $5339 r0 *1 119.83,86.02
X$5339 \$1271 VIA_M2M3_PR
* cell instance $5340 r0 *1 110.63,86.02
X$5340 \$1271 VIA_M2M3_PR
* cell instance $5341 r0 *1 89.93,109.82
X$5341 \$1271 VIA_M2M3_PR
* cell instance $5342 r0 *1 125.81,91.29
X$5342 \$1271 VIA_M1M2_PR
* cell instance $5343 r0 *1 110.63,205.19
X$5343 \$1271 VIA_M1M2_PR
* cell instance $5344 r0 *1 114.77,249.05
X$5344 \$1271 VIA_M1M2_PR
* cell instance $5345 r0 *1 121.67,249.05
X$5345 \$1271 VIA_M1M2_PR
* cell instance $5346 r0 *1 121.67,251.43
X$5346 \$1271 VIA_M1M2_PR
* cell instance $5347 r0 *1 112.93,224.91
X$5347 \$1271 VIA_M1M2_PR
* cell instance $5348 r0 *1 119.83,86.19
X$5348 \$1271 VIA_M1M2_PR
* cell instance $5349 r0 *1 110.63,85.17
X$5349 \$1271 VIA_M1M2_PR
* cell instance $5350 r0 *1 73.83,150.79
X$5350 \$1271 VIA_M1M2_PR
* cell instance $5351 r0 *1 65.09,148.07
X$5351 \$1271 VIA_M1M2_PR
* cell instance $5352 r0 *1 89.93,109.65
X$5352 \$1271 VIA_M1M2_PR
* cell instance $5353 r0 *1 93.61,109.65
X$5353 \$1271 VIA_M1M2_PR
* cell instance $5354 r0 *1 93.61,75.31
X$5354 \$1271 VIA_M1M2_PR
* cell instance $5355 r0 *1 75.67,150.79
X$5355 \$1271 VIA_M1M2_PR
* cell instance $5356 r0 *1 94.07,165.07
X$5356 \$1271 VIA_M1M2_PR
* cell instance $5357 r0 *1 151.57,178.67
X$5357 \$1271 VIA_M1M2_PR
* cell instance $5358 r0 *1 151.57,181.05
X$5358 \$1271 VIA_M1M2_PR
* cell instance $5359 r0 *1 113.85,178.67
X$5359 \$1271 VIA_M1M2_PR
* cell instance $5360 r0 *1 113.85,164.73
X$5360 \$1271 VIA_M1M2_PR
* cell instance $5361 r0 *1 110.63,178.67
X$5361 \$1271 VIA_M1M2_PR
* cell instance $5362 r0 *1 149.73,227.29
X$5362 \$1271 VIA_M1M2_PR
* cell instance $5363 r0 *1 149.73,223.89
X$5363 \$1271 VIA_M1M2_PR
* cell instance $5364 r0 *1 114.77,205.19
X$5364 \$1271 VIA_M1M2_PR
* cell instance $5365 r0 *1 110.63,200.43
X$5365 \$1271 VIA_M1M2_PR
* cell instance $5366 r0 *1 73.37,107.61
X$5366 \$1271 VIA_M1M2_PR
* cell instance $5367 r0 *1 93.61,77.35
X$5367 \$1271 VIA_M1M2_PR
* cell instance $5368 r0 *1 93.61,85.17
X$5368 \$1271 VIA_M1M2_PR
* cell instance $5369 r0 *1 65.09,148.07
X$5369 \$1271 VIA_L1M1_PR_MR
* cell instance $5370 r0 *1 157.09,227.29
X$5370 \$1271 VIA_L1M1_PR_MR
* cell instance $5371 r0 *1 72.91,151.13
X$5371 \$1271 VIA_L1M1_PR_MR
* cell instance $5372 r0 *1 157.09,180.71
X$5372 \$1271 VIA_L1M1_PR_MR
* cell instance $5373 r0 *1 151.025,178.67
X$5373 \$1271 VIA_L1M1_PR_MR
* cell instance $5374 r0 *1 122.19,251.09
X$5374 \$1271 VIA_L1M1_PR_MR
* cell instance $5375 r0 *1 119.83,249.05
X$5375 \$1271 VIA_L1M1_PR_MR
* cell instance $5376 r0 *1 100.97,200.43
X$5376 \$1271 VIA_L1M1_PR_MR
* cell instance $5377 r0 *1 113.85,164.73
X$5377 \$1271 VIA_L1M1_PR_MR
* cell instance $5378 r0 *1 111.55,165.07
X$5378 \$1271 VIA_L1M1_PR_MR
* cell instance $5379 r0 *1 108.33,205.53
X$5379 \$1271 VIA_L1M1_PR_MR
* cell instance $5380 r0 *1 146.51,223.89
X$5380 \$1271 VIA_L1M1_PR_MR
* cell instance $5381 r0 *1 90.85,77.35
X$5381 \$1271 VIA_L1M1_PR_MR
* cell instance $5382 r0 *1 73.37,107.61
X$5382 \$1271 VIA_L1M1_PR_MR
* cell instance $5383 r0 *1 102.35,75.31
X$5383 \$1271 VIA_L1M1_PR_MR
* cell instance $5384 r0 *1 125.81,91.29
X$5384 \$1271 VIA_L1M1_PR_MR
* cell instance $5385 r0 *1 118.91,86.19
X$5385 \$1271 VIA_L1M1_PR_MR
* cell instance $5386 r0 *1 93.61,109.65
X$5386 \$1271 VIA_L1M1_PR_MR
* cell instance $5387 r0 *1 114.31,75.31
X$5387 \$1272 VIA_M1M2_PR
* cell instance $5388 r0 *1 114.31,81.09
X$5388 \$1272 VIA_M1M2_PR
* cell instance $5389 r0 *1 114.31,82.79
X$5389 \$1272 VIA_M1M2_PR
* cell instance $5390 r0 *1 111.55,74.97
X$5390 \$1272 VIA_L1M1_PR_MR
* cell instance $5391 r0 *1 108.33,74.97
X$5391 \$1272 VIA_L1M1_PR_MR
* cell instance $5392 r0 *1 114.31,82.79
X$5392 \$1272 VIA_L1M1_PR_MR
* cell instance $5393 r0 *1 114.31,81.09
X$5393 \$1272 VIA_L1M1_PR_MR
* cell instance $5394 r0 *1 109.25,74.63
X$5394 \$1273 VIA_M1M2_PR
* cell instance $5395 r0 *1 109.25,71.91
X$5395 \$1273 VIA_M1M2_PR
* cell instance $5396 r0 *1 109.25,74.63
X$5396 \$1273 VIA_L1M1_PR_MR
* cell instance $5397 r0 *1 109.25,71.91
X$5397 \$1273 VIA_L1M1_PR_MR
* cell instance $5398 r0 *1 112.34,72.25
X$5398 \$1273 VIA_L1M1_PR_MR
* cell instance $5399 r0 *1 113.39,82.79
X$5399 \$1274 VIA_M1M2_PR
* cell instance $5400 r0 *1 113.39,74.63
X$5400 \$1274 VIA_M1M2_PR
* cell instance $5401 r0 *1 109.71,73.95
X$5401 \$1274 VIA_L1M1_PR_MR
* cell instance $5402 r0 *1 113.85,82.79
X$5402 \$1274 VIA_L1M1_PR_MR
* cell instance $5403 r0 *1 114.31,74.63
X$5403 \$1274 VIA_L1M1_PR_MR
* cell instance $5404 r0 *1 110.63,74.97
X$5404 \$1275 VIA_M1M2_PR
* cell instance $5405 r0 *1 110.63,69.87
X$5405 \$1275 VIA_M1M2_PR
* cell instance $5406 r0 *1 110.63,71.91
X$5406 \$1275 VIA_M1M2_PR
* cell instance $5407 r0 *1 110.63,71.91
X$5407 \$1275 VIA_L1M1_PR_MR
* cell instance $5408 r0 *1 109.71,74.97
X$5408 \$1275 VIA_L1M1_PR_MR
* cell instance $5409 r0 *1 111.09,69.87
X$5409 \$1275 VIA_L1M1_PR_MR
* cell instance $5410 r0 *1 110.63,82.11
X$5410 \$1281 VIA_M1M2_PR
* cell instance $5411 r0 *1 110.63,78.03
X$5411 \$1281 VIA_M1M2_PR
* cell instance $5412 r0 *1 112.01,78.03
X$5412 \$1281 VIA_M1M2_PR
* cell instance $5413 r0 *1 110.63,80.41
X$5413 \$1281 VIA_M1M2_PR
* cell instance $5414 r0 *1 112.01,69.87
X$5414 \$1281 VIA_M1M2_PR
* cell instance $5415 r0 *1 123.97,82.11
X$5415 \$1281 VIA_L1M1_PR_MR
* cell instance $5416 r0 *1 115.23,69.53
X$5416 \$1281 VIA_L1M1_PR_MR
* cell instance $5417 r0 *1 109.71,78.03
X$5417 \$1281 VIA_L1M1_PR_MR
* cell instance $5418 r0 *1 110.63,80.41
X$5418 \$1281 VIA_L1M1_PR_MR
* cell instance $5419 r0 *1 124.89,69.87
X$5419 \$1283 VIA_M1M2_PR
* cell instance $5420 r0 *1 124.89,74.29
X$5420 \$1283 VIA_M1M2_PR
* cell instance $5421 r0 *1 124.89,74.29
X$5421 \$1283 VIA_L1M1_PR_MR
* cell instance $5422 r0 *1 116.61,69.53
X$5422 \$1283 VIA_L1M1_PR_MR
* cell instance $5423 r0 *1 123.97,75.31
X$5423 \$1287 VIA_M1M2_PR
* cell instance $5424 r0 *1 123.97,76.67
X$5424 \$1287 VIA_M1M2_PR
* cell instance $5425 r0 *1 123.97,70.21
X$5425 \$1287 VIA_M1M2_PR
* cell instance $5426 r0 *1 115.69,77.35
X$5426 \$1287 VIA_L1M1_PR_MR
* cell instance $5427 r0 *1 121.67,70.21
X$5427 \$1287 VIA_L1M1_PR_MR
* cell instance $5428 r0 *1 125.81,75.31
X$5428 \$1287 VIA_L1M1_PR_MR
* cell instance $5429 r0 *1 123.51,78.37
X$5429 \$1288 VIA_M1M2_PR
* cell instance $5430 r0 *1 123.51,74.63
X$5430 \$1288 VIA_M1M2_PR
* cell instance $5431 r0 *1 127.65,74.97
X$5431 \$1288 VIA_L1M1_PR_MR
* cell instance $5432 r0 *1 114.31,77.35
X$5432 \$1288 VIA_L1M1_PR_MR
* cell instance $5433 r0 *1 123.97,74.63
X$5433 \$1288 VIA_L1M1_PR_MR
* cell instance $5434 r0 *1 111.09,77.01
X$5434 \$1288 VIA_L1M1_PR_MR
* cell instance $5435 r0 *1 121.67,80.07
X$5435 \$1299 VIA_M1M2_PR
* cell instance $5436 r0 *1 121.67,73.95
X$5436 \$1299 VIA_M1M2_PR
* cell instance $5437 r0 *1 110.63,73.95
X$5437 \$1299 VIA_L1M1_PR_MR
* cell instance $5438 r0 *1 121.67,80.07
X$5438 \$1299 VIA_L1M1_PR_MR
* cell instance $5439 r0 *1 118.45,74.63
X$5439 \$1302 VIA_M1M2_PR
* cell instance $5440 r0 *1 118.45,70.21
X$5440 \$1302 VIA_M1M2_PR
* cell instance $5441 r0 *1 117.53,70.21
X$5441 \$1302 VIA_L1M1_PR_MR
* cell instance $5442 r0 *1 116.61,74.63
X$5442 \$1302 VIA_L1M1_PR_MR
* cell instance $5443 r0 *1 170.66,229.5
X$5443 \$1362 VIA_M3M4_PR
* cell instance $5444 r0 *1 170.66,212.5
X$5444 \$1362 VIA_M3M4_PR
* cell instance $5445 r0 *1 152.95,179.18
X$5445 \$1362 VIA_M2M3_PR
* cell instance $5446 r0 *1 167.21,179.18
X$5446 \$1362 VIA_M2M3_PR
* cell instance $5447 r0 *1 162.15,179.18
X$5447 \$1362 VIA_M2M3_PR
* cell instance $5448 r0 *1 173.65,180.54
X$5448 \$1362 VIA_M2M3_PR
* cell instance $5449 r0 *1 170.43,229.5
X$5449 \$1362 VIA_M2M3_PR
* cell instance $5450 r0 *1 170.89,212.5
X$5450 \$1362 VIA_M2M3_PR
* cell instance $5451 r0 *1 179.17,97.07
X$5451 \$1362 VIA_M1M2_PR
* cell instance $5452 r0 *1 177.33,98.43
X$5452 \$1362 VIA_M1M2_PR
* cell instance $5453 r0 *1 179.17,94.35
X$5453 \$1362 VIA_M1M2_PR
* cell instance $5454 r0 *1 172.73,83.47
X$5454 \$1362 VIA_M1M2_PR
* cell instance $5455 r0 *1 172.27,85.85
X$5455 \$1362 VIA_M1M2_PR
* cell instance $5456 r0 *1 172.73,93.67
X$5456 \$1362 VIA_M1M2_PR
* cell instance $5457 r0 *1 172.27,87.55
X$5457 \$1362 VIA_M1M2_PR
* cell instance $5458 r0 *1 174.11,116.11
X$5458 \$1362 VIA_M1M2_PR
* cell instance $5459 r0 *1 170.43,111.01
X$5459 \$1362 VIA_M1M2_PR
* cell instance $5460 r0 *1 172.73,112.37
X$5460 \$1362 VIA_M1M2_PR
* cell instance $5461 r0 *1 172.73,111.01
X$5461 \$1362 VIA_M1M2_PR
* cell instance $5462 r0 *1 172.73,98.43
X$5462 \$1362 VIA_M1M2_PR
* cell instance $5463 r0 *1 172.73,115.77
X$5463 \$1362 VIA_M1M2_PR
* cell instance $5464 r0 *1 170.43,109.31
X$5464 \$1362 VIA_M1M2_PR
* cell instance $5465 r0 *1 170.43,254.49
X$5465 \$1362 VIA_M1M2_PR
* cell instance $5466 r0 *1 170.43,250.75
X$5466 \$1362 VIA_M1M2_PR
* cell instance $5467 r0 *1 169.97,256.87
X$5467 \$1362 VIA_M1M2_PR
* cell instance $5468 r0 *1 177.33,249.05
X$5468 \$1362 VIA_M1M2_PR
* cell instance $5469 r0 *1 177.33,250.75
X$5469 \$1362 VIA_M1M2_PR
* cell instance $5470 r0 *1 169.97,202.47
X$5470 \$1362 VIA_M1M2_PR
* cell instance $5471 r0 *1 170.89,202.47
X$5471 \$1362 VIA_M1M2_PR
* cell instance $5472 r0 *1 173.65,183.77
X$5472 \$1362 VIA_M1M2_PR
* cell instance $5473 r0 *1 169.05,186.15
X$5473 \$1362 VIA_M1M2_PR
* cell instance $5474 r0 *1 173.19,151.13
X$5474 \$1362 VIA_M1M2_PR
* cell instance $5475 r0 *1 167.21,169.83
X$5475 \$1362 VIA_M1M2_PR
* cell instance $5476 r0 *1 162.61,169.83
X$5476 \$1362 VIA_M1M2_PR
* cell instance $5477 r0 *1 167.21,178.33
X$5477 \$1362 VIA_M1M2_PR
* cell instance $5478 r0 *1 162.61,173.57
X$5478 \$1362 VIA_M1M2_PR
* cell instance $5479 r0 *1 173.19,152.83
X$5479 \$1362 VIA_M1M2_PR
* cell instance $5480 r0 *1 174.11,118.15
X$5480 \$1362 VIA_M1M2_PR
* cell instance $5481 r0 *1 172.73,137.53
X$5481 \$1362 VIA_M1M2_PR
* cell instance $5482 r0 *1 172.73,136.85
X$5482 \$1362 VIA_M1M2_PR
* cell instance $5483 r0 *1 178.71,153.17
X$5483 \$1362 VIA_M1M2_PR
* cell instance $5484 r0 *1 178.71,151.47
X$5484 \$1362 VIA_M1M2_PR
* cell instance $5485 r0 *1 173.19,148.07
X$5485 \$1362 VIA_M1M2_PR
* cell instance $5486 r0 *1 172.73,135.49
X$5486 \$1362 VIA_M1M2_PR
* cell instance $5487 r0 *1 167.21,152.83
X$5487 \$1362 VIA_M1M2_PR
* cell instance $5488 r0 *1 172.73,133.79
X$5488 \$1362 VIA_M1M2_PR
* cell instance $5489 r0 *1 170.89,131.75
X$5489 \$1362 VIA_M1M2_PR
* cell instance $5490 r0 *1 170.89,133.79
X$5490 \$1362 VIA_M1M2_PR
* cell instance $5491 r0 *1 174.57,136.85
X$5491 \$1362 VIA_M1M2_PR
* cell instance $5492 r0 *1 152.95,183.77
X$5492 \$1362 VIA_M1M2_PR
* cell instance $5493 r0 *1 173.65,185.47
X$5493 \$1362 VIA_M1M2_PR
* cell instance $5494 r0 *1 152.95,181.73
X$5494 \$1362 VIA_M1M2_PR
* cell instance $5495 r0 *1 177.33,96.73
X$5495 \$1362 VIA_M1M2_PR
* cell instance $5496 r0 *1 152.95,183.77
X$5496 \$1362 VIA_L1M1_PR_MR
* cell instance $5497 r0 *1 173.19,183.77
X$5497 \$1362 VIA_L1M1_PR_MR
* cell instance $5498 r0 *1 169.97,202.47
X$5498 \$1362 VIA_L1M1_PR_MR
* cell instance $5499 r0 *1 177.33,249.05
X$5499 \$1362 VIA_L1M1_PR_MR
* cell instance $5500 r0 *1 172.27,137.53
X$5500 \$1362 VIA_L1M1_PR_MR
* cell instance $5501 r0 *1 176.87,250.75
X$5501 \$1362 VIA_L1M1_PR_MR
* cell instance $5502 r0 *1 171.81,133.79
X$5502 \$1362 VIA_L1M1_PR_MR
* cell instance $5503 r0 *1 168.635,135.49
X$5503 \$1362 VIA_L1M1_PR_MR
* cell instance $5504 r0 *1 167.67,136.85
X$5504 \$1362 VIA_L1M1_PR_MR
* cell instance $5505 r0 *1 173.19,148.07
X$5505 \$1362 VIA_L1M1_PR_MR
* cell instance $5506 r0 *1 170.89,131.75
X$5506 \$1362 VIA_L1M1_PR_MR
* cell instance $5507 r0 *1 171.35,118.15
X$5507 \$1362 VIA_L1M1_PR_MR
* cell instance $5508 r0 *1 175.03,137.19
X$5508 \$1362 VIA_L1M1_PR_MR
* cell instance $5509 r0 *1 176.41,153.51
X$5509 \$1362 VIA_L1M1_PR_MR
* cell instance $5510 r0 *1 178.71,151.47
X$5510 \$1362 VIA_L1M1_PR_MR
* cell instance $5511 r0 *1 162.61,173.57
X$5511 \$1362 VIA_L1M1_PR_MR
* cell instance $5512 r0 *1 164.45,169.49
X$5512 \$1362 VIA_L1M1_PR_MR
* cell instance $5513 r0 *1 167.21,169.83
X$5513 \$1362 VIA_L1M1_PR_MR
* cell instance $5514 r0 *1 167.21,178.33
X$5514 \$1362 VIA_L1M1_PR_MR
* cell instance $5515 r0 *1 153.87,181.73
X$5515 \$1362 VIA_L1M1_PR_MR
* cell instance $5516 r0 *1 170.43,152.83
X$5516 \$1362 VIA_L1M1_PR_MR
* cell instance $5517 r0 *1 173.19,151.13
X$5517 \$1362 VIA_L1M1_PR_MR
* cell instance $5518 r0 *1 169.51,256.87
X$5518 \$1362 VIA_L1M1_PR_MR
* cell instance $5519 r0 *1 162.61,169.83
X$5519 \$1362 VIA_L1M1_PR_MR
* cell instance $5520 r0 *1 168.59,254.49
X$5520 \$1362 VIA_L1M1_PR_MR
* cell instance $5521 r0 *1 180.55,96.73
X$5521 \$1362 VIA_L1M1_PR_MR
* cell instance $5522 r0 *1 175.03,111.01
X$5522 \$1362 VIA_L1M1_PR_MR
* cell instance $5523 r0 *1 174.11,113.05
X$5523 \$1362 VIA_L1M1_PR_MR
* cell instance $5524 r0 *1 168.59,112.71
X$5524 \$1362 VIA_L1M1_PR_MR
* cell instance $5525 r0 *1 170.43,109.31
X$5525 \$1362 VIA_L1M1_PR_MR
* cell instance $5526 r0 *1 183.31,94.01
X$5526 \$1362 VIA_L1M1_PR_MR
* cell instance $5527 r0 *1 175.49,99.11
X$5527 \$1362 VIA_L1M1_PR_MR
* cell instance $5528 r0 *1 173.19,115.77
X$5528 \$1362 VIA_L1M1_PR_MR
* cell instance $5529 r0 *1 177.33,96.73
X$5529 \$1362 VIA_L1M1_PR_MR
* cell instance $5530 r0 *1 175.03,115.77
X$5530 \$1362 VIA_L1M1_PR_MR
* cell instance $5531 r0 *1 174.11,93.67
X$5531 \$1362 VIA_L1M1_PR_MR
* cell instance $5532 r0 *1 173.65,83.47
X$5532 \$1362 VIA_L1M1_PR_MR
* cell instance $5533 r0 *1 172.27,85.85
X$5533 \$1362 VIA_L1M1_PR_MR
* cell instance $5534 r0 *1 168.59,87.89
X$5534 \$1362 VIA_L1M1_PR_MR
* cell instance $5535 r0 *1 176.41,185.47
X$5535 \$1362 VIA_L1M1_PR_MR
* cell instance $5536 r0 *1 163.99,184.62
X$5536 \$1363 VIA_M2M3_PR
* cell instance $5537 r0 *1 156.17,184.62
X$5537 \$1363 VIA_M2M3_PR
* cell instance $5538 r0 *1 175.95,184.62
X$5538 \$1363 VIA_M2M3_PR
* cell instance $5539 r0 *1 175.95,110.67
X$5539 \$1363 VIA_M1M2_PR
* cell instance $5540 r0 *1 175.95,107.61
X$5540 \$1363 VIA_M1M2_PR
* cell instance $5541 r0 *1 172.27,94.69
X$5541 \$1363 VIA_M1M2_PR
* cell instance $5542 r0 *1 167.67,83.13
X$5542 \$1363 VIA_M1M2_PR
* cell instance $5543 r0 *1 167.67,85.85
X$5543 \$1363 VIA_M1M2_PR
* cell instance $5544 r0 *1 167.21,88.57
X$5544 \$1363 VIA_M1M2_PR
* cell instance $5545 r0 *1 169.51,95.71
X$5545 \$1363 VIA_M1M2_PR
* cell instance $5546 r0 *1 167.67,94.01
X$5546 \$1363 VIA_M1M2_PR
* cell instance $5547 r0 *1 167.67,91.29
X$5547 \$1363 VIA_M1M2_PR
* cell instance $5548 r0 *1 169.51,94.01
X$5548 \$1363 VIA_M1M2_PR
* cell instance $5549 r0 *1 174.57,110.67
X$5549 \$1363 VIA_M1M2_PR
* cell instance $5550 r0 *1 174.57,112.37
X$5550 \$1363 VIA_M1M2_PR
* cell instance $5551 r0 *1 174.57,115.09
X$5551 \$1363 VIA_M1M2_PR
* cell instance $5552 r0 *1 174.57,113.39
X$5552 \$1363 VIA_M1M2_PR
* cell instance $5553 r0 *1 172.27,95.71
X$5553 \$1363 VIA_M1M2_PR
* cell instance $5554 r0 *1 169.97,114.75
X$5554 \$1363 VIA_M1M2_PR
* cell instance $5555 r0 *1 169.51,96.73
X$5555 \$1363 VIA_M1M2_PR
* cell instance $5556 r0 *1 169.97,113.39
X$5556 \$1363 VIA_M1M2_PR
* cell instance $5557 r0 *1 169.51,247.01
X$5557 \$1363 VIA_M1M2_PR
* cell instance $5558 r0 *1 169.51,249.73
X$5558 \$1363 VIA_M1M2_PR
* cell instance $5559 r0 *1 169.51,256.19
X$5559 \$1363 VIA_M1M2_PR
* cell instance $5560 r0 *1 169.51,253.47
X$5560 \$1363 VIA_M1M2_PR
* cell instance $5561 r0 *1 154.79,247.01
X$5561 \$1363 VIA_M1M2_PR
* cell instance $5562 r0 *1 175.95,187.17
X$5562 \$1363 VIA_M1M2_PR
* cell instance $5563 r0 *1 170.43,156.91
X$5563 \$1363 VIA_M1M2_PR
* cell instance $5564 r0 *1 170.43,151.47
X$5564 \$1363 VIA_M1M2_PR
* cell instance $5565 r0 *1 174.11,150.45
X$5565 \$1363 VIA_M1M2_PR
* cell instance $5566 r0 *1 170.43,154.53
X$5566 \$1363 VIA_M1M2_PR
* cell instance $5567 r0 *1 163.99,170.51
X$5567 \$1363 VIA_M1M2_PR
* cell instance $5568 r0 *1 165.37,167.45
X$5568 \$1363 VIA_M1M2_PR
* cell instance $5569 r0 *1 165.37,169.83
X$5569 \$1363 VIA_M1M2_PR
* cell instance $5570 r0 *1 167.67,167.45
X$5570 \$1363 VIA_M1M2_PR
* cell instance $5571 r0 *1 175.03,137.87
X$5571 \$1363 VIA_M1M2_PR
* cell instance $5572 r0 *1 177.79,134.81
X$5572 \$1363 VIA_M1M2_PR
* cell instance $5573 r0 *1 177.79,132.43
X$5573 \$1363 VIA_M1M2_PR
* cell instance $5574 r0 *1 175.03,136.51
X$5574 \$1363 VIA_M1M2_PR
* cell instance $5575 r0 *1 175.03,134.81
X$5575 \$1363 VIA_M1M2_PR
* cell instance $5576 r0 *1 175.03,140.93
X$5576 \$1363 VIA_M1M2_PR
* cell instance $5577 r0 *1 175.49,151.13
X$5577 \$1363 VIA_M1M2_PR
* cell instance $5578 r0 *1 175.49,150.45
X$5578 \$1363 VIA_M1M2_PR
* cell instance $5579 r0 *1 174.11,148.07
X$5579 \$1363 VIA_M1M2_PR
* cell instance $5580 r0 *1 173.19,142.63
X$5580 \$1363 VIA_M1M2_PR
* cell instance $5581 r0 *1 173.19,140.93
X$5581 \$1363 VIA_M1M2_PR
* cell instance $5582 r0 *1 167.67,156.91
X$5582 \$1363 VIA_M1M2_PR
* cell instance $5583 r0 *1 174.57,132.43
X$5583 \$1363 VIA_M1M2_PR
* cell instance $5584 r0 *1 174.57,129.03
X$5584 \$1363 VIA_M1M2_PR
* cell instance $5585 r0 *1 174.57,118.49
X$5585 \$1363 VIA_M1M2_PR
* cell instance $5586 r0 *1 154.79,189.55
X$5586 \$1363 VIA_M1M2_PR
* cell instance $5587 r0 *1 152.03,189.21
X$5587 \$1363 VIA_M1M2_PR
* cell instance $5588 r0 *1 152.49,183.43
X$5588 \$1363 VIA_M1M2_PR
* cell instance $5589 r0 *1 154.79,192.27
X$5589 \$1363 VIA_M1M2_PR
* cell instance $5590 r0 *1 154.79,188.53
X$5590 \$1363 VIA_M1M2_PR
* cell instance $5591 r0 *1 156.17,183.77
X$5591 \$1363 VIA_M1M2_PR
* cell instance $5592 r0 *1 156.17,181.05
X$5592 \$1363 VIA_M1M2_PR
* cell instance $5593 r0 *1 154.33,183.77
X$5593 \$1363 VIA_L1M1_PR_MR
* cell instance $5594 r0 *1 152.03,189.21
X$5594 \$1363 VIA_L1M1_PR_MR
* cell instance $5595 r0 *1 154.79,188.53
X$5595 \$1363 VIA_L1M1_PR_MR
* cell instance $5596 r0 *1 155.71,191.59
X$5596 \$1363 VIA_L1M1_PR_MR
* cell instance $5597 r0 *1 174.57,137.53
X$5597 \$1363 VIA_L1M1_PR_MR
* cell instance $5598 r0 *1 174.57,118.49
X$5598 \$1363 VIA_L1M1_PR_MR
* cell instance $5599 r0 *1 171.765,135.15
X$5599 \$1363 VIA_L1M1_PR_MR
* cell instance $5600 r0 *1 172.64,140.25
X$5600 \$1363 VIA_L1M1_PR_MR
* cell instance $5601 r0 *1 172.27,142.63
X$5601 \$1363 VIA_L1M1_PR_MR
* cell instance $5602 r0 *1 178.71,249.05
X$5602 \$1363 VIA_L1M1_PR_MR
* cell instance $5603 r0 *1 170.89,136.51
X$5603 \$1363 VIA_L1M1_PR_MR
* cell instance $5604 r0 *1 175.03,134.81
X$5604 \$1363 VIA_L1M1_PR_MR
* cell instance $5605 r0 *1 176.87,118.49
X$5605 \$1363 VIA_L1M1_PR_MR
* cell instance $5606 r0 *1 174.11,129.03
X$5606 \$1363 VIA_L1M1_PR_MR
* cell instance $5607 r0 *1 170.43,245.99
X$5607 \$1363 VIA_L1M1_PR_MR
* cell instance $5608 r0 *1 176.87,150.45
X$5608 \$1363 VIA_L1M1_PR_MR
* cell instance $5609 r0 *1 175.49,151.13
X$5609 \$1363 VIA_L1M1_PR_MR
* cell instance $5610 r0 *1 174.57,148.07
X$5610 \$1363 VIA_L1M1_PR_MR
* cell instance $5611 r0 *1 167.67,254.49
X$5611 \$1363 VIA_L1M1_PR_MR
* cell instance $5612 r0 *1 165.37,169.83
X$5612 \$1363 VIA_L1M1_PR_MR
* cell instance $5613 r0 *1 170.43,256.19
X$5613 \$1363 VIA_L1M1_PR_MR
* cell instance $5614 r0 *1 169.51,253.47
X$5614 \$1363 VIA_L1M1_PR_MR
* cell instance $5615 r0 *1 156.63,181.05
X$5615 \$1363 VIA_L1M1_PR_MR
* cell instance $5616 r0 *1 169.51,255.17
X$5616 \$1363 VIA_L1M1_PR_MR
* cell instance $5617 r0 *1 170.89,156.57
X$5617 \$1363 VIA_L1M1_PR_MR
* cell instance $5618 r0 *1 170.43,154.53
X$5618 \$1363 VIA_L1M1_PR_MR
* cell instance $5619 r0 *1 168.13,151.47
X$5619 \$1363 VIA_L1M1_PR_MR
* cell instance $5620 r0 *1 167.67,167.45
X$5620 \$1363 VIA_L1M1_PR_MR
* cell instance $5621 r0 *1 175.95,107.61
X$5621 \$1363 VIA_L1M1_PR_MR
* cell instance $5622 r0 *1 169.51,96.73
X$5622 \$1363 VIA_L1M1_PR_MR
* cell instance $5623 r0 *1 169.97,114.75
X$5623 \$1363 VIA_L1M1_PR_MR
* cell instance $5624 r0 *1 173.65,113.05
X$5624 \$1363 VIA_L1M1_PR_MR
* cell instance $5625 r0 *1 169.51,113.05
X$5625 \$1363 VIA_L1M1_PR_MR
* cell instance $5626 r0 *1 178.25,93.67
X$5626 \$1363 VIA_L1M1_PR_MR
* cell instance $5627 r0 *1 175.49,115.09
X$5627 \$1363 VIA_L1M1_PR_MR
* cell instance $5628 r0 *1 176.87,112.71
X$5628 \$1363 VIA_L1M1_PR_MR
* cell instance $5629 r0 *1 175.49,110.33
X$5629 \$1363 VIA_L1M1_PR_MR
* cell instance $5630 r0 *1 168.13,85.85
X$5630 \$1363 VIA_L1M1_PR_MR
* cell instance $5631 r0 *1 165.83,88.57
X$5631 \$1363 VIA_L1M1_PR_MR
* cell instance $5632 r0 *1 167.67,91.29
X$5632 \$1363 VIA_L1M1_PR_MR
* cell instance $5633 r0 *1 172.27,83.13
X$5633 \$1363 VIA_L1M1_PR_MR
* cell instance $5634 r0 *1 166.75,93.67
X$5634 \$1363 VIA_L1M1_PR_MR
* cell instance $5635 r0 *1 176.41,187.17
X$5635 \$1363 VIA_L1M1_PR_MR
* cell instance $5636 r0 *1 112.47,80.07
X$5636 \$1386 VIA_M1M2_PR
* cell instance $5637 r0 *1 112.47,82.45
X$5637 \$1386 VIA_M1M2_PR
* cell instance $5638 r0 *1 116.61,82.45
X$5638 \$1386 VIA_L1M1_PR_MR
* cell instance $5639 r0 *1 112.47,80.07
X$5639 \$1386 VIA_L1M1_PR_MR
* cell instance $5640 r0 *1 113.39,88.23
X$5640 \$1402 VIA_M1M2_PR
* cell instance $5641 r0 *1 113.39,90.95
X$5641 \$1402 VIA_M1M2_PR
* cell instance $5642 r0 *1 114.31,88.23
X$5642 \$1402 VIA_L1M1_PR_MR
* cell instance $5643 r0 *1 112.93,90.95
X$5643 \$1402 VIA_L1M1_PR_MR
* cell instance $5644 r0 *1 120.75,88.23
X$5644 \$1402 VIA_L1M1_PR_MR
* cell instance $5645 r0 *1 117.53,88.74
X$5645 \$1404 VIA_M2M3_PR
* cell instance $5646 r0 *1 121.21,88.74
X$5646 \$1404 VIA_M2M3_PR
* cell instance $5647 r0 *1 117.53,87.89
X$5647 \$1404 VIA_M1M2_PR
* cell instance $5648 r0 *1 117.53,86.53
X$5648 \$1404 VIA_M1M2_PR
* cell instance $5649 r0 *1 121.21,88.57
X$5649 \$1404 VIA_M1M2_PR
* cell instance $5650 r0 *1 115.69,88.23
X$5650 \$1404 VIA_L1M1_PR_MR
* cell instance $5651 r0 *1 117.53,86.53
X$5651 \$1404 VIA_L1M1_PR_MR
* cell instance $5652 r0 *1 121.21,88.57
X$5652 \$1404 VIA_L1M1_PR_MR
* cell instance $5653 r0 *1 158.47,191.42
X$5653 \$1412 VIA_M2M3_PR
* cell instance $5654 r0 *1 169.97,224.74
X$5654 \$1412 VIA_M2M3_PR
* cell instance $5655 r0 *1 170.89,249.22
X$5655 \$1412 VIA_M2M3_PR
* cell instance $5656 r0 *1 166.29,221.34
X$5656 \$1412 VIA_M2M3_PR
* cell instance $5657 r0 *1 169.97,221.34
X$5657 \$1412 VIA_M2M3_PR
* cell instance $5658 r0 *1 172.27,191.42
X$5658 \$1412 VIA_M2M3_PR
* cell instance $5659 r0 *1 168.59,225.42
X$5659 \$1412 VIA_M2M3_PR
* cell instance $5660 r0 *1 179.63,249.22
X$5660 \$1412 VIA_M2M3_PR
* cell instance $5661 r0 *1 177.79,113.05
X$5661 \$1412 VIA_M1M2_PR
* cell instance $5662 r0 *1 169.97,88.91
X$5662 \$1412 VIA_M1M2_PR
* cell instance $5663 r0 *1 169.97,94.35
X$5663 \$1412 VIA_M1M2_PR
* cell instance $5664 r0 *1 169.97,85.85
X$5664 \$1412 VIA_M1M2_PR
* cell instance $5665 r0 *1 169.97,87.89
X$5665 \$1412 VIA_M1M2_PR
* cell instance $5666 r0 *1 169.97,97.07
X$5666 \$1412 VIA_M1M2_PR
* cell instance $5667 r0 *1 170.89,114.75
X$5667 \$1412 VIA_M1M2_PR
* cell instance $5668 r0 *1 166.29,93.67
X$5668 \$1412 VIA_M1M2_PR
* cell instance $5669 r0 *1 166.29,96.73
X$5669 \$1412 VIA_M1M2_PR
* cell instance $5670 r0 *1 171.81,113.05
X$5670 \$1412 VIA_M1M2_PR
* cell instance $5671 r0 *1 170.89,113.05
X$5671 \$1412 VIA_M1M2_PR
* cell instance $5672 r0 *1 169.97,108.29
X$5672 \$1412 VIA_M1M2_PR
* cell instance $5673 r0 *1 169.97,109.31
X$5673 \$1412 VIA_M1M2_PR
* cell instance $5674 r0 *1 171.81,108.29
X$5674 \$1412 VIA_M1M2_PR
* cell instance $5675 r0 *1 179.63,249.05
X$5675 \$1412 VIA_M1M2_PR
* cell instance $5676 r0 *1 170.89,248.03
X$5676 \$1412 VIA_M1M2_PR
* cell instance $5677 r0 *1 170.89,254.15
X$5677 \$1412 VIA_M1M2_PR
* cell instance $5678 r0 *1 170.89,246.33
X$5678 \$1412 VIA_M1M2_PR
* cell instance $5679 r0 *1 170.89,256.53
X$5679 \$1412 VIA_M1M2_PR
* cell instance $5680 r0 *1 169.51,245.99
X$5680 \$1412 VIA_M1M2_PR
* cell instance $5681 r0 *1 168.59,200.77
X$5681 \$1412 VIA_M1M2_PR
* cell instance $5682 r0 *1 172.27,200.77
X$5682 \$1412 VIA_M1M2_PR
* cell instance $5683 r0 *1 168.59,202.13
X$5683 \$1412 VIA_M1M2_PR
* cell instance $5684 r0 *1 172.73,183.77
X$5684 \$1412 VIA_M1M2_PR
* cell instance $5685 r0 *1 166.75,202.13
X$5685 \$1412 VIA_M1M2_PR
* cell instance $5686 r0 *1 168.59,153.17
X$5686 \$1412 VIA_M1M2_PR
* cell instance $5687 r0 *1 168.59,151.13
X$5687 \$1412 VIA_M1M2_PR
* cell instance $5688 r0 *1 168.59,154.19
X$5688 \$1412 VIA_M1M2_PR
* cell instance $5689 r0 *1 168.59,159.29
X$5689 \$1412 VIA_M1M2_PR
* cell instance $5690 r0 *1 168.59,156.57
X$5690 \$1412 VIA_M1M2_PR
* cell instance $5691 r0 *1 177.79,153.51
X$5691 \$1412 VIA_M1M2_PR
* cell instance $5692 r0 *1 169.51,131.75
X$5692 \$1412 VIA_M1M2_PR
* cell instance $5693 r0 *1 177.79,135.49
X$5693 \$1412 VIA_M1M2_PR
* cell instance $5694 r0 *1 176.87,134.81
X$5694 \$1412 VIA_M1M2_PR
* cell instance $5695 r0 *1 177.79,147.73
X$5695 \$1412 VIA_M1M2_PR
* cell instance $5696 r0 *1 169.51,118.49
X$5696 \$1412 VIA_M1M2_PR
* cell instance $5697 r0 *1 170.89,118.49
X$5697 \$1412 VIA_M1M2_PR
* cell instance $5698 r0 *1 169.51,128.35
X$5698 \$1412 VIA_M1M2_PR
* cell instance $5699 r0 *1 168.59,131.75
X$5699 \$1412 VIA_M1M2_PR
* cell instance $5700 r0 *1 168.59,167.45
X$5700 \$1412 VIA_M1M2_PR
* cell instance $5701 r0 *1 156.17,189.21
X$5701 \$1412 VIA_M1M2_PR
* cell instance $5702 r0 *1 156.17,191.59
X$5702 \$1412 VIA_M1M2_PR
* cell instance $5703 r0 *1 172.73,185.81
X$5703 \$1412 VIA_M1M2_PR
* cell instance $5704 r0 *1 155.71,180.71
X$5704 \$1412 VIA_M1M2_PR
* cell instance $5705 r0 *1 155.71,172.89
X$5705 \$1412 VIA_M1M2_PR
* cell instance $5706 r0 *1 168.59,172.21
X$5706 \$1412 VIA_M1M2_PR
* cell instance $5707 r0 *1 158.47,191.59
X$5707 \$1412 VIA_M1M2_PR
* cell instance $5708 r0 *1 177.79,114.75
X$5708 \$1412 VIA_M1M2_PR
* cell instance $5709 r0 *1 152.95,189.21
X$5709 \$1412 VIA_L1M1_PR_MR
* cell instance $5710 r0 *1 172.73,183.77
X$5710 \$1412 VIA_L1M1_PR_MR
* cell instance $5711 r0 *1 153.41,189.21
X$5711 \$1412 VIA_L1M1_PR_MR
* cell instance $5712 r0 *1 177.33,185.81
X$5712 \$1412 VIA_L1M1_PR_MR
* cell instance $5713 r0 *1 186.53,186.15
X$5713 \$1412 VIA_L1M1_PR_MR
* cell instance $5714 r0 *1 168.59,202.13
X$5714 \$1412 VIA_L1M1_PR_MR
* cell instance $5715 r0 *1 169.05,131.75
X$5715 \$1412 VIA_L1M1_PR_MR
* cell instance $5716 r0 *1 179.63,249.05
X$5716 \$1412 VIA_L1M1_PR_MR
* cell instance $5717 r0 *1 172.73,118.49
X$5717 \$1412 VIA_L1M1_PR_MR
* cell instance $5718 r0 *1 172.27,128.69
X$5718 \$1412 VIA_L1M1_PR_MR
* cell instance $5719 r0 *1 178.25,134.81
X$5719 \$1412 VIA_L1M1_PR_MR
* cell instance $5720 r0 *1 175.95,153.85
X$5720 \$1412 VIA_L1M1_PR_MR
* cell instance $5721 r0 *1 169.51,245.99
X$5721 \$1412 VIA_L1M1_PR_MR
* cell instance $5722 r0 *1 177.33,147.73
X$5722 \$1412 VIA_L1M1_PR_MR
* cell instance $5723 r0 *1 177.33,153.51
X$5723 \$1412 VIA_L1M1_PR_MR
* cell instance $5724 r0 *1 165.83,254.49
X$5724 \$1412 VIA_L1M1_PR_MR
* cell instance $5725 r0 *1 168.59,167.45
X$5725 \$1412 VIA_L1M1_PR_MR
* cell instance $5726 r0 *1 154.79,180.71
X$5726 \$1412 VIA_L1M1_PR_MR
* cell instance $5727 r0 *1 157.09,191.59
X$5727 \$1412 VIA_L1M1_PR_MR
* cell instance $5728 r0 *1 170.89,246.33
X$5728 \$1412 VIA_L1M1_PR_MR
* cell instance $5729 r0 *1 159.85,172.89
X$5729 \$1412 VIA_L1M1_PR_MR
* cell instance $5730 r0 *1 169.51,153.17
X$5730 \$1412 VIA_L1M1_PR_MR
* cell instance $5731 r0 *1 173.19,156.57
X$5731 \$1412 VIA_L1M1_PR_MR
* cell instance $5732 r0 *1 169.97,156.57
X$5732 \$1412 VIA_L1M1_PR_MR
* cell instance $5733 r0 *1 172.27,158.95
X$5733 \$1412 VIA_L1M1_PR_MR
* cell instance $5734 r0 *1 169.97,150.45
X$5734 \$1412 VIA_L1M1_PR_MR
* cell instance $5735 r0 *1 171.35,151.13
X$5735 \$1412 VIA_L1M1_PR_MR
* cell instance $5736 r0 *1 172.27,256.87
X$5736 \$1412 VIA_L1M1_PR_MR
* cell instance $5737 r0 *1 168.59,248.03
X$5737 \$1412 VIA_L1M1_PR_MR
* cell instance $5738 r0 *1 170.89,256.53
X$5738 \$1412 VIA_L1M1_PR_MR
* cell instance $5739 r0 *1 176.41,134.81
X$5739 \$1412 VIA_L1M1_PR_MR
* cell instance $5740 r0 *1 175.95,115.09
X$5740 \$1412 VIA_L1M1_PR_MR
* cell instance $5741 r0 *1 169.05,96.73
X$5741 \$1412 VIA_L1M1_PR_MR
* cell instance $5742 r0 *1 170.43,114.75
X$5742 \$1412 VIA_L1M1_PR_MR
* cell instance $5743 r0 *1 169.97,109.31
X$5743 \$1412 VIA_L1M1_PR_MR
* cell instance $5744 r0 *1 171.81,108.29
X$5744 \$1412 VIA_L1M1_PR_MR
* cell instance $5745 r0 *1 176.41,93.67
X$5745 \$1412 VIA_L1M1_PR_MR
* cell instance $5746 r0 *1 179.17,93.67
X$5746 \$1412 VIA_L1M1_PR_MR
* cell instance $5747 r0 *1 177.79,113.05
X$5747 \$1412 VIA_L1M1_PR_MR
* cell instance $5748 r0 *1 170.89,113.05
X$5748 \$1412 VIA_L1M1_PR_MR
* cell instance $5749 r0 *1 171.35,113.05
X$5749 \$1412 VIA_L1M1_PR_MR
* cell instance $5750 r0 *1 166.29,93.67
X$5750 \$1412 VIA_L1M1_PR_MR
* cell instance $5751 r0 *1 167.21,85.51
X$5751 \$1412 VIA_L1M1_PR_MR
* cell instance $5752 r0 *1 169.97,85.85
X$5752 \$1412 VIA_L1M1_PR_MR
* cell instance $5753 r0 *1 171.81,88.23
X$5753 \$1412 VIA_L1M1_PR_MR
* cell instance $5754 r0 *1 169.97,88.91
X$5754 \$1412 VIA_L1M1_PR_MR
* cell instance $5755 r0 *1 174.11,88.23
X$5755 \$1417 VIA_L1M1_PR_MR
* cell instance $5756 r0 *1 167.67,88.57
X$5756 \$1417 VIA_L1M1_PR_MR
* cell instance $5757 r0 *1 174.57,85.85
X$5757 \$1418 VIA_M1M2_PR
* cell instance $5758 r0 *1 176.41,86.19
X$5758 \$1418 VIA_M1M2_PR
* cell instance $5759 r0 *1 174.57,83.81
X$5759 \$1418 VIA_M1M2_PR
* cell instance $5760 r0 *1 176.41,88.23
X$5760 \$1418 VIA_M1M2_PR
* cell instance $5761 r0 *1 176.41,88.23
X$5761 \$1418 VIA_L1M1_PR_MR
* cell instance $5762 r0 *1 174.57,83.81
X$5762 \$1418 VIA_L1M1_PR_MR
* cell instance $5763 r0 *1 174.57,85.85
X$5763 \$1418 VIA_L1M1_PR_MR
* cell instance $5764 r0 *1 175.03,90.95
X$5764 \$1419 VIA_M1M2_PR
* cell instance $5765 r0 *1 175.03,85.85
X$5765 \$1419 VIA_M1M2_PR
* cell instance $5766 r0 *1 175.03,88.23
X$5766 \$1419 VIA_M1M2_PR
* cell instance $5767 r0 *1 175.03,85.85
X$5767 \$1419 VIA_L1M1_PR_MR
* cell instance $5768 r0 *1 175.03,88.23
X$5768 \$1419 VIA_L1M1_PR_MR
* cell instance $5769 r0 *1 174.11,90.95
X$5769 \$1419 VIA_L1M1_PR_MR
* cell instance $5770 r0 *1 181.47,85.85
X$5770 \$1421 VIA_M1M2_PR
* cell instance $5771 r0 *1 181.47,90.27
X$5771 \$1421 VIA_M1M2_PR
* cell instance $5772 r0 *1 181.01,90.27
X$5772 \$1421 VIA_L1M1_PR_MR
* cell instance $5773 r0 *1 175.95,85.85
X$5773 \$1421 VIA_L1M1_PR_MR
* cell instance $5774 r0 *1 174.11,85.51
X$5774 \$1424 VIA_M1M2_PR
* cell instance $5775 r0 *1 174.11,96.73
X$5775 \$1424 VIA_M1M2_PR
* cell instance $5776 r0 *1 174.57,96.73
X$5776 \$1424 VIA_L1M1_PR_MR
* cell instance $5777 r0 *1 175.49,85.51
X$5777 \$1424 VIA_L1M1_PR_MR
* cell instance $5778 r0 *1 133.63,86.19
X$5778 \$1425 VIA_M1M2_PR
* cell instance $5779 r0 *1 170.43,210.97
X$5779 \$1425 VIA_M1M2_PR
* cell instance $5780 r0 *1 169.51,208.25
X$5780 \$1425 VIA_M1M2_PR
* cell instance $5781 r0 *1 170.43,209.95
X$5781 \$1425 VIA_M1M2_PR
* cell instance $5782 r0 *1 169.51,209.95
X$5782 \$1425 VIA_M1M2_PR
* cell instance $5783 r0 *1 133.63,208.25
X$5783 \$1425 VIA_M1M2_PR
* cell instance $5784 r0 *1 170.43,210.97
X$5784 \$1425 VIA_L1M1_PR_MR
* cell instance $5785 r0 *1 173.65,86.19
X$5785 \$1425 VIA_L1M1_PR_MR
* cell instance $5786 r0 *1 174.57,91.29
X$5786 \$1427 VIA_M1M2_PR
* cell instance $5787 r0 *1 175.03,96.39
X$5787 \$1427 VIA_M1M2_PR
* cell instance $5788 r0 *1 179.17,91.29
X$5788 \$1427 VIA_M1M2_PR
* cell instance $5789 r0 *1 179.17,90.61
X$5789 \$1427 VIA_M1M2_PR
* cell instance $5790 r0 *1 174.57,86.53
X$5790 \$1427 VIA_M1M2_PR
* cell instance $5791 r0 *1 175.49,90.95
X$5791 \$1427 VIA_L1M1_PR_MR
* cell instance $5792 r0 *1 175.49,96.39
X$5792 \$1427 VIA_L1M1_PR_MR
* cell instance $5793 r0 *1 179.17,91.29
X$5793 \$1427 VIA_L1M1_PR_MR
* cell instance $5794 r0 *1 169.05,86.53
X$5794 \$1427 VIA_L1M1_PR_MR
* cell instance $5795 r0 *1 174.57,91.29
X$5795 \$1427 VIA_L1M1_PR_MR
* cell instance $5796 r0 *1 169.05,85.51
X$5796 \$1428 VIA_M1M2_PR
* cell instance $5797 r0 *1 169.05,91.29
X$5797 \$1428 VIA_M1M2_PR
* cell instance $5798 r0 *1 169.05,91.29
X$5798 \$1428 VIA_L1M1_PR_MR
* cell instance $5799 r0 *1 170.43,85.51
X$5799 \$1428 VIA_L1M1_PR_MR
* cell instance $5800 r0 *1 114.31,96.73
X$5800 \$1438 VIA_M1M2_PR
* cell instance $5801 r0 *1 114.31,87.55
X$5801 \$1438 VIA_M1M2_PR
* cell instance $5802 r0 *1 114.31,91.29
X$5802 \$1438 VIA_M1M2_PR
* cell instance $5803 r0 *1 115.23,91.29
X$5803 \$1438 VIA_L1M1_PR_MR
* cell instance $5804 r0 *1 117.07,87.55
X$5804 \$1438 VIA_L1M1_PR_MR
* cell instance $5805 r0 *1 112.01,97.07
X$5805 \$1438 VIA_L1M1_PR_MR
* cell instance $5806 r0 *1 113.39,96.9
X$5806 \$1453 VIA_M2M3_PR
* cell instance $5807 r0 *1 123.97,96.9
X$5807 \$1453 VIA_M2M3_PR
* cell instance $5808 r0 *1 113.39,96.05
X$5808 \$1453 VIA_M1M2_PR
* cell instance $5809 r0 *1 113.39,91.63
X$5809 \$1453 VIA_M1M2_PR
* cell instance $5810 r0 *1 123.97,101.83
X$5810 \$1453 VIA_M1M2_PR
* cell instance $5811 r0 *1 123.97,98.43
X$5811 \$1453 VIA_M1M2_PR
* cell instance $5812 r0 *1 123.97,98.43
X$5812 \$1453 VIA_L1M1_PR_MR
* cell instance $5813 r0 *1 123.51,101.83
X$5813 \$1453 VIA_L1M1_PR_MR
* cell instance $5814 r0 *1 116.15,91.29
X$5814 \$1453 VIA_L1M1_PR_MR
* cell instance $5815 r0 *1 110.17,96.73
X$5815 \$1453 VIA_L1M1_PR_MR
* cell instance $5816 r0 *1 124.43,109.99
X$5816 \$1459 VIA_M1M2_PR
* cell instance $5817 r0 *1 127.65,107.61
X$5817 \$1459 VIA_M1M2_PR
* cell instance $5818 r0 *1 127.65,109.99
X$5818 \$1459 VIA_M1M2_PR
* cell instance $5819 r0 *1 124.43,97.07
X$5819 \$1459 VIA_M1M2_PR
* cell instance $5820 r0 *1 124.43,99.45
X$5820 \$1459 VIA_M1M2_PR
* cell instance $5821 r0 *1 124.43,91.97
X$5821 \$1459 VIA_M1M2_PR
* cell instance $5822 r0 *1 115.23,99.45
X$5822 \$1459 VIA_L1M1_PR_MR
* cell instance $5823 r0 *1 124.43,109.99
X$5823 \$1459 VIA_L1M1_PR_MR
* cell instance $5824 r0 *1 127.65,107.61
X$5824 \$1459 VIA_L1M1_PR_MR
* cell instance $5825 r0 *1 126.73,91.63
X$5825 \$1459 VIA_L1M1_PR_MR
* cell instance $5826 r0 *1 122.13,91.63
X$5826 \$1459 VIA_L1M1_PR_MR
* cell instance $5827 r0 *1 123.05,96.73
X$5827 \$1459 VIA_L1M1_PR_MR
* cell instance $5828 r0 *1 123.51,96.73
X$5828 \$1459 VIA_L1M1_PR_MR
* cell instance $5829 r0 *1 143.98,88.74
X$5829 \$1460 VIA_M3M4_PR
* cell instance $5830 r0 *1 143.98,210.46
X$5830 \$1460 VIA_M3M4_PR
* cell instance $5831 r0 *1 174.11,210.46
X$5831 \$1460 VIA_M2M3_PR
* cell instance $5832 r0 *1 173.65,88.74
X$5832 \$1460 VIA_M2M3_PR
* cell instance $5833 r0 *1 173.65,88.57
X$5833 \$1460 VIA_M1M2_PR
* cell instance $5834 r0 *1 174.11,210.97
X$5834 \$1460 VIA_M1M2_PR
* cell instance $5835 r0 *1 174.11,210.97
X$5835 \$1460 VIA_L1M1_PR_MR
* cell instance $5836 r0 *1 173.65,88.57
X$5836 \$1460 VIA_L1M1_PR_MR
* cell instance $5837 r0 *1 170.89,90.27
X$5837 \$1465 VIA_M1M2_PR
* cell instance $5838 r0 *1 170.89,88.23
X$5838 \$1465 VIA_M1M2_PR
* cell instance $5839 r0 *1 170.89,90.95
X$5839 \$1465 VIA_M1M2_PR
* cell instance $5840 r0 *1 170.89,94.01
X$5840 \$1465 VIA_M1M2_PR
* cell instance $5841 r0 *1 168.59,91.29
X$5841 \$1465 VIA_L1M1_PR_MR
* cell instance $5842 r0 *1 166.75,88.23
X$5842 \$1465 VIA_L1M1_PR_MR
* cell instance $5843 r0 *1 170.89,90.27
X$5843 \$1465 VIA_L1M1_PR_MR
* cell instance $5844 r0 *1 174.57,94.01
X$5844 \$1465 VIA_L1M1_PR_MR
* cell instance $5845 r0 *1 173.19,92.99
X$5845 \$1467 VIA_M1M2_PR
* cell instance $5846 r0 *1 173.19,91.29
X$5846 \$1467 VIA_M1M2_PR
* cell instance $5847 r0 *1 173.65,99.11
X$5847 \$1467 VIA_M1M2_PR
* cell instance $5848 r0 *1 173.65,96.73
X$5848 \$1467 VIA_M1M2_PR
* cell instance $5849 r0 *1 173.19,99.11
X$5849 \$1467 VIA_L1M1_PR_MR
* cell instance $5850 r0 *1 173.65,96.73
X$5850 \$1467 VIA_L1M1_PR_MR
* cell instance $5851 r0 *1 175.95,96.73
X$5851 \$1467 VIA_L1M1_PR_MR
* cell instance $5852 r0 *1 172.73,91.29
X$5852 \$1467 VIA_L1M1_PR_MR
* cell instance $5853 r0 *1 167.21,92.99
X$5853 \$1467 VIA_L1M1_PR_MR
* cell instance $5854 r0 *1 177.79,92.99
X$5854 \$1468 VIA_M1M2_PR
* cell instance $5855 r0 *1 177.79,91.29
X$5855 \$1468 VIA_M1M2_PR
* cell instance $5856 r0 *1 179.17,92.99
X$5856 \$1468 VIA_L1M1_PR_MR
* cell instance $5857 r0 *1 177.79,91.29
X$5857 \$1468 VIA_L1M1_PR_MR
* cell instance $5858 r0 *1 173.65,91.29
X$5858 \$1468 VIA_L1M1_PR_MR
* cell instance $5859 r0 *1 170.845,91.63
X$5859 \$1468 VIA_L1M1_PR_MR
* cell instance $5860 r0 *1 172.73,88.23
X$5860 \$1472 VIA_M1M2_PR
* cell instance $5861 r0 *1 172.73,91.97
X$5861 \$1472 VIA_M1M2_PR
* cell instance $5862 r0 *1 178.71,91.97
X$5862 \$1472 VIA_M1M2_PR
* cell instance $5863 r0 *1 176.41,91.97
X$5863 \$1472 VIA_M1M2_PR
* cell instance $5864 r0 *1 178.71,95.71
X$5864 \$1472 VIA_M1M2_PR
* cell instance $5865 r0 *1 176.41,91.29
X$5865 \$1472 VIA_M1M2_PR
* cell instance $5866 r0 *1 173.19,96.73
X$5866 \$1472 VIA_L1M1_PR_MR
* cell instance $5867 r0 *1 179.63,91.63
X$5867 \$1472 VIA_L1M1_PR_MR
* cell instance $5868 r0 *1 176.41,91.29
X$5868 \$1472 VIA_L1M1_PR_MR
* cell instance $5869 r0 *1 178.71,95.71
X$5869 \$1472 VIA_L1M1_PR_MR
* cell instance $5870 r0 *1 172.73,88.23
X$5870 \$1472 VIA_L1M1_PR_MR
* cell instance $5871 r0 *1 182.85,91.29
X$5871 \$1474 VIA_M1M2_PR
* cell instance $5872 r0 *1 182.85,93.33
X$5872 \$1474 VIA_M1M2_PR
* cell instance $5873 r0 *1 177.33,90.95
X$5873 \$1474 VIA_L1M1_PR_MR
* cell instance $5874 r0 *1 180.09,91.29
X$5874 \$1474 VIA_L1M1_PR_MR
* cell instance $5875 r0 *1 182.85,93.33
X$5875 \$1474 VIA_L1M1_PR_MR
* cell instance $5876 r0 *1 178.71,89.25
X$5876 \$1482 VIA_M1M2_PR
* cell instance $5877 r0 *1 178.71,91.29
X$5877 \$1482 VIA_M1M2_PR
* cell instance $5878 r0 *1 178.71,91.29
X$5878 \$1482 VIA_L1M1_PR_MR
* cell instance $5879 r0 *1 170.89,89.25
X$5879 \$1482 VIA_L1M1_PR_MR
* cell instance $5880 r0 *1 170.43,93.67
X$5880 \$1489 VIA_M1M2_PR
* cell instance $5881 r0 *1 170.43,90.61
X$5881 \$1489 VIA_M1M2_PR
* cell instance $5882 r0 *1 170.43,96.73
X$5882 \$1489 VIA_M1M2_PR
* cell instance $5883 r0 *1 170.43,96.73
X$5883 \$1489 VIA_L1M1_PR_MR
* cell instance $5884 r0 *1 170.43,93.67
X$5884 \$1489 VIA_L1M1_PR_MR
* cell instance $5885 r0 *1 169.97,90.61
X$5885 \$1489 VIA_L1M1_PR_MR
* cell instance $5886 r0 *1 167.21,93.67
X$5886 \$1496 VIA_M1M2_PR
* cell instance $5887 r0 *1 167.21,91.63
X$5887 \$1496 VIA_M1M2_PR
* cell instance $5888 r0 *1 166.75,91.63
X$5888 \$1496 VIA_L1M1_PR_MR
* cell instance $5889 r0 *1 168.59,93.67
X$5889 \$1496 VIA_L1M1_PR_MR
* cell instance $5890 r0 *1 117.99,101.15
X$5890 \$1499 VIA_M1M2_PR
* cell instance $5891 r0 *1 117.99,89.25
X$5891 \$1499 VIA_M1M2_PR
* cell instance $5892 r0 *1 110.63,101.15
X$5892 \$1499 VIA_M1M2_PR
* cell instance $5893 r0 *1 110.63,99.11
X$5893 \$1499 VIA_M1M2_PR
* cell instance $5894 r0 *1 114.31,101.15
X$5894 \$1499 VIA_L1M1_PR_MR
* cell instance $5895 r0 *1 120.75,89.25
X$5895 \$1499 VIA_L1M1_PR_MR
* cell instance $5896 r0 *1 110.63,99.11
X$5896 \$1499 VIA_L1M1_PR_MR
* cell instance $5897 r0 *1 111.09,88.91
X$5897 \$1500 VIA_M1M2_PR
* cell instance $5898 r0 *1 111.09,93.67
X$5898 \$1500 VIA_M1M2_PR
* cell instance $5899 r0 *1 123.05,88.91
X$5899 \$1500 VIA_L1M1_PR_MR
* cell instance $5900 r0 *1 111.09,93.67
X$5900 \$1500 VIA_L1M1_PR_MR
* cell instance $5901 r0 *1 111.55,96.9
X$5901 \$1502 VIA_M2M3_PR
* cell instance $5902 r0 *1 110.17,96.9
X$5902 \$1502 VIA_M2M3_PR
* cell instance $5903 r0 *1 110.17,98.77
X$5903 \$1502 VIA_M1M2_PR
* cell instance $5904 r0 *1 123.05,88.23
X$5904 \$1502 VIA_M1M2_PR
* cell instance $5905 r0 *1 123.05,94.69
X$5905 \$1502 VIA_M1M2_PR
* cell instance $5906 r0 *1 111.55,94.01
X$5906 \$1502 VIA_M1M2_PR
* cell instance $5907 r0 *1 114.31,93.67
X$5907 \$1502 VIA_L1M1_PR_MR
* cell instance $5908 r0 *1 124.89,94.69
X$5908 \$1502 VIA_L1M1_PR_MR
* cell instance $5909 r0 *1 122.13,88.23
X$5909 \$1502 VIA_L1M1_PR_MR
* cell instance $5910 r0 *1 111.09,99.11
X$5910 \$1502 VIA_L1M1_PR_MR
* cell instance $5911 r0 *1 32.66,205.7
X$5911 \$1506 VIA_M3M4_PR
* cell instance $5912 r0 *1 32.66,94.18
X$5912 \$1506 VIA_M3M4_PR
* cell instance $5913 r0 *1 31.97,94.18
X$5913 \$1506 VIA_M2M3_PR
* cell instance $5914 r0 *1 32.43,205.7
X$5914 \$1506 VIA_M2M3_PR
* cell instance $5915 r0 *1 32.43,206.21
X$5915 \$1506 VIA_M1M2_PR
* cell instance $5916 r0 *1 31.97,94.01
X$5916 \$1506 VIA_M1M2_PR
* cell instance $5917 r0 *1 32.43,206.21
X$5917 \$1506 VIA_L1M1_PR_MR
* cell instance $5918 r0 *1 31.97,94.01
X$5918 \$1506 VIA_L1M1_PR_MR
* cell instance $5919 r0 *1 80.27,96.73
X$5919 \$1512 VIA_M1M2_PR
* cell instance $5920 r0 *1 80.27,94.69
X$5920 \$1512 VIA_M1M2_PR
* cell instance $5921 r0 *1 89.93,94.69
X$5921 \$1512 VIA_L1M1_PR_MR
* cell instance $5922 r0 *1 80.27,93.67
X$5922 \$1512 VIA_L1M1_PR_MR
* cell instance $5923 r0 *1 80.27,96.73
X$5923 \$1512 VIA_L1M1_PR_MR
* cell instance $5924 r0 *1 113.85,88.57
X$5924 \$1516 VIA_M1M2_PR
* cell instance $5925 r0 *1 113.85,93.33
X$5925 \$1516 VIA_M1M2_PR
* cell instance $5926 r0 *1 113.85,88.57
X$5926 \$1516 VIA_L1M1_PR_MR
* cell instance $5927 r0 *1 112.93,93.33
X$5927 \$1516 VIA_L1M1_PR_MR
* cell instance $5928 r0 *1 112.01,93.67
X$5928 \$1516 VIA_L1M1_PR_MR
* cell instance $5929 r0 *1 174.34,185.98
X$5929 \$1527 VIA_M3M4_PR
* cell instance $5930 r0 *1 174.34,234.26
X$5930 \$1527 VIA_M3M4_PR
* cell instance $5931 r0 *1 174.11,234.26
X$5931 \$1527 VIA_M2M3_PR
* cell instance $5932 r0 *1 173.19,185.98
X$5932 \$1527 VIA_M2M3_PR
* cell instance $5933 r0 *1 153.87,185.3
X$5933 \$1527 VIA_M2M3_PR
* cell instance $5934 r0 *1 175.03,107.61
X$5934 \$1527 VIA_M1M2_PR
* cell instance $5935 r0 *1 178.25,99.11
X$5935 \$1527 VIA_M1M2_PR
* cell instance $5936 r0 *1 175.03,102.51
X$5936 \$1527 VIA_M1M2_PR
* cell instance $5937 r0 *1 176.41,113.05
X$5937 \$1527 VIA_M1M2_PR
* cell instance $5938 r0 *1 173.65,116.45
X$5938 \$1527 VIA_M1M2_PR
* cell instance $5939 r0 *1 173.65,115.77
X$5939 \$1527 VIA_M1M2_PR
* cell instance $5940 r0 *1 178.25,94.35
X$5940 \$1527 VIA_M1M2_PR
* cell instance $5941 r0 *1 175.03,99.45
X$5941 \$1527 VIA_M1M2_PR
* cell instance $5942 r0 *1 175.95,249.05
X$5942 \$1527 VIA_M1M2_PR
* cell instance $5943 r0 *1 173.65,117.81
X$5943 \$1527 VIA_M1M2_PR
* cell instance $5944 r0 *1 174.11,243.95
X$5944 \$1527 VIA_M1M2_PR
* cell instance $5945 r0 *1 174.11,240.21
X$5945 \$1527 VIA_M1M2_PR
* cell instance $5946 r0 *1 174.11,242.93
X$5946 \$1527 VIA_M1M2_PR
* cell instance $5947 r0 *1 173.19,186.15
X$5947 \$1527 VIA_M1M2_PR
* cell instance $5948 r0 *1 174.57,156.57
X$5948 \$1527 VIA_M1M2_PR
* cell instance $5949 r0 *1 174.57,153.51
X$5949 \$1527 VIA_M1M2_PR
* cell instance $5950 r0 *1 166.75,137.19
X$5950 \$1527 VIA_M1M2_PR
* cell instance $5951 r0 *1 166.75,131.75
X$5951 \$1527 VIA_M1M2_PR
* cell instance $5952 r0 *1 174.57,145.69
X$5952 \$1527 VIA_M1M2_PR
* cell instance $5953 r0 *1 166.75,134.81
X$5953 \$1527 VIA_M1M2_PR
* cell instance $5954 r0 *1 174.11,134.81
X$5954 \$1527 VIA_M1M2_PR
* cell instance $5955 r0 *1 174.11,137.87
X$5955 \$1527 VIA_M1M2_PR
* cell instance $5956 r0 *1 153.87,183.77
X$5956 \$1527 VIA_M1M2_PR
* cell instance $5957 r0 *1 153.87,178.33
X$5957 \$1527 VIA_M1M2_PR
* cell instance $5958 r0 *1 176.41,116.45
X$5958 \$1527 VIA_M1M2_PR
* cell instance $5959 r0 *1 178.25,96.73
X$5959 \$1527 VIA_M1M2_PR
* cell instance $5960 r0 *1 152.03,183.77
X$5960 \$1527 VIA_L1M1_PR_MR
* cell instance $5961 r0 *1 153.87,183.77
X$5961 \$1527 VIA_L1M1_PR_MR
* cell instance $5962 r0 *1 167.215,243.72
X$5962 \$1527 VIA_L1M1_PR_MR
* cell instance $5963 r0 *1 169.05,240.55
X$5963 \$1527 VIA_L1M1_PR_MR
* cell instance $5964 r0 *1 173.19,186.15
X$5964 \$1527 VIA_L1M1_PR_MR
* cell instance $5965 r0 *1 175.95,242.93
X$5965 \$1527 VIA_L1M1_PR_MR
* cell instance $5966 r0 *1 171.35,137.19
X$5966 \$1527 VIA_L1M1_PR_MR
* cell instance $5967 r0 *1 173.19,137.19
X$5967 \$1527 VIA_L1M1_PR_MR
* cell instance $5968 r0 *1 170.43,118.15
X$5968 \$1527 VIA_L1M1_PR_MR
* cell instance $5969 r0 *1 175.95,249.05
X$5969 \$1527 VIA_L1M1_PR_MR
* cell instance $5970 r0 *1 168.13,131.75
X$5970 \$1527 VIA_L1M1_PR_MR
* cell instance $5971 r0 *1 173.65,134.81
X$5971 \$1527 VIA_L1M1_PR_MR
* cell instance $5972 r0 *1 166.29,131.75
X$5972 \$1527 VIA_L1M1_PR_MR
* cell instance $5973 r0 *1 175.95,145.69
X$5973 \$1527 VIA_L1M1_PR_MR
* cell instance $5974 r0 *1 166.75,137.19
X$5974 \$1527 VIA_L1M1_PR_MR
* cell instance $5975 r0 *1 166.75,134.81
X$5975 \$1527 VIA_L1M1_PR_MR
* cell instance $5976 r0 *1 175.03,156.57
X$5976 \$1527 VIA_L1M1_PR_MR
* cell instance $5977 r0 *1 154.33,178.33
X$5977 \$1527 VIA_L1M1_PR_MR
* cell instance $5978 r0 *1 174.57,153.51
X$5978 \$1527 VIA_L1M1_PR_MR
* cell instance $5979 r0 *1 172.73,102.17
X$5979 \$1527 VIA_L1M1_PR_MR
* cell instance $5980 r0 *1 178.25,96.73
X$5980 \$1527 VIA_L1M1_PR_MR
* cell instance $5981 r0 *1 176.41,99.11
X$5981 \$1527 VIA_L1M1_PR_MR
* cell instance $5982 r0 *1 179.63,112.71
X$5982 \$1527 VIA_L1M1_PR_MR
* cell instance $5983 r0 *1 174.57,99.45
X$5983 \$1527 VIA_L1M1_PR_MR
* cell instance $5984 r0 *1 173.65,115.09
X$5984 \$1527 VIA_L1M1_PR_MR
* cell instance $5985 r0 *1 169.51,115.09
X$5985 \$1527 VIA_L1M1_PR_MR
* cell instance $5986 r0 *1 173.65,115.77
X$5986 \$1527 VIA_L1M1_PR_MR
* cell instance $5987 r0 *1 181.01,94.01
X$5987 \$1527 VIA_L1M1_PR_MR
* cell instance $5988 r0 *1 181.93,93.67
X$5988 \$1527 VIA_L1M1_PR_MR
* cell instance $5989 r0 *1 175.03,107.61
X$5989 \$1527 VIA_L1M1_PR_MR
* cell instance $5990 r0 *1 176.41,113.05
X$5990 \$1527 VIA_L1M1_PR_MR
* cell instance $5991 r0 *1 198.95,96.22
X$5991 O[4] VIA_M2M3_PR
* cell instance $5992 r0 *1 184.69,249.05
X$5992 O[4] VIA_M1M2_PR
* cell instance $5993 r0 *1 198.95,189.89
X$5993 O[4] VIA_M1M2_PR
* cell instance $5994 r0 *1 184.69,189.89
X$5994 O[4] VIA_M1M2_PR
* cell instance $5995 r0 *1 182.85,249.05
X$5995 O[4] VIA_L1M1_PR_MR
* cell instance $5996 r0 *1 32.89,96.73
X$5996 \$1532 VIA_M1M2_PR
* cell instance $5997 r0 *1 32.89,102.51
X$5997 \$1532 VIA_M1M2_PR
* cell instance $5998 r0 *1 32.89,97.41
X$5998 \$1532 VIA_M1M2_PR
* cell instance $5999 r0 *1 32.89,93.67
X$5999 \$1532 VIA_M1M2_PR
* cell instance $6000 r0 *1 33.81,102.51
X$6000 \$1532 VIA_L1M1_PR_MR
* cell instance $6001 r0 *1 32.89,96.73
X$6001 \$1532 VIA_L1M1_PR_MR
* cell instance $6002 r0 *1 31.51,93.67
X$6002 \$1532 VIA_L1M1_PR_MR
* cell instance $6003 r0 *1 38.415,102.28
X$6003 \$1532 VIA_L1M1_PR_MR
* cell instance $6004 r0 *1 29.21,97.41
X$6004 \$1532 VIA_L1M1_PR_MR
* cell instance $6005 r0 *1 40.25,94.01
X$6005 \$1537 VIA_M1M2_PR
* cell instance $6006 r0 *1 40.25,95.71
X$6006 \$1537 VIA_M1M2_PR
* cell instance $6007 r0 *1 40.25,94.01
X$6007 \$1537 VIA_L1M1_PR_MR
* cell instance $6008 r0 *1 40.25,95.71
X$6008 \$1537 VIA_L1M1_PR_MR
* cell instance $6009 r0 *1 106.95,267.41
X$6009 \$1539 VIA_M1M2_PR
* cell instance $6010 r0 *1 165.83,267.41
X$6010 \$1539 VIA_M1M2_PR
* cell instance $6011 r0 *1 165.83,270.47
X$6011 \$1539 VIA_M1M2_PR
* cell instance $6012 r0 *1 106.95,96.39
X$6012 \$1539 VIA_M1M2_PR
* cell instance $6013 r0 *1 79.35,96.39
X$6013 \$1539 VIA_M1M2_PR
* cell instance $6014 r0 *1 79.35,94.69
X$6014 \$1539 VIA_M1M2_PR
* cell instance $6015 r0 *1 171.35,270.47
X$6015 \$1539 VIA_L1M1_PR_MR
* cell instance $6016 r0 *1 79.81,94.69
X$6016 \$1539 VIA_L1M1_PR_MR
* cell instance $6017 r0 *1 134.09,93.33
X$6017 \$1543 VIA_M1M2_PR
* cell instance $6018 r0 *1 134.09,215.73
X$6018 \$1543 VIA_M1M2_PR
* cell instance $6019 r0 *1 172.73,216.41
X$6019 \$1543 VIA_L1M1_PR_MR
* cell instance $6020 r0 *1 173.65,93.33
X$6020 \$1543 VIA_L1M1_PR_MR
* cell instance $6021 r0 *1 117.53,93.33
X$6021 \$1554 VIA_L1M1_PR_MR
* cell instance $6022 r0 *1 115.23,93.33
X$6022 \$1554 VIA_L1M1_PR_MR
* cell instance $6023 r0 *1 114.77,102.17
X$6023 \$1555 VIA_M1M2_PR
* cell instance $6024 r0 *1 114.77,97.41
X$6024 \$1555 VIA_M1M2_PR
* cell instance $6025 r0 *1 114.77,92.99
X$6025 \$1555 VIA_M1M2_PR
* cell instance $6026 r0 *1 113.39,93.67
X$6026 \$1555 VIA_L1M1_PR_MR
* cell instance $6027 r0 *1 113.39,92.99
X$6027 \$1555 VIA_L1M1_PR_MR
* cell instance $6028 r0 *1 114.31,97.41
X$6028 \$1555 VIA_L1M1_PR_MR
* cell instance $6029 r0 *1 114.77,102.17
X$6029 \$1555 VIA_L1M1_PR_MR
* cell instance $6030 r0 *1 112.47,93.67
X$6030 \$1555 VIA_L1M1_PR_MR
* cell instance $6031 r0 *1 115.23,96.39
X$6031 \$1557 VIA_M1M2_PR
* cell instance $6032 r0 *1 115.23,94.69
X$6032 \$1557 VIA_M1M2_PR
* cell instance $6033 r0 *1 110.17,94.69
X$6033 \$1557 VIA_L1M1_PR_MR
* cell instance $6034 r0 *1 121.67,96.39
X$6034 \$1557 VIA_L1M1_PR_MR
* cell instance $6035 r0 *1 30.13,96.9
X$6035 \$1558 VIA_M2M3_PR
* cell instance $6036 r0 *1 39.79,96.9
X$6036 \$1558 VIA_M2M3_PR
* cell instance $6037 r0 *1 79.81,101.15
X$6037 \$1558 VIA_M1M2_PR
* cell instance $6038 r0 *1 79.81,97.41
X$6038 \$1558 VIA_M1M2_PR
* cell instance $6039 r0 *1 79.81,96.73
X$6039 \$1558 VIA_M1M2_PR
* cell instance $6040 r0 *1 34.27,162.01
X$6040 \$1558 VIA_M1M2_PR
* cell instance $6041 r0 *1 33.81,206.21
X$6041 \$1558 VIA_M1M2_PR
* cell instance $6042 r0 *1 34.27,158.27
X$6042 \$1558 VIA_M1M2_PR
* cell instance $6043 r0 *1 25.07,156.57
X$6043 \$1558 VIA_M1M2_PR
* cell instance $6044 r0 *1 25.07,153.85
X$6044 \$1558 VIA_M1M2_PR
* cell instance $6045 r0 *1 27.83,158.27
X$6045 \$1558 VIA_M1M2_PR
* cell instance $6046 r0 *1 27.83,156.91
X$6046 \$1558 VIA_M1M2_PR
* cell instance $6047 r0 *1 34.27,154.19
X$6047 \$1558 VIA_M1M2_PR
* cell instance $6048 r0 *1 26.91,97.07
X$6048 \$1558 VIA_M1M2_PR
* cell instance $6049 r0 *1 26.91,98.43
X$6049 \$1558 VIA_M1M2_PR
* cell instance $6050 r0 *1 39.79,96.73
X$6050 \$1558 VIA_M1M2_PR
* cell instance $6051 r0 *1 39.79,99.11
X$6051 \$1558 VIA_M1M2_PR
* cell instance $6052 r0 *1 34.27,102.85
X$6052 \$1558 VIA_M1M2_PR
* cell instance $6053 r0 *1 30.13,97.07
X$6053 \$1558 VIA_M1M2_PR
* cell instance $6054 r0 *1 24.61,101.49
X$6054 \$1558 VIA_M1M2_PR
* cell instance $6055 r0 *1 24.61,98.43
X$6055 \$1558 VIA_M1M2_PR
* cell instance $6056 r0 *1 24.61,153.85
X$6056 \$1558 VIA_L1M1_PR_MR
* cell instance $6057 r0 *1 38.41,153.85
X$6057 \$1558 VIA_L1M1_PR_MR
* cell instance $6058 r0 *1 26.45,156.57
X$6058 \$1558 VIA_L1M1_PR_MR
* cell instance $6059 r0 *1 32.89,206.21
X$6059 \$1558 VIA_L1M1_PR_MR
* cell instance $6060 r0 *1 34.27,162.01
X$6060 \$1558 VIA_L1M1_PR_MR
* cell instance $6061 r0 *1 39.79,99.11
X$6061 \$1558 VIA_L1M1_PR_MR
* cell instance $6062 r0 *1 26.45,101.49
X$6062 \$1558 VIA_L1M1_PR_MR
* cell instance $6063 r0 *1 26.91,98.43
X$6063 \$1558 VIA_L1M1_PR_MR
* cell instance $6064 r0 *1 26.45,102.51
X$6064 \$1558 VIA_L1M1_PR_MR
* cell instance $6065 r0 *1 28.29,97.07
X$6065 \$1558 VIA_L1M1_PR_MR
* cell instance $6066 r0 *1 78.89,102.17
X$6066 \$1558 VIA_L1M1_PR_MR
* cell instance $6067 r0 *1 81.19,97.41
X$6067 \$1558 VIA_L1M1_PR_MR
* cell instance $6068 r0 *1 79.81,96.73
X$6068 \$1558 VIA_L1M1_PR_MR
* cell instance $6069 r0 *1 27.83,96.73
X$6069 \$1562 VIA_M1M2_PR
* cell instance $6070 r0 *1 27.83,106.59
X$6070 \$1562 VIA_M1M2_PR
* cell instance $6071 r0 *1 27.37,106.59
X$6071 \$1562 VIA_L1M1_PR_MR
* cell instance $6072 r0 *1 31.05,96.73
X$6072 \$1562 VIA_L1M1_PR_MR
* cell instance $6073 r0 *1 34.27,97.41
X$6073 \$1563 VIA_M1M2_PR
* cell instance $6074 r0 *1 34.27,98.43
X$6074 \$1563 VIA_M1M2_PR
* cell instance $6075 r0 *1 30.59,98.77
X$6075 \$1563 VIA_L1M1_PR_MR
* cell instance $6076 r0 *1 34.27,97.41
X$6076 \$1563 VIA_L1M1_PR_MR
* cell instance $6077 r0 *1 38.41,97.07
X$6077 \$1564 VIA_L1M1_PR_MR
* cell instance $6078 r0 *1 30.59,96.73
X$6078 \$1564 VIA_L1M1_PR_MR
* cell instance $6079 r0 *1 38.87,96.73
X$6079 \$1566 VIA_M1M2_PR
* cell instance $6080 r0 *1 38.87,98.77
X$6080 \$1566 VIA_M1M2_PR
* cell instance $6081 r0 *1 38.87,101.49
X$6081 \$1566 VIA_M1M2_PR
* cell instance $6082 r0 *1 32.43,96.39
X$6082 \$1566 VIA_L1M1_PR_MR
* cell instance $6083 r0 *1 37.95,96.73
X$6083 \$1566 VIA_L1M1_PR_MR
* cell instance $6084 r0 *1 37.95,102.17
X$6084 \$1566 VIA_L1M1_PR_MR
* cell instance $6085 r0 *1 38.87,98.77
X$6085 \$1566 VIA_L1M1_PR_MR
* cell instance $6086 r0 *1 83.49,98.77
X$6086 \$1571 VIA_L1M1_PR_MR
* cell instance $6087 r0 *1 80.73,98.43
X$6087 \$1571 VIA_L1M1_PR_MR
* cell instance $6088 r0 *1 118.45,104.21
X$6088 \$1582 VIA_M1M2_PR
* cell instance $6089 r0 *1 118.45,98.43
X$6089 \$1582 VIA_M1M2_PR
* cell instance $6090 r0 *1 114.31,98.43
X$6090 \$1582 VIA_M1M2_PR
* cell instance $6091 r0 *1 114.31,99.11
X$6091 \$1582 VIA_M1M2_PR
* cell instance $6092 r0 *1 118.45,91.29
X$6092 \$1582 VIA_M1M2_PR
* cell instance $6093 r0 *1 118.45,91.29
X$6093 \$1582 VIA_L1M1_PR_MR
* cell instance $6094 r0 *1 120.29,104.55
X$6094 \$1582 VIA_L1M1_PR_MR
* cell instance $6095 r0 *1 114.31,99.11
X$6095 \$1582 VIA_L1M1_PR_MR
* cell instance $6096 r0 *1 169.51,99.11
X$6096 \$1592 VIA_L1M1_PR_MR
* cell instance $6097 r0 *1 172.73,99.11
X$6097 \$1592 VIA_L1M1_PR_MR
* cell instance $6098 r0 *1 175.03,98.77
X$6098 \$1592 VIA_L1M1_PR_MR
* cell instance $6099 r0 *1 141.45,96.39
X$6099 \$1611 VIA_M1M2_PR
* cell instance $6100 r0 *1 141.45,213.01
X$6100 \$1611 VIA_M1M2_PR
* cell instance $6101 r0 *1 168.59,213.35
X$6101 \$1611 VIA_L1M1_PR_MR
* cell instance $6102 r0 *1 171.35,96.39
X$6102 \$1611 VIA_L1M1_PR_MR
* cell instance $6103 r0 *1 77.51,97.41
X$6103 \$1614 VIA_M1M2_PR
* cell instance $6104 r0 *1 77.51,104.55
X$6104 \$1614 VIA_M1M2_PR
* cell instance $6105 r0 *1 79.35,97.41
X$6105 \$1614 VIA_L1M1_PR_MR
* cell instance $6106 r0 *1 77.51,104.55
X$6106 \$1614 VIA_L1M1_PR_MR
* cell instance $6107 r0 *1 122.13,101.49
X$6107 \$1618 VIA_M1M2_PR
* cell instance $6108 r0 *1 122.13,100.13
X$6108 \$1618 VIA_M1M2_PR
* cell instance $6109 r0 *1 122.13,104.55
X$6109 \$1618 VIA_M1M2_PR
* cell instance $6110 r0 *1 122.13,97.41
X$6110 \$1618 VIA_M1M2_PR
* cell instance $6111 r0 *1 122.13,101.49
X$6111 \$1618 VIA_L1M1_PR_MR
* cell instance $6112 r0 *1 122.59,104.55
X$6112 \$1618 VIA_L1M1_PR_MR
* cell instance $6113 r0 *1 114.77,99.11
X$6113 \$1618 VIA_L1M1_PR_MR
* cell instance $6114 r0 *1 132.25,97.41
X$6114 \$1618 VIA_L1M1_PR_MR
* cell instance $6115 r0 *1 82.57,94.01
X$6115 \$1620 VIA_M1M2_PR
* cell instance $6116 r0 *1 82.57,96.05
X$6116 \$1620 VIA_M1M2_PR
* cell instance $6117 r0 *1 83.03,96.05
X$6117 \$1620 VIA_L1M1_PR_MR
* cell instance $6118 r0 *1 82.57,94.01
X$6118 \$1620 VIA_L1M1_PR_MR
* cell instance $6119 r0 *1 112.93,99.11
X$6119 \$1627 VIA_M1M2_PR
* cell instance $6120 r0 *1 112.93,97.41
X$6120 \$1627 VIA_M1M2_PR
* cell instance $6121 r0 *1 113.39,99.11
X$6121 \$1627 VIA_L1M1_PR_MR
* cell instance $6122 r0 *1 112.47,97.41
X$6122 \$1627 VIA_L1M1_PR_MR
* cell instance $6123 r0 *1 28.75,99.79
X$6123 \$1642 VIA_M1M2_PR
* cell instance $6124 r0 *1 28.75,101.49
X$6124 \$1642 VIA_M1M2_PR
* cell instance $6125 r0 *1 28.75,99.79
X$6125 \$1642 VIA_L1M1_PR_MR
* cell instance $6126 r0 *1 37.49,102.17
X$6126 \$1642 VIA_L1M1_PR_MR
* cell instance $6127 r0 *1 77.97,104.89
X$6127 \$1649 VIA_M1M2_PR
* cell instance $6128 r0 *1 77.97,99.79
X$6128 \$1649 VIA_M1M2_PR
* cell instance $6129 r0 *1 81.19,99.45
X$6129 \$1649 VIA_M1M2_PR
* cell instance $6130 r0 *1 79.35,107.95
X$6130 \$1649 VIA_M1M2_PR
* cell instance $6131 r0 *1 77.97,107.61
X$6131 \$1649 VIA_M1M2_PR
* cell instance $6132 r0 *1 79.35,109.99
X$6132 \$1649 VIA_M1M2_PR
* cell instance $6133 r0 *1 33.35,110.33
X$6133 \$1649 VIA_M1M2_PR
* cell instance $6134 r0 *1 33.35,104.89
X$6134 \$1649 VIA_M1M2_PR
* cell instance $6135 r0 *1 33.35,99.45
X$6135 \$1649 VIA_M1M2_PR
* cell instance $6136 r0 *1 81.19,94.01
X$6136 \$1649 VIA_M1M2_PR
* cell instance $6137 r0 *1 42.55,104.89
X$6137 \$1649 VIA_L1M1_PR_MR
* cell instance $6138 r0 *1 29.21,99.45
X$6138 \$1649 VIA_L1M1_PR_MR
* cell instance $6139 r0 *1 29.21,110.33
X$6139 \$1649 VIA_L1M1_PR_MR
* cell instance $6140 r0 *1 81.19,94.01
X$6140 \$1649 VIA_L1M1_PR_MR
* cell instance $6141 r0 *1 71.07,107.95
X$6141 \$1649 VIA_L1M1_PR_MR
* cell instance $6142 r0 *1 82.11,99.45
X$6142 \$1649 VIA_L1M1_PR_MR
* cell instance $6143 r0 *1 79.35,109.99
X$6143 \$1649 VIA_L1M1_PR_MR
* cell instance $6144 r0 *1 77.51,107.61
X$6144 \$1649 VIA_L1M1_PR_MR
* cell instance $6145 r0 *1 84.87,107.95
X$6145 \$1650 VIA_M1M2_PR
* cell instance $6146 r0 *1 84.87,109.31
X$6146 \$1650 VIA_M1M2_PR
* cell instance $6147 r0 *1 81.65,99.11
X$6147 \$1650 VIA_M1M2_PR
* cell instance $6148 r0 *1 81.65,101.49
X$6148 \$1650 VIA_M1M2_PR
* cell instance $6149 r0 *1 84.87,101.49
X$6149 \$1650 VIA_M1M2_PR
* cell instance $6150 r0 *1 83.95,107.61
X$6150 \$1650 VIA_L1M1_PR_MR
* cell instance $6151 r0 *1 83.03,102.17
X$6151 \$1650 VIA_L1M1_PR_MR
* cell instance $6152 r0 *1 78.43,109.65
X$6152 \$1650 VIA_L1M1_PR_MR
* cell instance $6153 r0 *1 81.65,99.11
X$6153 \$1650 VIA_L1M1_PR_MR
* cell instance $6154 r0 *1 89.01,100.13
X$6154 \$1652 VIA_M1M2_PR
* cell instance $6155 r0 *1 89.01,102.17
X$6155 \$1652 VIA_M1M2_PR
* cell instance $6156 r0 *1 83.95,106.93
X$6156 \$1652 VIA_M1M2_PR
* cell instance $6157 r0 *1 83.95,101.83
X$6157 \$1652 VIA_M1M2_PR
* cell instance $6158 r0 *1 83.485,107.56
X$6158 \$1652 VIA_L1M1_PR_MR
* cell instance $6159 r0 *1 90.85,100.13
X$6159 \$1652 VIA_L1M1_PR_MR
* cell instance $6160 r0 *1 89.01,102.17
X$6160 \$1652 VIA_L1M1_PR_MR
* cell instance $6161 r0 *1 83.95,101.83
X$6161 \$1652 VIA_L1M1_PR_MR
* cell instance $6162 r0 *1 143.06,101.66
X$6162 \$1660 VIA_M3M4_PR
* cell instance $6163 r0 *1 143.06,208.42
X$6163 \$1660 VIA_M3M4_PR
* cell instance $6164 r0 *1 174.57,208.42
X$6164 \$1660 VIA_M2M3_PR
* cell instance $6165 r0 *1 170.43,101.66
X$6165 \$1660 VIA_M2M3_PR
* cell instance $6166 r0 *1 170.43,100.13
X$6166 \$1660 VIA_M1M2_PR
* cell instance $6167 r0 *1 174.57,210.97
X$6167 \$1660 VIA_M1M2_PR
* cell instance $6168 r0 *1 174.57,210.97
X$6168 \$1660 VIA_L1M1_PR_MR
* cell instance $6169 r0 *1 170.43,100.13
X$6169 \$1660 VIA_L1M1_PR_MR
* cell instance $6170 r0 *1 171.81,101.83
X$6170 \$1663 VIA_M1M2_PR
* cell instance $6171 r0 *1 168.13,99.11
X$6171 \$1663 VIA_M1M2_PR
* cell instance $6172 r0 *1 168.13,97.07
X$6172 \$1663 VIA_M1M2_PR
* cell instance $6173 r0 *1 171.81,99.45
X$6173 \$1663 VIA_M1M2_PR
* cell instance $6174 r0 *1 168.13,97.07
X$6174 \$1663 VIA_L1M1_PR_MR
* cell instance $6175 r0 *1 174.11,99.45
X$6175 \$1663 VIA_L1M1_PR_MR
* cell instance $6176 r0 *1 173.19,102.17
X$6176 \$1663 VIA_L1M1_PR_MR
* cell instance $6177 r0 *1 168.59,99.11
X$6177 \$1663 VIA_L1M1_PR_MR
* cell instance $6178 r0 *1 141.91,98.77
X$6178 \$1682 VIA_M1M2_PR
* cell instance $6179 r0 *1 141.91,207.23
X$6179 \$1682 VIA_M1M2_PR
* cell instance $6180 r0 *1 169.05,207.91
X$6180 \$1682 VIA_L1M1_PR_MR
* cell instance $6181 r0 *1 171.81,98.77
X$6181 \$1682 VIA_L1M1_PR_MR
* cell instance $6182 r0 *1 78.89,99.45
X$6182 \$1695 VIA_M1M2_PR
* cell instance $6183 r0 *1 78.89,101.15
X$6183 \$1695 VIA_M1M2_PR
* cell instance $6184 r0 *1 78.89,99.45
X$6184 \$1695 VIA_L1M1_PR_MR
* cell instance $6185 r0 *1 77.05,101.15
X$6185 \$1695 VIA_L1M1_PR_MR
* cell instance $6186 r0 *1 78.89,103.87
X$6186 \$1699 VIA_M1M2_PR
* cell instance $6187 r0 *1 79.35,101.83
X$6187 \$1699 VIA_M1M2_PR
* cell instance $6188 r0 *1 78.89,104.55
X$6188 \$1699 VIA_M1M2_PR
* cell instance $6189 r0 *1 76.59,103.87
X$6189 \$1699 VIA_L1M1_PR_MR
* cell instance $6190 r0 *1 79.81,101.83
X$6190 \$1699 VIA_L1M1_PR_MR
* cell instance $6191 r0 *1 78.89,104.55
X$6191 \$1699 VIA_L1M1_PR_MR
* cell instance $6192 r0 *1 82.11,97.07
X$6192 \$1702 VIA_M1M2_PR
* cell instance $6193 r0 *1 82.11,101.15
X$6193 \$1702 VIA_M1M2_PR
* cell instance $6194 r0 *1 82.11,97.07
X$6194 \$1702 VIA_L1M1_PR_MR
* cell instance $6195 r0 *1 81.19,101.15
X$6195 \$1702 VIA_L1M1_PR_MR
* cell instance $6196 r0 *1 83.03,108.29
X$6196 \$1705 VIA_M1M2_PR
* cell instance $6197 r0 *1 83.95,162.35
X$6197 \$1705 VIA_M1M2_PR
* cell instance $6198 r0 *1 83.49,102.17
X$6198 \$1705 VIA_M1M2_PR
* cell instance $6199 r0 *1 85.33,162.35
X$6199 \$1705 VIA_L1M1_PR_MR
* cell instance $6200 r0 *1 81.19,108.29
X$6200 \$1705 VIA_L1M1_PR_MR
* cell instance $6201 r0 *1 85.33,102.17
X$6201 \$1705 VIA_L1M1_PR_MR
* cell instance $6202 r0 *1 116.61,98.77
X$6202 \$1709 VIA_L1M1_PR_MR
* cell instance $6203 r0 *1 112.47,98.77
X$6203 \$1709 VIA_L1M1_PR_MR
* cell instance $6204 r0 *1 81.65,104.89
X$6204 \$1728 VIA_M1M2_PR
* cell instance $6205 r0 *1 81.65,106.59
X$6205 \$1728 VIA_M1M2_PR
* cell instance $6206 r0 *1 78.43,104.55
X$6206 \$1728 VIA_L1M1_PR_MR
* cell instance $6207 r0 *1 82.11,106.93
X$6207 \$1728 VIA_L1M1_PR_MR
* cell instance $6208 r0 *1 82.57,113.05
X$6208 \$1729 VIA_M1M2_PR
* cell instance $6209 r0 *1 82.57,110.33
X$6209 \$1729 VIA_M1M2_PR
* cell instance $6210 r0 *1 78.89,110.33
X$6210 \$1729 VIA_M1M2_PR
* cell instance $6211 r0 *1 79.35,104.55
X$6211 \$1729 VIA_M1M2_PR
* cell instance $6212 r0 *1 82.11,113.05
X$6212 \$1729 VIA_L1M1_PR_MR
* cell instance $6213 r0 *1 88.09,110.33
X$6213 \$1729 VIA_L1M1_PR_MR
* cell instance $6214 r0 *1 77.97,109.99
X$6214 \$1729 VIA_L1M1_PR_MR
* cell instance $6215 r0 *1 79.375,104.55
X$6215 \$1729 VIA_L1M1_PR_MR
* cell instance $6216 r0 *1 70.61,151.13
X$6216 \$1733 VIA_M1M2_PR
* cell instance $6217 r0 *1 70.61,104.21
X$6217 \$1733 VIA_M1M2_PR
* cell instance $6218 r0 *1 70.61,151.13
X$6218 \$1733 VIA_L1M1_PR_MR
* cell instance $6219 r0 *1 81.65,103.87
X$6219 \$1733 VIA_L1M1_PR_MR
* cell instance $6220 r0 *1 115.23,106.93
X$6220 \$1740 VIA_M1M2_PR
* cell instance $6221 r0 *1 115.23,102.85
X$6221 \$1740 VIA_M1M2_PR
* cell instance $6222 r0 *1 115.23,104.55
X$6222 \$1740 VIA_M1M2_PR
* cell instance $6223 r0 *1 117.53,107.61
X$6223 \$1740 VIA_L1M1_PR_MR
* cell instance $6224 r0 *1 117.07,102.85
X$6224 \$1740 VIA_L1M1_PR_MR
* cell instance $6225 r0 *1 115.69,104.55
X$6225 \$1740 VIA_L1M1_PR_MR
* cell instance $6226 r0 *1 118.91,103.87
X$6226 \$1742 VIA_M1M2_PR
* cell instance $6227 r0 *1 119.37,112.71
X$6227 \$1742 VIA_M1M2_PR
* cell instance $6228 r0 *1 119.37,110.33
X$6228 \$1742 VIA_M1M2_PR
* cell instance $6229 r0 *1 118.45,107.95
X$6229 \$1742 VIA_M1M2_PR
* cell instance $6230 r0 *1 117.07,107.61
X$6230 \$1742 VIA_L1M1_PR_MR
* cell instance $6231 r0 *1 113.85,104.21
X$6231 \$1742 VIA_L1M1_PR_MR
* cell instance $6232 r0 *1 115.69,110.33
X$6232 \$1742 VIA_L1M1_PR_MR
* cell instance $6233 r0 *1 118.91,112.71
X$6233 \$1742 VIA_L1M1_PR_MR
* cell instance $6234 r0 *1 122.13,113.05
X$6234 \$1743 VIA_M1M2_PR
* cell instance $6235 r0 *1 118.45,106.59
X$6235 \$1743 VIA_M1M2_PR
* cell instance $6236 r0 *1 118.45,105.57
X$6236 \$1743 VIA_M1M2_PR
* cell instance $6237 r0 *1 122.59,106.59
X$6237 \$1743 VIA_M1M2_PR
* cell instance $6238 r0 *1 122.13,113.05
X$6238 \$1743 VIA_L1M1_PR_MR
* cell instance $6239 r0 *1 117.53,105.23
X$6239 \$1743 VIA_L1M1_PR_MR
* cell instance $6240 r0 *1 117.53,106.59
X$6240 \$1743 VIA_L1M1_PR_MR
* cell instance $6241 r0 *1 30.13,107.61
X$6241 \$1754 VIA_M1M2_PR
* cell instance $6242 r0 *1 30.13,104.55
X$6242 \$1754 VIA_M1M2_PR
* cell instance $6243 r0 *1 28.75,102.85
X$6243 \$1754 VIA_M1M2_PR
* cell instance $6244 r0 *1 28.75,104.55
X$6244 \$1754 VIA_M1M2_PR
* cell instance $6245 r0 *1 29.21,102.85
X$6245 \$1754 VIA_L1M1_PR_MR
* cell instance $6246 r0 *1 33.81,107.61
X$6246 \$1754 VIA_L1M1_PR_MR
* cell instance $6247 r0 *1 29.67,107.61
X$6247 \$1754 VIA_L1M1_PR_MR
* cell instance $6248 r0 *1 31.05,107.61
X$6248 \$1754 VIA_L1M1_PR_MR
* cell instance $6249 r0 *1 135.93,102.85
X$6249 \$1757 VIA_M1M2_PR
* cell instance $6250 r0 *1 173.65,211.65
X$6250 \$1757 VIA_M1M2_PR
* cell instance $6251 r0 *1 173.65,213.35
X$6251 \$1757 VIA_M1M2_PR
* cell instance $6252 r0 *1 135.93,211.31
X$6252 \$1757 VIA_M1M2_PR
* cell instance $6253 r0 *1 173.65,213.35
X$6253 \$1757 VIA_L1M1_PR_MR
* cell instance $6254 r0 *1 172.73,102.85
X$6254 \$1757 VIA_L1M1_PR_MR
* cell instance $6255 r0 *1 124.89,104.21
X$6255 \$1764 VIA_M1M2_PR
* cell instance $6256 r0 *1 124.89,96.39
X$6256 \$1764 VIA_M1M2_PR
* cell instance $6257 r0 *1 121.67,104.21
X$6257 \$1764 VIA_L1M1_PR_MR
* cell instance $6258 r0 *1 124.89,96.39
X$6258 \$1764 VIA_L1M1_PR_MR
* cell instance $6259 r0 *1 41.17,102.51
X$6259 \$1765 VIA_M1M2_PR
* cell instance $6260 r0 *1 41.17,104.21
X$6260 \$1765 VIA_M1M2_PR
* cell instance $6261 r0 *1 39.79,102.51
X$6261 \$1765 VIA_L1M1_PR_MR
* cell instance $6262 r0 *1 41.17,104.21
X$6262 \$1765 VIA_L1M1_PR_MR
* cell instance $6263 r0 *1 123.05,109.65
X$6263 \$1768 VIA_M1M2_PR
* cell instance $6264 r0 *1 123.05,105.57
X$6264 \$1768 VIA_M1M2_PR
* cell instance $6265 r0 *1 123.05,109.65
X$6265 \$1768 VIA_L1M1_PR_MR
* cell instance $6266 r0 *1 119.37,105.57
X$6266 \$1768 VIA_L1M1_PR_MR
* cell instance $6267 r0 *1 80.73,99.11
X$6267 \$1773 VIA_M1M2_PR
* cell instance $6268 r0 *1 80.73,102.51
X$6268 \$1773 VIA_M1M2_PR
* cell instance $6269 r0 *1 88.55,102.51
X$6269 \$1773 VIA_L1M1_PR_MR
* cell instance $6270 r0 *1 80.73,99.11
X$6270 \$1773 VIA_L1M1_PR_MR
* cell instance $6271 r0 *1 79.35,102.51
X$6271 \$1773 VIA_L1M1_PR_MR
* cell instance $6272 r0 *1 80.73,109.65
X$6272 \$1774 VIA_M1M2_PR
* cell instance $6273 r0 *1 80.73,105.57
X$6273 \$1774 VIA_M1M2_PR
* cell instance $6274 r0 *1 80.73,109.65
X$6274 \$1774 VIA_L1M1_PR_MR
* cell instance $6275 r0 *1 80.27,105.57
X$6275 \$1774 VIA_L1M1_PR_MR
* cell instance $6276 r0 *1 118.45,104.89
X$6276 \$1775 VIA_L1M1_PR_MR
* cell instance $6277 r0 *1 116.61,104.89
X$6277 \$1775 VIA_L1M1_PR_MR
* cell instance $6278 r0 *1 117.99,106.93
X$6278 \$1782 VIA_M1M2_PR
* cell instance $6279 r0 *1 117.99,112.37
X$6279 \$1782 VIA_M1M2_PR
* cell instance $6280 r0 *1 117.99,104.55
X$6280 \$1782 VIA_M1M2_PR
* cell instance $6281 r0 *1 117.53,112.37
X$6281 \$1782 VIA_L1M1_PR_MR
* cell instance $6282 r0 *1 119.83,113.05
X$6282 \$1782 VIA_L1M1_PR_MR
* cell instance $6283 r0 *1 117.11,104.55
X$6283 \$1782 VIA_L1M1_PR_MR
* cell instance $6284 r0 *1 118.91,106.93
X$6284 \$1782 VIA_L1M1_PR_MR
* cell instance $6285 r0 *1 84.41,112.37
X$6285 \$1783 VIA_M1M2_PR
* cell instance $6286 r0 *1 84.41,107.61
X$6286 \$1783 VIA_M1M2_PR
* cell instance $6287 r0 *1 84.41,102.85
X$6287 \$1783 VIA_M1M2_PR
* cell instance $6288 r0 *1 83.03,112.37
X$6288 \$1783 VIA_L1M1_PR_MR
* cell instance $6289 r0 *1 84.41,107.61
X$6289 \$1783 VIA_L1M1_PR_MR
* cell instance $6290 r0 *1 83.49,102.85
X$6290 \$1783 VIA_L1M1_PR_MR
* cell instance $6291 r0 *1 92.69,102.85
X$6291 \$1787 VIA_M1M2_PR
* cell instance $6292 r0 *1 92.69,162.35
X$6292 \$1787 VIA_M1M2_PR
* cell instance $6293 r0 *1 85.79,162.35
X$6293 \$1787 VIA_L1M1_PR_MR
* cell instance $6294 r0 *1 86.25,102.85
X$6294 \$1787 VIA_L1M1_PR_MR
* cell instance $6295 r0 *1 31.51,109.31
X$6295 \$1791 VIA_M1M2_PR
* cell instance $6296 r0 *1 31.51,104.21
X$6296 \$1791 VIA_M1M2_PR
* cell instance $6297 r0 *1 31.51,104.21
X$6297 \$1791 VIA_L1M1_PR_MR
* cell instance $6298 r0 *1 30.59,109.65
X$6298 \$1791 VIA_L1M1_PR_MR
* cell instance $6299 r0 *1 130.41,109.31
X$6299 \$1822 VIA_M1M2_PR
* cell instance $6300 r0 *1 130.41,207.57
X$6300 \$1822 VIA_M1M2_PR
* cell instance $6301 r0 *1 166.75,207.91
X$6301 \$1822 VIA_L1M1_PR_MR
* cell instance $6302 r0 *1 172.73,109.99
X$6302 \$1822 VIA_L1M1_PR_MR
* cell instance $6303 r0 *1 170.89,109.65
X$6303 \$1823 VIA_M1M2_PR
* cell instance $6304 r0 *1 170.89,107.95
X$6304 \$1823 VIA_M1M2_PR
* cell instance $6305 r0 *1 174.57,107.95
X$6305 \$1823 VIA_L1M1_PR_MR
* cell instance $6306 r0 *1 171.35,107.95
X$6306 \$1823 VIA_L1M1_PR_MR
* cell instance $6307 r0 *1 170.89,109.65
X$6307 \$1823 VIA_L1M1_PR_MR
* cell instance $6308 r0 *1 189.29,208.25
X$6308 \$1826 VIA_M1M2_PR
* cell instance $6309 r0 *1 182.85,159.63
X$6309 \$1826 VIA_M1M2_PR
* cell instance $6310 r0 *1 189.29,159.63
X$6310 \$1826 VIA_M1M2_PR
* cell instance $6311 r0 *1 182.85,107.27
X$6311 \$1826 VIA_M1M2_PR
* cell instance $6312 r0 *1 173.65,107.27
X$6312 \$1826 VIA_L1M1_PR_MR
* cell instance $6313 r0 *1 180.09,208.25
X$6313 \$1826 VIA_L1M1_PR_MR
* cell instance $6314 r0 *1 173.19,107.61
X$6314 \$1832 VIA_M1M2_PR
* cell instance $6315 r0 *1 173.19,113.73
X$6315 \$1832 VIA_M1M2_PR
* cell instance $6316 r0 *1 177.79,118.49
X$6316 \$1832 VIA_M1M2_PR
* cell instance $6317 r0 *1 178.25,115.43
X$6317 \$1832 VIA_M1M2_PR
* cell instance $6318 r0 *1 178.25,113.39
X$6318 \$1832 VIA_M1M2_PR
* cell instance $6319 r0 *1 177.79,118.49
X$6319 \$1832 VIA_L1M1_PR_MR
* cell instance $6320 r0 *1 178.25,115.43
X$6320 \$1832 VIA_L1M1_PR_MR
* cell instance $6321 r0 *1 175.03,113.05
X$6321 \$1832 VIA_L1M1_PR_MR
* cell instance $6322 r0 *1 171.81,113.73
X$6322 \$1832 VIA_L1M1_PR_MR
* cell instance $6323 r0 *1 172.73,107.61
X$6323 \$1832 VIA_L1M1_PR_MR
* cell instance $6324 r0 *1 31.97,107.27
X$6324 \$1835 VIA_M1M2_PR
* cell instance $6325 r0 *1 31.97,96.73
X$6325 \$1835 VIA_M1M2_PR
* cell instance $6326 r0 *1 31.97,96.73
X$6326 \$1835 VIA_L1M1_PR_MR
* cell instance $6327 r0 *1 31.97,107.27
X$6327 \$1835 VIA_L1M1_PR_MR
* cell instance $6328 r0 *1 36.57,102.17
X$6328 \$1839 VIA_M1M2_PR
* cell instance $6329 r0 *1 36.57,106.59
X$6329 \$1839 VIA_M1M2_PR
* cell instance $6330 r0 *1 34.27,106.59
X$6330 \$1839 VIA_L1M1_PR_MR
* cell instance $6331 r0 *1 36.57,102.17
X$6331 \$1839 VIA_L1M1_PR_MR
* cell instance $6332 r0 *1 167.67,112.71
X$6332 \$1842 VIA_M1M2_PR
* cell instance $6333 r0 *1 167.67,109.99
X$6333 \$1842 VIA_M1M2_PR
* cell instance $6334 r0 *1 167.67,112.71
X$6334 \$1842 VIA_L1M1_PR_MR
* cell instance $6335 r0 *1 169.05,109.99
X$6335 \$1842 VIA_L1M1_PR_MR
* cell instance $6336 r0 *1 114.31,116.45
X$6336 \$1875 VIA_M1M2_PR
* cell instance $6337 r0 *1 114.31,115.77
X$6337 \$1875 VIA_M1M2_PR
* cell instance $6338 r0 *1 88.55,139.91
X$6338 \$1875 VIA_M1M2_PR
* cell instance $6339 r0 *1 88.55,113.39
X$6339 \$1875 VIA_M1M2_PR
* cell instance $6340 r0 *1 88.55,116.45
X$6340 \$1875 VIA_M1M2_PR
* cell instance $6341 r0 *1 88.55,110.67
X$6341 \$1875 VIA_M1M2_PR
* cell instance $6342 r0 *1 88.55,136.51
X$6342 \$1875 VIA_M1M2_PR
* cell instance $6343 r0 *1 88.55,134.47
X$6343 \$1875 VIA_M1M2_PR
* cell instance $6344 r0 *1 86.25,139.91
X$6344 \$1875 VIA_M1M2_PR
* cell instance $6345 r0 *1 86.25,142.97
X$6345 \$1875 VIA_M1M2_PR
* cell instance $6346 r0 *1 114.31,123.59
X$6346 \$1875 VIA_M1M2_PR
* cell instance $6347 r0 *1 83.03,142.97
X$6347 \$1875 VIA_L1M1_PR_MR
* cell instance $6348 r0 *1 86.25,139.91
X$6348 \$1875 VIA_L1M1_PR_MR
* cell instance $6349 r0 *1 91.31,137.19
X$6349 \$1875 VIA_L1M1_PR_MR
* cell instance $6350 r0 *1 87.17,134.47
X$6350 \$1875 VIA_L1M1_PR_MR
* cell instance $6351 r0 *1 116.15,115.77
X$6351 \$1875 VIA_L1M1_PR_MR
* cell instance $6352 r0 *1 85.33,113.39
X$6352 \$1875 VIA_L1M1_PR_MR
* cell instance $6353 r0 *1 89.47,110.33
X$6353 \$1875 VIA_L1M1_PR_MR
* cell instance $6354 r0 *1 114.31,123.59
X$6354 \$1875 VIA_L1M1_PR_MR
* cell instance $6355 r0 *1 114.77,116.45
X$6355 \$1878 VIA_L1M1_PR_MR
* cell instance $6356 r0 *1 117.53,115.77
X$6356 \$1878 VIA_L1M1_PR_MR
* cell instance $6357 r0 *1 122.13,114.75
X$6357 \$1879 VIA_M1M2_PR
* cell instance $6358 r0 *1 122.13,121.55
X$6358 \$1879 VIA_M1M2_PR
* cell instance $6359 r0 *1 122.13,118.49
X$6359 \$1879 VIA_M1M2_PR
* cell instance $6360 r0 *1 115.23,115.43
X$6360 \$1879 VIA_L1M1_PR_MR
* cell instance $6361 r0 *1 124.89,114.75
X$6361 \$1879 VIA_L1M1_PR_MR
* cell instance $6362 r0 *1 122.13,118.49
X$6362 \$1879 VIA_L1M1_PR_MR
* cell instance $6363 r0 *1 121.21,121.55
X$6363 \$1879 VIA_L1M1_PR_MR
* cell instance $6364 r0 *1 178.71,113.73
X$6364 \$1901 VIA_M1M2_PR
* cell instance $6365 r0 *1 173.65,113.73
X$6365 \$1901 VIA_M1M2_PR
* cell instance $6366 r0 *1 173.65,109.99
X$6366 \$1901 VIA_M1M2_PR
* cell instance $6367 r0 *1 178.71,115.43
X$6367 \$1901 VIA_M1M2_PR
* cell instance $6368 r0 *1 178.71,115.43
X$6368 \$1901 VIA_L1M1_PR_MR
* cell instance $6369 r0 *1 173.65,109.99
X$6369 \$1901 VIA_L1M1_PR_MR
* cell instance $6370 r0 *1 177.79,113.73
X$6370 \$1901 VIA_L1M1_PR_MR
* cell instance $6371 r0 *1 174.11,115.43
X$6371 \$1910 VIA_M1M2_PR
* cell instance $6372 r0 *1 174.11,109.99
X$6372 \$1910 VIA_M1M2_PR
* cell instance $6373 r0 *1 178.25,118.49
X$6373 \$1910 VIA_M1M2_PR
* cell instance $6374 r0 *1 178.25,116.45
X$6374 \$1910 VIA_M1M2_PR
* cell instance $6375 r0 *1 178.25,118.49
X$6375 \$1910 VIA_L1M1_PR_MR
* cell instance $6376 r0 *1 177.33,115.43
X$6376 \$1910 VIA_L1M1_PR_MR
* cell instance $6377 r0 *1 178.25,116.45
X$6377 \$1910 VIA_L1M1_PR_MR
* cell instance $6378 r0 *1 176.87,116.45
X$6378 \$1910 VIA_L1M1_PR_MR
* cell instance $6379 r0 *1 174.11,109.99
X$6379 \$1910 VIA_L1M1_PR_MR
* cell instance $6380 r0 *1 191.13,216.41
X$6380 \$1914 VIA_M1M2_PR
* cell instance $6381 r0 *1 191.13,171.87
X$6381 \$1914 VIA_M1M2_PR
* cell instance $6382 r0 *1 181.47,171.87
X$6382 \$1914 VIA_M1M2_PR
* cell instance $6383 r0 *1 181.47,116.45
X$6383 \$1914 VIA_M1M2_PR
* cell instance $6384 r0 *1 180.09,116.45
X$6384 \$1914 VIA_L1M1_PR_MR
* cell instance $6385 r0 *1 181.01,216.41
X$6385 \$1914 VIA_L1M1_PR_MR
* cell instance $6386 r0 *1 128.57,115.43
X$6386 \$1933 VIA_M1M2_PR
* cell instance $6387 r0 *1 177.33,210.63
X$6387 \$1933 VIA_M1M2_PR
* cell instance $6388 r0 *1 177.33,213.01
X$6388 \$1933 VIA_M1M2_PR
* cell instance $6389 r0 *1 128.57,210.63
X$6389 \$1933 VIA_M1M2_PR
* cell instance $6390 r0 *1 172.27,115.43
X$6390 \$1933 VIA_L1M1_PR_MR
* cell instance $6391 r0 *1 181.47,213.35
X$6391 \$1933 VIA_L1M1_PR_MR
* cell instance $6392 r0 *1 128.11,110.33
X$6392 \$1935 VIA_M1M2_PR
* cell instance $6393 r0 *1 128.11,210.29
X$6393 \$1935 VIA_M1M2_PR
* cell instance $6394 r0 *1 171.81,110.33
X$6394 \$1935 VIA_L1M1_PR_MR
* cell instance $6395 r0 *1 180.09,210.63
X$6395 \$1935 VIA_L1M1_PR_MR
* cell instance $6396 r0 *1 126.27,112.03
X$6396 \$1937 VIA_M1M2_PR
* cell instance $6397 r0 *1 126.27,107.95
X$6397 \$1937 VIA_M1M2_PR
* cell instance $6398 r0 *1 121.67,112.03
X$6398 \$1937 VIA_L1M1_PR_MR
* cell instance $6399 r0 *1 126.27,107.95
X$6399 \$1937 VIA_L1M1_PR_MR
* cell instance $6400 r0 *1 113.85,115.77
X$6400 \$1958 VIA_M1M2_PR
* cell instance $6401 r0 *1 113.85,117.81
X$6401 \$1958 VIA_M1M2_PR
* cell instance $6402 r0 *1 113.85,120.53
X$6402 \$1958 VIA_M1M2_PR
* cell instance $6403 r0 *1 121.67,117.81
X$6403 \$1958 VIA_L1M1_PR_MR
* cell instance $6404 r0 *1 113.85,115.77
X$6404 \$1958 VIA_L1M1_PR_MR
* cell instance $6405 r0 *1 115.69,120.87
X$6405 \$1958 VIA_L1M1_PR_MR
* cell instance $6406 r0 *1 116.15,120.53
X$6406 \$1960 VIA_M1M2_PR
* cell instance $6407 r0 *1 122.59,121.21
X$6407 \$1960 VIA_M1M2_PR
* cell instance $6408 r0 *1 116.15,118.83
X$6408 \$1960 VIA_M1M2_PR
* cell instance $6409 r0 *1 122.59,122.91
X$6409 \$1960 VIA_M1M2_PR
* cell instance $6410 r0 *1 123.05,122.91
X$6410 \$1960 VIA_L1M1_PR_MR
* cell instance $6411 r0 *1 122.59,121.21
X$6411 \$1960 VIA_L1M1_PR_MR
* cell instance $6412 r0 *1 118.45,120.87
X$6412 \$1960 VIA_L1M1_PR_MR
* cell instance $6413 r0 *1 116.15,118.83
X$6413 \$1960 VIA_L1M1_PR_MR
* cell instance $6414 r0 *1 118.91,120.87
X$6414 \$1961 VIA_M1M2_PR
* cell instance $6415 r0 *1 118.91,118.83
X$6415 \$1961 VIA_M1M2_PR
* cell instance $6416 r0 *1 118.91,125.97
X$6416 \$1961 VIA_M1M2_PR
* cell instance $6417 r0 *1 118.91,125.97
X$6417 \$1961 VIA_L1M1_PR_MR
* cell instance $6418 r0 *1 118.91,120.87
X$6418 \$1961 VIA_L1M1_PR_MR
* cell instance $6419 r0 *1 117.99,118.83
X$6419 \$1961 VIA_L1M1_PR_MR
* cell instance $6420 r0 *1 135.01,123.42
X$6420 O[3] VIA_M2M3_PR
* cell instance $6421 r0 *1 135.01,253.81
X$6421 O[3] VIA_M1M2_PR
* cell instance $6422 r0 *1 178.71,253.81
X$6422 O[3] VIA_L1M1_PR_MR
* cell instance $6423 r0 *1 166.06,155.38
X$6423 \$1976 VIA_M3M4_PR
* cell instance $6424 r0 *1 166.06,209.1
X$6424 \$1976 VIA_M3M4_PR
* cell instance $6425 r0 *1 163.07,209.1
X$6425 \$1976 VIA_M2M3_PR
* cell instance $6426 r0 *1 169.97,155.38
X$6426 \$1976 VIA_M2M3_PR
* cell instance $6427 r0 *1 163.07,210.97
X$6427 \$1976 VIA_M1M2_PR
* cell instance $6428 r0 *1 169.97,119.17
X$6428 \$1976 VIA_M1M2_PR
* cell instance $6429 r0 *1 163.53,210.97
X$6429 \$1976 VIA_L1M1_PR_MR
* cell instance $6430 r0 *1 170.89,119.17
X$6430 \$1976 VIA_L1M1_PR_MR
* cell instance $6431 r0 *1 172.27,118.83
X$6431 \$1976 VIA_L1M1_PR_MR
* cell instance $6432 r0 *1 176.41,118.49
X$6432 \$1976 VIA_L1M1_PR_MR
* cell instance $6433 r0 *1 129.03,117.47
X$6433 \$1984 VIA_M1M2_PR
* cell instance $6434 r0 *1 129.03,216.07
X$6434 \$1984 VIA_M1M2_PR
* cell instance $6435 r0 *1 165.83,216.07
X$6435 \$1984 VIA_L1M1_PR_MR
* cell instance $6436 r0 *1 175.49,117.47
X$6436 \$1984 VIA_L1M1_PR_MR
* cell instance $6437 r0 *1 118.45,123.59
X$6437 \$2002 VIA_M1M2_PR
* cell instance $6438 r0 *1 118.45,119.17
X$6438 \$2002 VIA_M1M2_PR
* cell instance $6439 r0 *1 119.83,119.17
X$6439 \$2002 VIA_L1M1_PR_MR
* cell instance $6440 r0 *1 115.69,123.59
X$6440 \$2002 VIA_L1M1_PR_MR
* cell instance $6441 r0 *1 120.75,118.15
X$6441 \$2005 VIA_L1M1_PR_MR
* cell instance $6442 r0 *1 118.91,118.15
X$6442 \$2005 VIA_L1M1_PR_MR
* cell instance $6443 r0 *1 17.25,132.26
X$6443 enable VIA_M2M3_PR
* cell instance $6444 r0 *1 31.05,198.05
X$6444 enable VIA_M1M2_PR
* cell instance $6445 r0 *1 31.05,199.41
X$6445 enable VIA_M1M2_PR
* cell instance $6446 r0 *1 17.25,196.35
X$6446 enable VIA_M1M2_PR
* cell instance $6447 r0 *1 30.13,196.35
X$6447 enable VIA_L1M1_PR_MR
* cell instance $6448 r0 *1 31.05,199.41
X$6448 enable VIA_L1M1_PR_MR
* cell instance $6449 r0 *1 30.59,198.05
X$6449 enable VIA_L1M1_PR_MR
* cell instance $6450 r0 *1 112.47,139.91
X$6450 \$2017 VIA_M1M2_PR
* cell instance $6451 r0 *1 112.47,135.15
X$6451 \$2017 VIA_M1M2_PR
* cell instance $6452 r0 *1 112.47,131.07
X$6452 \$2017 VIA_M1M2_PR
* cell instance $6453 r0 *1 112.93,139.91
X$6453 \$2017 VIA_L1M1_PR_MR
* cell instance $6454 r0 *1 109.71,131.41
X$6454 \$2017 VIA_L1M1_PR_MR
* cell instance $6455 r0 *1 115.69,139.91
X$6455 \$2017 VIA_L1M1_PR_MR
* cell instance $6456 r0 *1 114.77,134.81
X$6456 \$2017 VIA_L1M1_PR_MR
* cell instance $6457 r0 *1 112.01,133.79
X$6457 \$2018 VIA_M1M2_PR
* cell instance $6458 r0 *1 112.01,129.37
X$6458 \$2018 VIA_M1M2_PR
* cell instance $6459 r0 *1 112.01,129.37
X$6459 \$2018 VIA_L1M1_PR_MR
* cell instance $6460 r0 *1 112.01,133.79
X$6460 \$2018 VIA_L1M1_PR_MR
* cell instance $6461 r0 *1 114.31,129.71
X$6461 \$2018 VIA_L1M1_PR_MR
* cell instance $6462 r0 *1 114.77,131.75
X$6462 \$2019 VIA_M1M2_PR
* cell instance $6463 r0 *1 114.77,134.13
X$6463 \$2019 VIA_M1M2_PR
* cell instance $6464 r0 *1 111.55,131.75
X$6464 \$2019 VIA_L1M1_PR_MR
* cell instance $6465 r0 *1 117.07,131.41
X$6465 \$2019 VIA_L1M1_PR_MR
* cell instance $6466 r0 *1 114.31,134.81
X$6466 \$2019 VIA_L1M1_PR_MR
* cell instance $6467 r0 *1 113.85,131.75
X$6467 \$2020 VIA_M1M2_PR
* cell instance $6468 r0 *1 113.85,137.19
X$6468 \$2020 VIA_M1M2_PR
* cell instance $6469 r0 *1 113.85,129.37
X$6469 \$2020 VIA_M1M2_PR
* cell instance $6470 r0 *1 114.77,137.53
X$6470 \$2020 VIA_L1M1_PR_MR
* cell instance $6471 r0 *1 113.39,131.75
X$6471 \$2020 VIA_L1M1_PR_MR
* cell instance $6472 r0 *1 114.77,129.37
X$6472 \$2020 VIA_L1M1_PR_MR
* cell instance $6473 r0 *1 113.85,137.19
X$6473 \$2020 VIA_L1M1_PR_MR
* cell instance $6474 r0 *1 114.31,135.49
X$6474 \$2021 VIA_M1M2_PR
* cell instance $6475 r0 *1 114.31,131.75
X$6475 \$2021 VIA_M1M2_PR
* cell instance $6476 r0 *1 114.31,129.03
X$6476 \$2021 VIA_M1M2_PR
* cell instance $6477 r0 *1 112.93,129.03
X$6477 \$2021 VIA_L1M1_PR_MR
* cell instance $6478 r0 *1 111.55,134.81
X$6478 \$2021 VIA_L1M1_PR_MR
* cell instance $6479 r0 *1 114.31,131.75
X$6479 \$2021 VIA_L1M1_PR_MR
* cell instance $6480 r0 *1 115.69,128.69
X$6480 \$2021 VIA_L1M1_PR_MR
* cell instance $6481 r0 *1 172.27,131.07
X$6481 \$2029 VIA_M1M2_PR
* cell instance $6482 r0 *1 167.21,131.07
X$6482 \$2029 VIA_M1M2_PR
* cell instance $6483 r0 *1 172.27,130.05
X$6483 \$2029 VIA_M1M2_PR
* cell instance $6484 r0 *1 172.27,132.43
X$6484 \$2029 VIA_M1M2_PR
* cell instance $6485 r0 *1 167.21,131.75
X$6485 \$2029 VIA_M1M2_PR
* cell instance $6486 r0 *1 167.21,133.79
X$6486 \$2029 VIA_M1M2_PR
* cell instance $6487 r0 *1 171.81,130.05
X$6487 \$2029 VIA_L1M1_PR_MR
* cell instance $6488 r0 *1 170.89,129.03
X$6488 \$2029 VIA_L1M1_PR_MR
* cell instance $6489 r0 *1 171.81,128.69
X$6489 \$2029 VIA_L1M1_PR_MR
* cell instance $6490 r0 *1 168.59,133.79
X$6490 \$2029 VIA_L1M1_PR_MR
* cell instance $6491 r0 *1 173.19,132.09
X$6491 \$2029 VIA_L1M1_PR_MR
* cell instance $6492 r0 *1 167.21,131.75
X$6492 \$2029 VIA_L1M1_PR_MR
* cell instance $6493 r0 *1 167.67,132.09
X$6493 \$2033 VIA_L1M1_PR_MR
* cell instance $6494 r0 *1 174.115,131.75
X$6494 \$2033 VIA_L1M1_PR_MR
* cell instance $6495 r0 *1 175.03,131.75
X$6495 \$2037 VIA_M1M2_PR
* cell instance $6496 r0 *1 175.03,133.79
X$6496 \$2037 VIA_M1M2_PR
* cell instance $6497 r0 *1 175.03,129.03
X$6497 \$2037 VIA_M1M2_PR
* cell instance $6498 r0 *1 174.57,133.79
X$6498 \$2037 VIA_L1M1_PR_MR
* cell instance $6499 r0 *1 175.49,128.69
X$6499 \$2037 VIA_L1M1_PR_MR
* cell instance $6500 r0 *1 175.03,131.75
X$6500 \$2037 VIA_L1M1_PR_MR
* cell instance $6501 r0 *1 167.67,224.74
X$6501 \$2038 VIA_M2M3_PR
* cell instance $6502 r0 *1 143.29,224.74
X$6502 \$2038 VIA_M2M3_PR
* cell instance $6503 r0 *1 167.67,224.23
X$6503 \$2038 VIA_M1M2_PR
* cell instance $6504 r0 *1 143.29,129.71
X$6504 \$2038 VIA_M1M2_PR
* cell instance $6505 r0 *1 167.67,224.23
X$6505 \$2038 VIA_L1M1_PR_MR
* cell instance $6506 r0 *1 175.03,130.05
X$6506 \$2038 VIA_L1M1_PR_MR
* cell instance $6507 r0 *1 171.81,129.37
X$6507 \$2043 VIA_M1M2_PR
* cell instance $6508 r0 *1 173.19,140.25
X$6508 \$2043 VIA_M1M2_PR
* cell instance $6509 r0 *1 173.19,137.87
X$6509 \$2043 VIA_M1M2_PR
* cell instance $6510 r0 *1 172.73,131.75
X$6510 \$2043 VIA_M1M2_PR
* cell instance $6511 r0 *1 173.19,135.15
X$6511 \$2043 VIA_M1M2_PR
* cell instance $6512 r0 *1 172.27,131.75
X$6512 \$2043 VIA_L1M1_PR_MR
* cell instance $6513 r0 *1 169.97,129.37
X$6513 \$2043 VIA_L1M1_PR_MR
* cell instance $6514 r0 *1 168.59,137.87
X$6514 \$2043 VIA_L1M1_PR_MR
* cell instance $6515 r0 *1 173.19,140.25
X$6515 \$2043 VIA_L1M1_PR_MR
* cell instance $6516 r0 *1 177.33,134.81
X$6516 \$2043 VIA_L1M1_PR_MR
* cell instance $6517 r0 *1 177.33,129.37
X$6517 \$2043 VIA_L1M1_PR_MR
* cell instance $6518 r0 *1 169.05,129.37
X$6518 \$2048 VIA_M1M2_PR
* cell instance $6519 r0 *1 169.05,136.51
X$6519 \$2048 VIA_M1M2_PR
* cell instance $6520 r0 *1 168.13,129.37
X$6520 \$2048 VIA_L1M1_PR_MR
* cell instance $6521 r0 *1 169.05,136.51
X$6521 \$2048 VIA_L1M1_PR_MR
* cell instance $6522 r0 *1 144.67,230.01
X$6522 \$2049 VIA_M1M2_PR
* cell instance $6523 r0 *1 143.75,182.75
X$6523 \$2049 VIA_M1M2_PR
* cell instance $6524 r0 *1 144.67,182.75
X$6524 \$2049 VIA_M1M2_PR
* cell instance $6525 r0 *1 143.75,130.05
X$6525 \$2049 VIA_M1M2_PR
* cell instance $6526 r0 *1 174.11,229.67
X$6526 \$2049 VIA_L1M1_PR_MR
* cell instance $6527 r0 *1 168.59,130.05
X$6527 \$2049 VIA_L1M1_PR_MR
* cell instance $6528 r0 *1 117.99,139.57
X$6528 \$2052 VIA_M1M2_PR
* cell instance $6529 r0 *1 117.99,133.79
X$6529 \$2052 VIA_M1M2_PR
* cell instance $6530 r0 *1 117.99,131.75
X$6530 \$2052 VIA_M1M2_PR
* cell instance $6531 r0 *1 125.35,140.25
X$6531 \$2052 VIA_L1M1_PR_MR
* cell instance $6532 r0 *1 111.55,139.57
X$6532 \$2052 VIA_L1M1_PR_MR
* cell instance $6533 r0 *1 118.91,133.79
X$6533 \$2052 VIA_L1M1_PR_MR
* cell instance $6534 r0 *1 123.51,131.75
X$6534 \$2052 VIA_L1M1_PR_MR
* cell instance $6535 r0 *1 115.23,129.03
X$6535 \$2053 VIA_M1M2_PR
* cell instance $6536 r0 *1 115.23,131.41
X$6536 \$2053 VIA_M1M2_PR
* cell instance $6537 r0 *1 115.23,131.41
X$6537 \$2053 VIA_L1M1_PR_MR
* cell instance $6538 r0 *1 123.05,129.03
X$6538 \$2053 VIA_L1M1_PR_MR
* cell instance $6539 r0 *1 110.63,134.98
X$6539 \$2068 VIA_M2M3_PR
* cell instance $6540 r0 *1 123.97,134.98
X$6540 \$2068 VIA_M2M3_PR
* cell instance $6541 r0 *1 110.63,134.47
X$6541 \$2068 VIA_M1M2_PR
* cell instance $6542 r0 *1 123.97,141.95
X$6542 \$2068 VIA_M1M2_PR
* cell instance $6543 r0 *1 123.97,137.19
X$6543 \$2068 VIA_M1M2_PR
* cell instance $6544 r0 *1 123.05,141.95
X$6544 \$2068 VIA_L1M1_PR_MR
* cell instance $6545 r0 *1 112.01,134.47
X$6545 \$2068 VIA_L1M1_PR_MR
* cell instance $6546 r0 *1 123.97,137.19
X$6546 \$2068 VIA_L1M1_PR_MR
* cell instance $6547 r0 *1 112.93,131.75
X$6547 \$2072 VIA_M1M2_PR
* cell instance $6548 r0 *1 112.93,136.51
X$6548 \$2072 VIA_M1M2_PR
* cell instance $6549 r0 *1 112.93,131.75
X$6549 \$2072 VIA_L1M1_PR_MR
* cell instance $6550 r0 *1 113.39,137.19
X$6550 \$2072 VIA_L1M1_PR_MR
* cell instance $6551 r0 *1 124.43,136.51
X$6551 \$2072 VIA_L1M1_PR_MR
* cell instance $6552 r0 *1 126.73,135.49
X$6552 \$2076 VIA_M1M2_PR
* cell instance $6553 r0 *1 126.73,139.91
X$6553 \$2076 VIA_M1M2_PR
* cell instance $6554 r0 *1 126.73,132.09
X$6554 \$2076 VIA_M1M2_PR
* cell instance $6555 r0 *1 126.73,139.91
X$6555 \$2076 VIA_L1M1_PR_MR
* cell instance $6556 r0 *1 117.53,134.81
X$6556 \$2076 VIA_L1M1_PR_MR
* cell instance $6557 r0 *1 123.05,132.09
X$6557 \$2076 VIA_L1M1_PR_MR
* cell instance $6558 r0 *1 113.39,134.81
X$6558 \$2079 VIA_M1M2_PR
* cell instance $6559 r0 *1 113.39,132.77
X$6559 \$2079 VIA_M1M2_PR
* cell instance $6560 r0 *1 124.89,132.43
X$6560 \$2079 VIA_M1M2_PR
* cell instance $6561 r0 *1 124.89,137.19
X$6561 \$2079 VIA_M1M2_PR
* cell instance $6562 r0 *1 112.93,134.81
X$6562 \$2079 VIA_L1M1_PR_MR
* cell instance $6563 r0 *1 125.35,132.43
X$6563 \$2079 VIA_L1M1_PR_MR
* cell instance $6564 r0 *1 124.89,137.19
X$6564 \$2079 VIA_L1M1_PR_MR
* cell instance $6565 r0 *1 169.97,225.25
X$6565 \$2083 VIA_M1M2_PR
* cell instance $6566 r0 *1 169.97,227.29
X$6566 \$2083 VIA_M1M2_PR
* cell instance $6567 r0 *1 137.31,225.25
X$6567 \$2083 VIA_M1M2_PR
* cell instance $6568 r0 *1 137.31,135.15
X$6568 \$2083 VIA_M1M2_PR
* cell instance $6569 r0 *1 169.97,227.29
X$6569 \$2083 VIA_L1M1_PR_MR
* cell instance $6570 r0 *1 170.43,134.81
X$6570 \$2083 VIA_L1M1_PR_MR
* cell instance $6571 r0 *1 170.43,132.43
X$6571 \$2084 VIA_L1M1_PR_MR
* cell instance $6572 r0 *1 173.65,132.09
X$6572 \$2084 VIA_L1M1_PR_MR
* cell instance $6573 r0 *1 173.65,143.31
X$6573 \$2100 VIA_M1M2_PR
* cell instance $6574 r0 *1 173.65,140.25
X$6574 \$2100 VIA_M1M2_PR
* cell instance $6575 r0 *1 173.65,134.13
X$6575 \$2100 VIA_M1M2_PR
* cell instance $6576 r0 *1 172.73,143.31
X$6576 \$2100 VIA_L1M1_PR_MR
* cell instance $6577 r0 *1 177.79,134.13
X$6577 \$2100 VIA_L1M1_PR_MR
* cell instance $6578 r0 *1 173.65,140.25
X$6578 \$2100 VIA_L1M1_PR_MR
* cell instance $6579 r0 *1 78.89,142.29
X$6579 \$2104 VIA_M1M2_PR
* cell instance $6580 r0 *1 78.89,137.53
X$6580 \$2104 VIA_M1M2_PR
* cell instance $6581 r0 *1 78.89,135.49
X$6581 \$2104 VIA_M1M2_PR
* cell instance $6582 r0 *1 72.45,142.29
X$6582 \$2104 VIA_L1M1_PR_MR
* cell instance $6583 r0 *1 79.35,137.53
X$6583 \$2104 VIA_L1M1_PR_MR
* cell instance $6584 r0 *1 78.43,135.49
X$6584 \$2104 VIA_L1M1_PR_MR
* cell instance $6585 r0 *1 79.81,141.95
X$6585 \$2108 VIA_M1M2_PR
* cell instance $6586 r0 *1 79.81,134.47
X$6586 \$2108 VIA_M1M2_PR
* cell instance $6587 r0 *1 74.29,141.95
X$6587 \$2108 VIA_L1M1_PR_MR
* cell instance $6588 r0 *1 85.79,134.47
X$6588 \$2108 VIA_L1M1_PR_MR
* cell instance $6589 r0 *1 171.35,132.43
X$6589 \$2110 VIA_M1M2_PR
* cell instance $6590 r0 *1 171.35,134.47
X$6590 \$2110 VIA_M1M2_PR
* cell instance $6591 r0 *1 129.49,232.73
X$6591 \$2110 VIA_M1M2_PR
* cell instance $6592 r0 *1 129.49,134.47
X$6592 \$2110 VIA_M1M2_PR
* cell instance $6593 r0 *1 170.43,232.73
X$6593 \$2110 VIA_L1M1_PR_MR
* cell instance $6594 r0 *1 171.35,132.43
X$6594 \$2110 VIA_L1M1_PR_MR
* cell instance $6595 r0 *1 137.77,229.67
X$6595 \$2112 VIA_M1M2_PR
* cell instance $6596 r0 *1 137.77,134.13
X$6596 \$2112 VIA_M1M2_PR
* cell instance $6597 r0 *1 170.43,229.67
X$6597 \$2112 VIA_L1M1_PR_MR
* cell instance $6598 r0 *1 169.51,134.13
X$6598 \$2112 VIA_L1M1_PR_MR
* cell instance $6599 r0 *1 123.05,139.91
X$6599 \$2125 VIA_M1M2_PR
* cell instance $6600 r0 *1 123.05,132.77
X$6600 \$2125 VIA_M1M2_PR
* cell instance $6601 r0 *1 123.05,139.91
X$6601 \$2125 VIA_L1M1_PR_MR
* cell instance $6602 r0 *1 121.21,132.77
X$6602 \$2125 VIA_L1M1_PR_MR
* cell instance $6603 r0 *1 112.47,132.09
X$6603 \$2127 VIA_L1M1_PR_MR
* cell instance $6604 r0 *1 122.13,132.09
X$6604 \$2127 VIA_L1M1_PR_MR
* cell instance $6605 r0 *1 90.39,143.65
X$6605 \$2135 VIA_M1M2_PR
* cell instance $6606 r0 *1 90.39,145.35
X$6606 \$2135 VIA_M1M2_PR
* cell instance $6607 r0 *1 70.15,151.13
X$6607 \$2135 VIA_M1M2_PR
* cell instance $6608 r0 *1 70.15,143.31
X$6608 \$2135 VIA_M1M2_PR
* cell instance $6609 r0 *1 70.125,151.13
X$6609 \$2135 VIA_L1M1_PR_MR
* cell instance $6610 r0 *1 80.73,142.63
X$6610 \$2135 VIA_L1M1_PR_MR
* cell instance $6611 r0 *1 91.77,143.65
X$6611 \$2135 VIA_L1M1_PR_MR
* cell instance $6612 r0 *1 90.39,145.35
X$6612 \$2135 VIA_L1M1_PR_MR
* cell instance $6613 r0 *1 89.93,137.53
X$6613 \$2136 VIA_L1M1_PR_MR
* cell instance $6614 r0 *1 81.65,137.87
X$6614 \$2136 VIA_L1M1_PR_MR
* cell instance $6615 r0 *1 82.57,141.95
X$6615 \$2138 VIA_L1M1_PR_MR
* cell instance $6616 r0 *1 84.41,142.29
X$6616 \$2138 VIA_L1M1_PR_MR
* cell instance $6617 r0 *1 111.55,137.87
X$6617 \$2141 VIA_L1M1_PR_MR
* cell instance $6618 r0 *1 122.19,138.21
X$6618 \$2141 VIA_L1M1_PR_MR
* cell instance $6619 r0 *1 117.99,142.97
X$6619 \$2146 VIA_M1M2_PR
* cell instance $6620 r0 *1 117.99,145.69
X$6620 \$2146 VIA_M1M2_PR
* cell instance $6621 r0 *1 117.07,142.97
X$6621 \$2146 VIA_L1M1_PR_MR
* cell instance $6622 r0 *1 117.99,145.69
X$6622 \$2146 VIA_L1M1_PR_MR
* cell instance $6623 r0 *1 113.85,142.63
X$6623 \$2146 VIA_L1M1_PR_MR
* cell instance $6624 r0 *1 158.93,178.5
X$6624 \$2156 VIA_M2M3_PR
* cell instance $6625 r0 *1 168.59,178.5
X$6625 \$2156 VIA_M2M3_PR
* cell instance $6626 r0 *1 158.93,178.33
X$6626 \$2156 VIA_M1M2_PR
* cell instance $6627 r0 *1 168.59,178.33
X$6627 \$2156 VIA_M1M2_PR
* cell instance $6628 r0 *1 124.43,140.25
X$6628 \$2156 VIA_M1M2_PR
* cell instance $6629 r0 *1 147.89,177.99
X$6629 \$2156 VIA_M1M2_PR
* cell instance $6630 r0 *1 147.89,174.93
X$6630 \$2156 VIA_M1M2_PR
* cell instance $6631 r0 *1 127.65,174.93
X$6631 \$2156 VIA_M1M2_PR
* cell instance $6632 r0 *1 124.43,129.37
X$6632 \$2156 VIA_M1M2_PR
* cell instance $6633 r0 *1 127.65,140.59
X$6633 \$2156 VIA_M1M2_PR
* cell instance $6634 r0 *1 124.43,137.53
X$6634 \$2156 VIA_M1M2_PR
* cell instance $6635 r0 *1 127.65,145.69
X$6635 \$2156 VIA_M1M2_PR
* cell instance $6636 r0 *1 127.65,134.81
X$6636 \$2156 VIA_M1M2_PR
* cell instance $6637 r0 *1 169.05,178.33
X$6637 \$2156 VIA_L1M1_PR_MR
* cell instance $6638 r0 *1 146.97,174.93
X$6638 \$2156 VIA_L1M1_PR_MR
* cell instance $6639 r0 *1 147.43,177.99
X$6639 \$2156 VIA_L1M1_PR_MR
* cell instance $6640 r0 *1 127.65,145.69
X$6640 \$2156 VIA_L1M1_PR_MR
* cell instance $6641 r0 *1 127.65,134.81
X$6641 \$2156 VIA_L1M1_PR_MR
* cell instance $6642 r0 *1 124.43,140.25
X$6642 \$2156 VIA_L1M1_PR_MR
* cell instance $6643 r0 *1 124.43,129.37
X$6643 \$2156 VIA_L1M1_PR_MR
* cell instance $6644 r0 *1 123.51,137.53
X$6644 \$2156 VIA_L1M1_PR_MR
* cell instance $6645 r0 *1 165.14,141.1
X$6645 \$2161 VIA_M3M4_PR
* cell instance $6646 r0 *1 165.14,226.78
X$6646 \$2161 VIA_M3M4_PR
* cell instance $6647 r0 *1 173.65,226.78
X$6647 \$2161 VIA_M2M3_PR
* cell instance $6648 r0 *1 171.35,141.1
X$6648 \$2161 VIA_M2M3_PR
* cell instance $6649 r0 *1 173.65,227.29
X$6649 \$2161 VIA_M1M2_PR
* cell instance $6650 r0 *1 171.35,140.59
X$6650 \$2161 VIA_M1M2_PR
* cell instance $6651 r0 *1 173.65,227.29
X$6651 \$2161 VIA_L1M1_PR_MR
* cell instance $6652 r0 *1 171.35,140.59
X$6652 \$2161 VIA_L1M1_PR_MR
* cell instance $6653 r0 *1 174.57,140.25
X$6653 \$2168 VIA_M1M2_PR
* cell instance $6654 r0 *1 174.57,142.63
X$6654 \$2168 VIA_M1M2_PR
* cell instance $6655 r0 *1 174.57,138.21
X$6655 \$2168 VIA_M1M2_PR
* cell instance $6656 r0 *1 173.65,138.21
X$6656 \$2168 VIA_L1M1_PR_MR
* cell instance $6657 r0 *1 173.65,142.63
X$6657 \$2168 VIA_L1M1_PR_MR
* cell instance $6658 r0 *1 174.57,140.25
X$6658 \$2168 VIA_L1M1_PR_MR
* cell instance $6659 r0 *1 28.29,148.75
X$6659 \$2174 VIA_M1M2_PR
* cell instance $6660 r0 *1 28.29,142.63
X$6660 \$2174 VIA_M1M2_PR
* cell instance $6661 r0 *1 32.43,153.85
X$6661 \$2174 VIA_M1M2_PR
* cell instance $6662 r0 *1 32.43,153.17
X$6662 \$2174 VIA_M1M2_PR
* cell instance $6663 r0 *1 28.29,153.17
X$6663 \$2174 VIA_M1M2_PR
* cell instance $6664 r0 *1 25.07,148.75
X$6664 \$2174 VIA_L1M1_PR_MR
* cell instance $6665 r0 *1 34.27,153.51
X$6665 \$2174 VIA_L1M1_PR_MR
* cell instance $6666 r0 *1 80.27,141.95
X$6666 \$2186 VIA_M1M2_PR
* cell instance $6667 r0 *1 80.27,137.19
X$6667 \$2186 VIA_M1M2_PR
* cell instance $6668 r0 *1 80.27,141.95
X$6668 \$2186 VIA_L1M1_PR_MR
* cell instance $6669 r0 *1 79.81,136.51
X$6669 \$2186 VIA_L1M1_PR_MR
* cell instance $6670 r0 *1 79.81,137.19
X$6670 \$2186 VIA_L1M1_PR_MR
* cell instance $6671 r0 *1 82.57,136.51
X$6671 \$2186 VIA_L1M1_PR_MR
* cell instance $6672 r0 *1 74.75,139.91
X$6672 \$2190 VIA_M1M2_PR
* cell instance $6673 r0 *1 74.75,148.75
X$6673 \$2190 VIA_M1M2_PR
* cell instance $6674 r0 *1 73.37,148.75
X$6674 \$2190 VIA_L1M1_PR_MR
* cell instance $6675 r0 *1 84.87,139.91
X$6675 \$2190 VIA_L1M1_PR_MR
* cell instance $6676 r0 *1 126.27,135.15
X$6676 \$2195 VIA_M1M2_PR
* cell instance $6677 r0 *1 126.27,139.57
X$6677 \$2195 VIA_M1M2_PR
* cell instance $6678 r0 *1 126.27,139.57
X$6678 \$2195 VIA_L1M1_PR_MR
* cell instance $6679 r0 *1 126.27,135.15
X$6679 \$2195 VIA_L1M1_PR_MR
* cell instance $6680 r0 *1 110.63,135.49
X$6680 \$2202 VIA_M1M2_PR
* cell instance $6681 r0 *1 110.63,137.19
X$6681 \$2202 VIA_M1M2_PR
* cell instance $6682 r0 *1 112.47,137.19
X$6682 \$2202 VIA_L1M1_PR_MR
* cell instance $6683 r0 *1 110.63,135.49
X$6683 \$2202 VIA_L1M1_PR_MR
* cell instance $6684 r0 *1 118.91,149.09
X$6684 \$2212 VIA_M1M2_PR
* cell instance $6685 r0 *1 118.91,150.79
X$6685 \$2212 VIA_M1M2_PR
* cell instance $6686 r0 *1 115.23,142.63
X$6686 \$2212 VIA_M1M2_PR
* cell instance $6687 r0 *1 115.69,145.69
X$6687 \$2212 VIA_M1M2_PR
* cell instance $6688 r0 *1 117.07,145.69
X$6688 \$2212 VIA_M1M2_PR
* cell instance $6689 r0 *1 117.07,149.09
X$6689 \$2212 VIA_M1M2_PR
* cell instance $6690 r0 *1 118.91,150.79
X$6690 \$2212 VIA_L1M1_PR_MR
* cell instance $6691 r0 *1 123.97,149.09
X$6691 \$2212 VIA_L1M1_PR_MR
* cell instance $6692 r0 *1 115.69,142.63
X$6692 \$2212 VIA_L1M1_PR_MR
* cell instance $6693 r0 *1 117.07,145.69
X$6693 \$2212 VIA_L1M1_PR_MR
* cell instance $6694 r0 *1 61.41,147.73
X$6694 \$2217 VIA_M1M2_PR
* cell instance $6695 r0 *1 61.41,145.69
X$6695 \$2217 VIA_M1M2_PR
* cell instance $6696 r0 *1 77.97,156.23
X$6696 \$2217 VIA_M1M2_PR
* cell instance $6697 r0 *1 77.97,146.03
X$6697 \$2217 VIA_M1M2_PR
* cell instance $6698 r0 *1 31.05,148.41
X$6698 \$2217 VIA_M1M2_PR
* cell instance $6699 r0 *1 32.43,145.35
X$6699 \$2217 VIA_M1M2_PR
* cell instance $6700 r0 *1 32.43,148.41
X$6700 \$2217 VIA_M1M2_PR
* cell instance $6701 r0 *1 31.05,150.11
X$6701 \$2217 VIA_M1M2_PR
* cell instance $6702 r0 *1 28.75,150.11
X$6702 \$2217 VIA_M1M2_PR
* cell instance $6703 r0 *1 28.75,158.95
X$6703 \$2217 VIA_M1M2_PR
* cell instance $6704 r0 *1 75.21,145.69
X$6704 \$2217 VIA_L1M1_PR_MR
* cell instance $6705 r0 *1 35.65,145.69
X$6705 \$2217 VIA_L1M1_PR_MR
* cell instance $6706 r0 *1 31.05,148.41
X$6706 \$2217 VIA_L1M1_PR_MR
* cell instance $6707 r0 *1 77.97,156.23
X$6707 \$2217 VIA_L1M1_PR_MR
* cell instance $6708 r0 *1 58.19,147.73
X$6708 \$2217 VIA_L1M1_PR_MR
* cell instance $6709 r0 *1 61.41,147.73
X$6709 \$2217 VIA_L1M1_PR_MR
* cell instance $6710 r0 *1 26.45,150.79
X$6710 \$2217 VIA_L1M1_PR_MR
* cell instance $6711 r0 *1 29.21,158.95
X$6711 \$2217 VIA_L1M1_PR_MR
* cell instance $6712 r0 *1 74.29,142.97
X$6712 \$2222 VIA_M1M2_PR
* cell instance $6713 r0 *1 74.29,147.39
X$6713 \$2222 VIA_M1M2_PR
* cell instance $6714 r0 *1 74.29,145.69
X$6714 \$2222 VIA_M1M2_PR
* cell instance $6715 r0 *1 72.45,145.69
X$6715 \$2222 VIA_L1M1_PR_MR
* cell instance $6716 r0 *1 71.99,142.97
X$6716 \$2222 VIA_L1M1_PR_MR
* cell instance $6717 r0 *1 76.13,147.39
X$6717 \$2222 VIA_L1M1_PR_MR
* cell instance $6718 r0 *1 71.99,146.37
X$6718 \$2223 VIA_M1M2_PR
* cell instance $6719 r0 *1 71.99,147.39
X$6719 \$2223 VIA_M1M2_PR
* cell instance $6720 r0 *1 77.51,140.93
X$6720 \$2223 VIA_M1M2_PR
* cell instance $6721 r0 *1 77.51,144.67
X$6721 \$2223 VIA_M1M2_PR
* cell instance $6722 r0 *1 71.53,147.39
X$6722 \$2223 VIA_L1M1_PR_MR
* cell instance $6723 r0 *1 71.99,146.37
X$6723 \$2223 VIA_L1M1_PR_MR
* cell instance $6724 r0 *1 71.99,145.35
X$6724 \$2223 VIA_L1M1_PR_MR
* cell instance $6725 r0 *1 77.51,140.93
X$6725 \$2223 VIA_L1M1_PR_MR
* cell instance $6726 r0 *1 94.07,145.69
X$6726 \$2224 VIA_M1M2_PR
* cell instance $6727 r0 *1 94.07,147.39
X$6727 \$2224 VIA_M1M2_PR
* cell instance $6728 r0 *1 82.57,150.11
X$6728 \$2224 VIA_M1M2_PR
* cell instance $6729 r0 *1 80.73,150.11
X$6729 \$2224 VIA_M1M2_PR
* cell instance $6730 r0 *1 80.73,152.83
X$6730 \$2224 VIA_M1M2_PR
* cell instance $6731 r0 *1 82.57,145.01
X$6731 \$2224 VIA_M1M2_PR
* cell instance $6732 r0 *1 81.65,152.83
X$6732 \$2224 VIA_L1M1_PR_MR
* cell instance $6733 r0 *1 71.985,151.13
X$6733 \$2224 VIA_L1M1_PR_MR
* cell instance $6734 r0 *1 89.93,145.69
X$6734 \$2224 VIA_L1M1_PR_MR
* cell instance $6735 r0 *1 94.07,147.39
X$6735 \$2224 VIA_L1M1_PR_MR
* cell instance $6736 r0 *1 117.99,150.45
X$6736 \$2229 VIA_M1M2_PR
* cell instance $6737 r0 *1 117.99,147.39
X$6737 \$2229 VIA_M1M2_PR
* cell instance $6738 r0 *1 117.99,146.37
X$6738 \$2229 VIA_M1M2_PR
* cell instance $6739 r0 *1 118.91,146.37
X$6739 \$2229 VIA_L1M1_PR_MR
* cell instance $6740 r0 *1 117.53,150.45
X$6740 \$2229 VIA_L1M1_PR_MR
* cell instance $6741 r0 *1 119.83,151.13
X$6741 \$2229 VIA_L1M1_PR_MR
* cell instance $6742 r0 *1 114.77,148.07
X$6742 \$2229 VIA_L1M1_PR_MR
* cell instance $6743 r0 *1 170.43,145.69
X$6743 \$2235 VIA_M1M2_PR
* cell instance $6744 r0 *1 170.43,148.07
X$6744 \$2235 VIA_M1M2_PR
* cell instance $6745 r0 *1 169.51,148.41
X$6745 \$2235 VIA_L1M1_PR_MR
* cell instance $6746 r0 *1 171.81,145.69
X$6746 \$2235 VIA_L1M1_PR_MR
* cell instance $6747 r0 *1 175.49,145.35
X$6747 \$2235 VIA_L1M1_PR_MR
* cell instance $6748 r0 *1 176.41,149.09
X$6748 \$2235 VIA_L1M1_PR_MR
* cell instance $6749 r0 *1 173.65,148.07
X$6749 \$2235 VIA_L1M1_PR_MR
* cell instance $6750 r0 *1 163.99,224.57
X$6750 \$2236 VIA_M1M2_PR
* cell instance $6751 r0 *1 163.99,221.85
X$6751 \$2236 VIA_M1M2_PR
* cell instance $6752 r0 *1 142.83,221.85
X$6752 \$2236 VIA_M1M2_PR
* cell instance $6753 r0 *1 142.83,143.31
X$6753 \$2236 VIA_M1M2_PR
* cell instance $6754 r0 *1 174.57,143.65
X$6754 \$2236 VIA_L1M1_PR_MR
* cell instance $6755 r0 *1 178.25,224.23
X$6755 \$2236 VIA_L1M1_PR_MR
* cell instance $6756 r0 *1 171.35,152.83
X$6756 \$2237 VIA_M1M2_PR
* cell instance $6757 r0 *1 171.35,146.03
X$6757 \$2237 VIA_M1M2_PR
* cell instance $6758 r0 *1 171.35,148.75
X$6758 \$2237 VIA_M1M2_PR
* cell instance $6759 r0 *1 173.19,145.69
X$6759 \$2237 VIA_L1M1_PR_MR
* cell instance $6760 r0 *1 170.43,148.75
X$6760 \$2237 VIA_L1M1_PR_MR
* cell instance $6761 r0 *1 171.35,152.83
X$6761 \$2237 VIA_L1M1_PR_MR
* cell instance $6762 r0 *1 34.27,142.97
X$6762 \$2246 VIA_M1M2_PR
* cell instance $6763 r0 *1 34.27,144.67
X$6763 \$2246 VIA_M1M2_PR
* cell instance $6764 r0 *1 34.27,142.97
X$6764 \$2246 VIA_L1M1_PR_MR
* cell instance $6765 r0 *1 34.33,144.67
X$6765 \$2246 VIA_L1M1_PR_MR
* cell instance $6766 r0 *1 144.21,230.69
X$6766 \$2251 VIA_M1M2_PR
* cell instance $6767 r0 *1 144.21,146.37
X$6767 \$2251 VIA_M1M2_PR
* cell instance $6768 r0 *1 175.49,229.67
X$6768 \$2251 VIA_L1M1_PR_MR
* cell instance $6769 r0 *1 174.11,146.37
X$6769 \$2251 VIA_L1M1_PR_MR
* cell instance $6770 r0 *1 123.97,150.11
X$6770 \$2253 VIA_M1M2_PR
* cell instance $6771 r0 *1 123.97,145.35
X$6771 \$2253 VIA_M1M2_PR
* cell instance $6772 r0 *1 126.27,145.35
X$6772 \$2253 VIA_L1M1_PR_MR
* cell instance $6773 r0 *1 121.67,150.11
X$6773 \$2253 VIA_L1M1_PR_MR
* cell instance $6774 r0 *1 78.89,152.83
X$6774 \$2264 VIA_M1M2_PR
* cell instance $6775 r0 *1 78.43,149.09
X$6775 \$2264 VIA_M1M2_PR
* cell instance $6776 r0 *1 78.89,145.35
X$6776 \$2264 VIA_M1M2_PR
* cell instance $6777 r0 *1 71.07,148.41
X$6777 \$2264 VIA_L1M1_PR_MR
* cell instance $6778 r0 *1 77.97,152.83
X$6778 \$2264 VIA_L1M1_PR_MR
* cell instance $6779 r0 *1 83.95,145.35
X$6779 \$2264 VIA_L1M1_PR_MR
* cell instance $6780 r0 *1 89.47,149.09
X$6780 \$2265 VIA_M1M2_PR
* cell instance $6781 r0 *1 89.47,150.11
X$6781 \$2265 VIA_M1M2_PR
* cell instance $6782 r0 *1 82.57,153.17
X$6782 \$2265 VIA_M1M2_PR
* cell instance $6783 r0 *1 83.03,149.09
X$6783 \$2265 VIA_M1M2_PR
* cell instance $6784 r0 *1 83.03,145.69
X$6784 \$2265 VIA_M1M2_PR
* cell instance $6785 r0 *1 77.51,156.23
X$6785 \$2265 VIA_M1M2_PR
* cell instance $6786 r0 *1 77.51,153.17
X$6786 \$2265 VIA_M1M2_PR
* cell instance $6787 r0 *1 84.87,145.69
X$6787 \$2265 VIA_L1M1_PR_MR
* cell instance $6788 r0 *1 73.83,156.57
X$6788 \$2265 VIA_L1M1_PR_MR
* cell instance $6789 r0 *1 96.83,150.11
X$6789 \$2265 VIA_L1M1_PR_MR
* cell instance $6790 r0 *1 83.49,147.73
X$6790 \$2266 VIA_M1M2_PR
* cell instance $6791 r0 *1 83.49,146.37
X$6791 \$2266 VIA_M1M2_PR
* cell instance $6792 r0 *1 74.29,146.37
X$6792 \$2266 VIA_L1M1_PR_MR
* cell instance $6793 r0 *1 83.49,147.73
X$6793 \$2266 VIA_L1M1_PR_MR
* cell instance $6794 r0 *1 129.26,278.46
X$6794 \$2269 VIA_M3M4_PR
* cell instance $6795 r0 *1 129.26,173.06
X$6795 \$2269 VIA_M3M4_PR
* cell instance $6796 r0 *1 88.55,173.06
X$6796 \$2269 VIA_M2M3_PR
* cell instance $6797 r0 *1 174.57,278.46
X$6797 \$2269 VIA_M2M3_PR
* cell instance $6798 r0 *1 174.57,276.25
X$6798 \$2269 VIA_M1M2_PR
* cell instance $6799 r0 *1 174.57,277.95
X$6799 \$2269 VIA_M1M2_PR
* cell instance $6800 r0 *1 88.55,146.03
X$6800 \$2269 VIA_M1M2_PR
* cell instance $6801 r0 *1 85.33,146.03
X$6801 \$2269 VIA_L1M1_PR_MR
* cell instance $6802 r0 *1 174.11,277.95
X$6802 \$2269 VIA_L1M1_PR_MR
* cell instance $6803 r0 *1 174.57,276.25
X$6803 \$2269 VIA_L1M1_PR_MR
* cell instance $6804 r0 *1 113.39,143.31
X$6804 \$2270 VIA_M1M2_PR
* cell instance $6805 r0 *1 113.39,148.07
X$6805 \$2270 VIA_M1M2_PR
* cell instance $6806 r0 *1 112.93,143.31
X$6806 \$2270 VIA_L1M1_PR_MR
* cell instance $6807 r0 *1 113.39,148.07
X$6807 \$2270 VIA_L1M1_PR_MR
* cell instance $6808 r0 *1 83.03,154.53
X$6808 \$2285 VIA_M1M2_PR
* cell instance $6809 r0 *1 72.91,154.53
X$6809 \$2285 VIA_M1M2_PR
* cell instance $6810 r0 *1 72.91,150.45
X$6810 \$2285 VIA_M1M2_PR
* cell instance $6811 r0 *1 83.03,161.33
X$6811 \$2285 VIA_M1M2_PR
* cell instance $6812 r0 *1 83.95,161.33
X$6812 \$2285 VIA_L1M1_PR_MR
* cell instance $6813 r0 *1 72.45,151.13
X$6813 \$2285 VIA_L1M1_PR_MR
* cell instance $6814 r0 *1 77.05,150.79
X$6814 \$2288 VIA_M1M2_PR
* cell instance $6815 r0 *1 84.41,153.51
X$6815 \$2288 VIA_M1M2_PR
* cell instance $6816 r0 *1 84.87,150.11
X$6816 \$2288 VIA_M1M2_PR
* cell instance $6817 r0 *1 77.05,148.41
X$6817 \$2288 VIA_M1M2_PR
* cell instance $6818 r0 *1 77.05,142.63
X$6818 \$2288 VIA_M1M2_PR
* cell instance $6819 r0 *1 84.87,148.41
X$6819 \$2288 VIA_M1M2_PR
* cell instance $6820 r0 *1 77.05,142.63
X$6820 \$2288 VIA_L1M1_PR_MR
* cell instance $6821 r0 *1 85.33,148.41
X$6821 \$2288 VIA_L1M1_PR_MR
* cell instance $6822 r0 *1 84.87,148.41
X$6822 \$2288 VIA_L1M1_PR_MR
* cell instance $6823 r0 *1 77.05,150.79
X$6823 \$2288 VIA_L1M1_PR_MR
* cell instance $6824 r0 *1 87.17,150.79
X$6824 \$2288 VIA_L1M1_PR_MR
* cell instance $6825 r0 *1 84.41,153.51
X$6825 \$2288 VIA_L1M1_PR_MR
* cell instance $6826 r0 *1 88.09,150.79
X$6826 \$2288 VIA_L1M1_PR_MR
* cell instance $6827 r0 *1 113.85,151.47
X$6827 \$2293 VIA_M1M2_PR
* cell instance $6828 r0 *1 113.85,148.07
X$6828 \$2293 VIA_M1M2_PR
* cell instance $6829 r0 *1 114.31,145.69
X$6829 \$2293 VIA_M1M2_PR
* cell instance $6830 r0 *1 114.31,148.07
X$6830 \$2293 VIA_L1M1_PR_MR
* cell instance $6831 r0 *1 114.31,145.69
X$6831 \$2293 VIA_L1M1_PR_MR
* cell instance $6832 r0 *1 121.21,151.13
X$6832 \$2293 VIA_L1M1_PR_MR
* cell instance $6833 r0 *1 77.05,159.63
X$6833 \$2294 VIA_M1M2_PR
* cell instance $6834 r0 *1 88.55,199.75
X$6834 \$2294 VIA_M1M2_PR
* cell instance $6835 r0 *1 88.55,202.47
X$6835 \$2294 VIA_M1M2_PR
* cell instance $6836 r0 *1 77.05,164.39
X$6836 \$2294 VIA_M1M2_PR
* cell instance $6837 r0 *1 114.31,159.29
X$6837 \$2294 VIA_M1M2_PR
* cell instance $6838 r0 *1 115.23,159.29
X$6838 \$2294 VIA_M1M2_PR
* cell instance $6839 r0 *1 114.31,148.75
X$6839 \$2294 VIA_M1M2_PR
* cell instance $6840 r0 *1 101.43,197.03
X$6840 \$2294 VIA_M1M2_PR
* cell instance $6841 r0 *1 101.43,199.75
X$6841 \$2294 VIA_M1M2_PR
* cell instance $6842 r0 *1 115.23,199.75
X$6842 \$2294 VIA_M1M2_PR
* cell instance $6843 r0 *1 115.23,185.81
X$6843 \$2294 VIA_M1M2_PR
* cell instance $6844 r0 *1 115.23,184.11
X$6844 \$2294 VIA_M1M2_PR
* cell instance $6845 r0 *1 77.05,164.39
X$6845 \$2294 VIA_L1M1_PR_MR
* cell instance $6846 r0 *1 91.31,159.29
X$6846 \$2294 VIA_L1M1_PR_MR
* cell instance $6847 r0 *1 39.33,202.47
X$6847 \$2294 VIA_L1M1_PR_MR
* cell instance $6848 r0 *1 116.61,186.15
X$6848 \$2294 VIA_L1M1_PR_MR
* cell instance $6849 r0 *1 114.31,183.77
X$6849 \$2294 VIA_L1M1_PR_MR
* cell instance $6850 r0 *1 104.65,199.75
X$6850 \$2294 VIA_L1M1_PR_MR
* cell instance $6851 r0 *1 101.43,197.03
X$6851 \$2294 VIA_L1M1_PR_MR
* cell instance $6852 r0 *1 115.23,148.41
X$6852 \$2294 VIA_L1M1_PR_MR
* cell instance $6853 r0 *1 112.47,149.09
X$6853 \$2295 VIA_L1M1_PR_MR
* cell instance $6854 r0 *1 116.61,148.41
X$6854 \$2295 VIA_L1M1_PR_MR
* cell instance $6855 r0 *1 142.37,150.62
X$6855 O[2] VIA_M2M3_PR
* cell instance $6856 r0 *1 182.85,245.31
X$6856 O[2] VIA_M1M2_PR
* cell instance $6857 r0 *1 182.85,243.27
X$6857 O[2] VIA_M1M2_PR
* cell instance $6858 r0 *1 142.37,242.59
X$6858 O[2] VIA_M1M2_PR
* cell instance $6859 r0 *1 182.85,245.31
X$6859 O[2] VIA_L1M1_PR_MR
* cell instance $6860 r0 *1 171.81,148.07
X$6860 \$2305 VIA_M1M2_PR
* cell instance $6861 r0 *1 171.81,158.95
X$6861 \$2305 VIA_M1M2_PR
* cell instance $6862 r0 *1 170.89,148.07
X$6862 \$2305 VIA_L1M1_PR_MR
* cell instance $6863 r0 *1 172.56,148.07
X$6863 \$2305 VIA_L1M1_PR_MR
* cell instance $6864 r0 *1 171.81,158.95
X$6864 \$2305 VIA_L1M1_PR_MR
* cell instance $6865 r0 *1 172.73,156.23
X$6865 \$2313 VIA_M1M2_PR
* cell instance $6866 r0 *1 172.73,151.81
X$6866 \$2313 VIA_M1M2_PR
* cell instance $6867 r0 *1 175.03,147.73
X$6867 \$2313 VIA_M1M2_PR
* cell instance $6868 r0 *1 175.03,151.81
X$6868 \$2313 VIA_M1M2_PR
* cell instance $6869 r0 *1 172.73,153.85
X$6869 \$2313 VIA_M1M2_PR
* cell instance $6870 r0 *1 176.41,147.73
X$6870 \$2313 VIA_L1M1_PR_MR
* cell instance $6871 r0 *1 176.41,151.81
X$6871 \$2313 VIA_L1M1_PR_MR
* cell instance $6872 r0 *1 172.73,153.85
X$6872 \$2313 VIA_L1M1_PR_MR
* cell instance $6873 r0 *1 172.27,156.23
X$6873 \$2313 VIA_L1M1_PR_MR
* cell instance $6874 r0 *1 130.87,229.33
X$6874 \$2318 VIA_M1M2_PR
* cell instance $6875 r0 *1 130.87,147.39
X$6875 \$2318 VIA_M1M2_PR
* cell instance $6876 r0 *1 171.81,229.67
X$6876 \$2318 VIA_L1M1_PR_MR
* cell instance $6877 r0 *1 175.49,147.39
X$6877 \$2318 VIA_L1M1_PR_MR
* cell instance $6878 r0 *1 31.51,162.01
X$6878 \$2321 VIA_M1M2_PR
* cell instance $6879 r0 *1 31.51,147.39
X$6879 \$2321 VIA_M1M2_PR
* cell instance $6880 r0 *1 30.13,147.39
X$6880 \$2321 VIA_L1M1_PR_MR
* cell instance $6881 r0 *1 31.51,162.01
X$6881 \$2321 VIA_L1M1_PR_MR
* cell instance $6882 r0 *1 166.29,222.53
X$6882 \$2323 VIA_M1M2_PR
* cell instance $6883 r0 *1 166.29,223.89
X$6883 \$2323 VIA_M1M2_PR
* cell instance $6884 r0 *1 127.19,222.53
X$6884 \$2323 VIA_M1M2_PR
* cell instance $6885 r0 *1 127.19,147.73
X$6885 \$2323 VIA_M1M2_PR
* cell instance $6886 r0 *1 166.29,223.89
X$6886 \$2323 VIA_L1M1_PR_MR
* cell instance $6887 r0 *1 171.35,147.73
X$6887 \$2323 VIA_L1M1_PR_MR
* cell instance $6888 r0 *1 33.81,147.73
X$6888 \$2324 VIA_M1M2_PR
* cell instance $6889 r0 *1 33.81,152.83
X$6889 \$2324 VIA_M1M2_PR
* cell instance $6890 r0 *1 32.43,147.73
X$6890 \$2324 VIA_L1M1_PR_MR
* cell instance $6891 r0 *1 34.73,152.83
X$6891 \$2324 VIA_L1M1_PR_MR
* cell instance $6892 r0 *1 172.73,150.11
X$6892 \$2325 VIA_M1M2_PR
* cell instance $6893 r0 *1 172.73,145.69
X$6893 \$2325 VIA_M1M2_PR
* cell instance $6894 r0 *1 172.73,145.69
X$6894 \$2325 VIA_L1M1_PR_MR
* cell instance $6895 r0 *1 170.43,150.11
X$6895 \$2325 VIA_L1M1_PR_MR
* cell instance $6896 r0 *1 136.85,226.61
X$6896 \$2331 VIA_M1M2_PR
* cell instance $6897 r0 *1 136.85,149.09
X$6897 \$2331 VIA_M1M2_PR
* cell instance $6898 r0 *1 168.59,227.29
X$6898 \$2331 VIA_L1M1_PR_MR
* cell instance $6899 r0 *1 168.59,149.09
X$6899 \$2331 VIA_L1M1_PR_MR
* cell instance $6900 r0 *1 88.09,146.37
X$6900 \$2352 VIA_M1M2_PR
* cell instance $6901 r0 *1 88.09,147.73
X$6901 \$2352 VIA_M1M2_PR
* cell instance $6902 r0 *1 86.71,147.73
X$6902 \$2352 VIA_L1M1_PR_MR
* cell instance $6903 r0 *1 88.09,146.37
X$6903 \$2352 VIA_L1M1_PR_MR
* cell instance $6904 r0 *1 78.43,151.81
X$6904 \$2376 VIA_M1M2_PR
* cell instance $6905 r0 *1 78.43,153.85
X$6905 \$2376 VIA_M1M2_PR
* cell instance $6906 r0 *1 78.43,162.01
X$6906 \$2376 VIA_M1M2_PR
* cell instance $6907 r0 *1 77.05,162.01
X$6907 \$2376 VIA_L1M1_PR_MR
* cell instance $6908 r0 *1 78.43,153.85
X$6908 \$2376 VIA_L1M1_PR_MR
* cell instance $6909 r0 *1 78.43,151.81
X$6909 \$2376 VIA_L1M1_PR_MR
* cell instance $6910 r0 *1 88.09,153.85
X$6910 \$2377 VIA_M1M2_PR
* cell instance $6911 r0 *1 88.09,162.01
X$6911 \$2377 VIA_M1M2_PR
* cell instance $6912 r0 *1 86.71,162.01
X$6912 \$2377 VIA_L1M1_PR_MR
* cell instance $6913 r0 *1 82.11,153.51
X$6913 \$2377 VIA_L1M1_PR_MR
* cell instance $6914 r0 *1 93.15,153.85
X$6914 \$2377 VIA_L1M1_PR_MR
* cell instance $6915 r0 *1 85.79,153.17
X$6915 \$2379 VIA_L1M1_PR_MR
* cell instance $6916 r0 *1 83.95,152.83
X$6916 \$2379 VIA_L1M1_PR_MR
* cell instance $6917 r0 *1 172.27,151.47
X$6917 \$2404 VIA_M1M2_PR
* cell instance $6918 r0 *1 172.27,145.69
X$6918 \$2404 VIA_M1M2_PR
* cell instance $6919 r0 *1 172.27,145.69
X$6919 \$2404 VIA_L1M1_PR_MR
* cell instance $6920 r0 *1 174.11,151.47
X$6920 \$2404 VIA_L1M1_PR_MR
* cell instance $6921 r0 *1 35.65,153.51
X$6921 \$2406 VIA_M1M2_PR
* cell instance $6922 r0 *1 35.65,151.81
X$6922 \$2406 VIA_M1M2_PR
* cell instance $6923 r0 *1 35.65,153.51
X$6923 \$2406 VIA_L1M1_PR_MR
* cell instance $6924 r0 *1 37.03,151.81
X$6924 \$2406 VIA_L1M1_PR_MR
* cell instance $6925 r0 *1 69.23,153.17
X$6925 \$2416 VIA_M1M2_PR
* cell instance $6926 r0 *1 69.23,186.49
X$6926 \$2416 VIA_M1M2_PR
* cell instance $6927 r0 *1 79.35,283.39
X$6927 \$2416 VIA_M1M2_PR
* cell instance $6928 r0 *1 79.35,186.49
X$6928 \$2416 VIA_M1M2_PR
* cell instance $6929 r0 *1 69.69,153.17
X$6929 \$2416 VIA_L1M1_PR_MR
* cell instance $6930 r0 *1 105.57,283.39
X$6930 \$2416 VIA_L1M1_PR_MR
* cell instance $6931 r0 *1 70.15,152.83
X$6931 \$2419 VIA_M1M2_PR
* cell instance $6932 r0 *1 70.15,207.91
X$6932 \$2419 VIA_M1M2_PR
* cell instance $6933 r0 *1 81.19,237.15
X$6933 \$2419 VIA_M1M2_PR
* cell instance $6934 r0 *1 81.19,207.91
X$6934 \$2419 VIA_M1M2_PR
* cell instance $6935 r0 *1 73.37,152.83
X$6935 \$2419 VIA_L1M1_PR_MR
* cell instance $6936 r0 *1 111.09,237.15
X$6936 \$2419 VIA_L1M1_PR_MR
* cell instance $6937 r0 *1 71.99,151.81
X$6937 \$2420 VIA_M1M2_PR
* cell instance $6938 r0 *1 71.99,156.57
X$6938 \$2420 VIA_M1M2_PR
* cell instance $6939 r0 *1 71.99,156.57
X$6939 \$2420 VIA_L1M1_PR_MR
* cell instance $6940 r0 *1 69.23,151.81
X$6940 \$2420 VIA_L1M1_PR_MR
* cell instance $6941 r0 *1 71.53,153.51
X$6941 \$2421 VIA_M1M2_PR
* cell instance $6942 r0 *1 71.53,249.73
X$6942 \$2421 VIA_M1M2_PR
* cell instance $6943 r0 *1 72.45,153.51
X$6943 \$2421 VIA_L1M1_PR_MR
* cell instance $6944 r0 *1 116.61,249.73
X$6944 \$2421 VIA_L1M1_PR_MR
* cell instance $6945 r0 *1 76.59,152.83
X$6945 \$2423 VIA_M1M2_PR
* cell instance $6946 r0 *1 76.59,145.35
X$6946 \$2423 VIA_M1M2_PR
* cell instance $6947 r0 *1 76.59,145.35
X$6947 \$2423 VIA_L1M1_PR_MR
* cell instance $6948 r0 *1 76.13,152.83
X$6948 \$2423 VIA_L1M1_PR_MR
* cell instance $6949 r0 *1 103.73,251.77
X$6949 \$2425 VIA_M1M2_PR
* cell instance $6950 r0 *1 103.73,258.91
X$6950 \$2425 VIA_M1M2_PR
* cell instance $6951 r0 *1 73.83,153.51
X$6951 \$2425 VIA_M1M2_PR
* cell instance $6952 r0 *1 73.83,251.77
X$6952 \$2425 VIA_M1M2_PR
* cell instance $6953 r0 *1 72.91,153.51
X$6953 \$2425 VIA_L1M1_PR_MR
* cell instance $6954 r0 *1 110.63,258.91
X$6954 \$2425 VIA_L1M1_PR_MR
* cell instance $6955 r0 *1 83.49,150.79
X$6955 \$2437 VIA_M1M2_PR
* cell instance $6956 r0 *1 83.49,160.99
X$6956 \$2437 VIA_M1M2_PR
* cell instance $6957 r0 *1 78.89,160.99
X$6957 \$2437 VIA_L1M1_PR_MR
* cell instance $6958 r0 *1 85.79,150.79
X$6958 \$2437 VIA_L1M1_PR_MR
* cell instance $6959 r0 *1 87.63,156.23
X$6959 \$2438 VIA_M1M2_PR
* cell instance $6960 r0 *1 87.63,151.47
X$6960 \$2438 VIA_M1M2_PR
* cell instance $6961 r0 *1 71.07,155.89
X$6961 \$2438 VIA_L1M1_PR_MR
* cell instance $6962 r0 *1 89.47,151.47
X$6962 \$2438 VIA_L1M1_PR_MR
* cell instance $6963 r0 *1 28.29,156.23
X$6963 \$2441 VIA_M1M2_PR
* cell instance $6964 r0 *1 28.29,153.85
X$6964 \$2441 VIA_M1M2_PR
* cell instance $6965 r0 *1 27.37,156.57
X$6965 \$2441 VIA_L1M1_PR_MR
* cell instance $6966 r0 *1 28.29,153.85
X$6966 \$2441 VIA_L1M1_PR_MR
* cell instance $6967 r0 *1 78.66,278.46
X$6967 \$2449 VIA_M3M4_PR
* cell instance $6968 r0 *1 78.66,156.74
X$6968 \$2449 VIA_M3M4_PR
* cell instance $6969 r0 *1 69.69,156.74
X$6969 \$2449 VIA_M2M3_PR
* cell instance $6970 r0 *1 106.49,278.46
X$6970 \$2449 VIA_M2M3_PR
* cell instance $6971 r0 *1 106.49,278.29
X$6971 \$2449 VIA_M1M2_PR
* cell instance $6972 r0 *1 69.69,154.53
X$6972 \$2449 VIA_M1M2_PR
* cell instance $6973 r0 *1 69.69,154.53
X$6973 \$2449 VIA_L1M1_PR_MR
* cell instance $6974 r0 *1 106.49,278.29
X$6974 \$2449 VIA_L1M1_PR_MR
* cell instance $6975 r0 *1 71.3,265.54
X$6975 \$2450 VIA_M3M4_PR
* cell instance $6976 r0 *1 71.3,156.06
X$6976 \$2450 VIA_M3M4_PR
* cell instance $6977 r0 *1 123.97,265.54
X$6977 \$2450 VIA_M2M3_PR
* cell instance $6978 r0 *1 70.61,156.06
X$6978 \$2450 VIA_M2M3_PR
* cell instance $6979 r0 *1 123.97,275.23
X$6979 \$2450 VIA_M1M2_PR
* cell instance $6980 r0 *1 70.61,153.17
X$6980 \$2450 VIA_M1M2_PR
* cell instance $6981 r0 *1 70.61,153.17
X$6981 \$2450 VIA_L1M1_PR_MR
* cell instance $6982 r0 *1 123.97,275.23
X$6982 \$2450 VIA_L1M1_PR_MR
* cell instance $6983 r0 *1 68.77,154.53
X$6983 \$2453 VIA_M1M2_PR
* cell instance $6984 r0 *1 68.77,158.95
X$6984 \$2453 VIA_M1M2_PR
* cell instance $6985 r0 *1 68.77,154.53
X$6985 \$2453 VIA_L1M1_PR_MR
* cell instance $6986 r0 *1 76.13,158.61
X$6986 \$2453 VIA_L1M1_PR_MR
* cell instance $6987 r0 *1 78.89,157.25
X$6987 \$2454 VIA_M1M2_PR
* cell instance $6988 r0 *1 78.89,188.19
X$6988 \$2454 VIA_M1M2_PR
* cell instance $6989 r0 *1 76.59,156.57
X$6989 \$2454 VIA_L1M1_PR_MR
* cell instance $6990 r0 *1 116.61,188.19
X$6990 \$2454 VIA_L1M1_PR_MR
* cell instance $6991 r0 *1 169.97,278.29
X$6991 \$2455 VIA_M1M2_PR
* cell instance $6992 r0 *1 169.97,265.71
X$6992 \$2455 VIA_M1M2_PR
* cell instance $6993 r0 *1 76.13,159.29
X$6993 \$2455 VIA_M1M2_PR
* cell instance $6994 r0 *1 77.05,265.71
X$6994 \$2455 VIA_M1M2_PR
* cell instance $6995 r0 *1 77.05,165.07
X$6995 \$2455 VIA_M1M2_PR
* cell instance $6996 r0 *1 76.13,165.07
X$6996 \$2455 VIA_M1M2_PR
* cell instance $6997 r0 *1 77.51,158.95
X$6997 \$2455 VIA_L1M1_PR_MR
* cell instance $6998 r0 *1 171.35,278.29
X$6998 \$2455 VIA_L1M1_PR_MR
* cell instance $6999 r0 *1 79.81,157.25
X$6999 \$2458 VIA_M1M2_PR
* cell instance $7000 r0 *1 79.81,158.95
X$7000 \$2458 VIA_M1M2_PR
* cell instance $7001 r0 *1 79.81,161.67
X$7001 \$2458 VIA_M1M2_PR
* cell instance $7002 r0 *1 81.65,161.67
X$7002 \$2458 VIA_L1M1_PR_MR
* cell instance $7003 r0 *1 79.81,158.95
X$7003 \$2458 VIA_L1M1_PR_MR
* cell instance $7004 r0 *1 86.71,157.25
X$7004 \$2458 VIA_L1M1_PR_MR
* cell instance $7005 r0 *1 91.31,157.25
X$7005 \$2462 VIA_M1M2_PR
* cell instance $7006 r0 *1 91.31,159.97
X$7006 \$2462 VIA_M1M2_PR
* cell instance $7007 r0 *1 84.87,159.97
X$7007 \$2462 VIA_M1M2_PR
* cell instance $7008 r0 *1 84.87,162.01
X$7008 \$2462 VIA_M1M2_PR
* cell instance $7009 r0 *1 84.845,162.01
X$7009 \$2462 VIA_L1M1_PR_MR
* cell instance $7010 r0 *1 80.27,158.95
X$7010 \$2462 VIA_L1M1_PR_MR
* cell instance $7011 r0 *1 82.57,159.97
X$7011 \$2462 VIA_L1M1_PR_MR
* cell instance $7012 r0 *1 82.57,159.29
X$7012 \$2462 VIA_L1M1_PR_MR
* cell instance $7013 r0 *1 89.93,157.25
X$7013 \$2462 VIA_L1M1_PR_MR
* cell instance $7014 r0 *1 164.22,158.1
X$7014 \$2475 VIA_M3M4_PR
* cell instance $7015 r0 *1 164.22,228.14
X$7015 \$2475 VIA_M3M4_PR
* cell instance $7016 r0 *1 166.29,228.14
X$7016 \$2475 VIA_M2M3_PR
* cell instance $7017 r0 *1 174.11,158.1
X$7017 \$2475 VIA_M2M3_PR
* cell instance $7018 r0 *1 166.29,233.07
X$7018 \$2475 VIA_M1M2_PR
* cell instance $7019 r0 *1 174.11,153.85
X$7019 \$2475 VIA_M1M2_PR
* cell instance $7020 r0 *1 171.81,233.07
X$7020 \$2475 VIA_L1M1_PR_MR
* cell instance $7021 r0 *1 174.11,153.85
X$7021 \$2475 VIA_L1M1_PR_MR
* cell instance $7022 r0 *1 27.83,156.23
X$7022 \$2492 VIA_M1M2_PR
* cell instance $7023 r0 *1 27.83,151.47
X$7023 \$2492 VIA_M1M2_PR
* cell instance $7024 r0 *1 27.83,156.23
X$7024 \$2492 VIA_L1M1_PR_MR
* cell instance $7025 r0 *1 27.83,151.47
X$7025 \$2492 VIA_L1M1_PR_MR
* cell instance $7026 r0 *1 173.19,155.89
X$7026 \$2498 VIA_M1M2_PR
* cell instance $7027 r0 *1 173.19,153.51
X$7027 \$2498 VIA_M1M2_PR
* cell instance $7028 r0 *1 171.35,155.89
X$7028 \$2498 VIA_L1M1_PR_MR
* cell instance $7029 r0 *1 173.19,153.51
X$7029 \$2498 VIA_L1M1_PR_MR
* cell instance $7030 r0 *1 175.95,221.51
X$7030 \$2500 VIA_M1M2_PR
* cell instance $7031 r0 *1 175.95,223.55
X$7031 \$2500 VIA_M1M2_PR
* cell instance $7032 r0 *1 161.69,157.25
X$7032 \$2500 VIA_M1M2_PR
* cell instance $7033 r0 *1 161.69,176.29
X$7033 \$2500 VIA_M1M2_PR
* cell instance $7034 r0 *1 143.75,221.17
X$7034 \$2500 VIA_M1M2_PR
* cell instance $7035 r0 *1 143.75,183.43
X$7035 \$2500 VIA_M1M2_PR
* cell instance $7036 r0 *1 145.13,183.43
X$7036 \$2500 VIA_M1M2_PR
* cell instance $7037 r0 *1 144.67,176.29
X$7037 \$2500 VIA_M1M2_PR
* cell instance $7038 r0 *1 173.19,157.25
X$7038 \$2500 VIA_L1M1_PR_MR
* cell instance $7039 r0 *1 179.63,223.89
X$7039 \$2500 VIA_L1M1_PR_MR
* cell instance $7040 r0 *1 72.45,154.53
X$7040 \$2511 VIA_M1M2_PR
* cell instance $7041 r0 *1 72.45,158.61
X$7041 \$2511 VIA_M1M2_PR
* cell instance $7042 r0 *1 71.53,154.53
X$7042 \$2511 VIA_L1M1_PR_MR
* cell instance $7043 r0 *1 75.21,158.61
X$7043 \$2511 VIA_L1M1_PR_MR
* cell instance $7044 r0 *1 76.59,157.25
X$7044 \$2517 VIA_M1M2_PR
* cell instance $7045 r0 *1 76.13,207.57
X$7045 \$2517 VIA_M1M2_PR
* cell instance $7046 r0 *1 96.37,218.11
X$7046 \$2517 VIA_M1M2_PR
* cell instance $7047 r0 *1 96.37,207.57
X$7047 \$2517 VIA_M1M2_PR
* cell instance $7048 r0 *1 76.13,157.25
X$7048 \$2517 VIA_L1M1_PR_MR
* cell instance $7049 r0 *1 113.85,218.11
X$7049 \$2517 VIA_L1M1_PR_MR
* cell instance $7050 r0 *1 73.37,175.27
X$7050 \$2518 VIA_M1M2_PR
* cell instance $7051 r0 *1 73.37,156.91
X$7051 \$2518 VIA_M1M2_PR
* cell instance $7052 r0 *1 100.05,215.39
X$7052 \$2518 VIA_M1M2_PR
* cell instance $7053 r0 *1 100.05,175.27
X$7053 \$2518 VIA_M1M2_PR
* cell instance $7054 r0 *1 75.67,156.91
X$7054 \$2518 VIA_L1M1_PR_MR
* cell instance $7055 r0 *1 111.09,215.39
X$7055 \$2518 VIA_L1M1_PR_MR
* cell instance $7056 r0 *1 74.75,159.97
X$7056 \$2519 VIA_M1M2_PR
* cell instance $7057 r0 *1 74.75,157.25
X$7057 \$2519 VIA_M1M2_PR
* cell instance $7058 r0 *1 74.75,157.25
X$7058 \$2519 VIA_L1M1_PR_MR
* cell instance $7059 r0 *1 76.13,159.97
X$7059 \$2519 VIA_L1M1_PR_MR
* cell instance $7060 r0 *1 77.97,158.27
X$7060 \$2523 VIA_M1M2_PR
* cell instance $7061 r0 *1 77.97,156.91
X$7061 \$2523 VIA_M1M2_PR
* cell instance $7062 r0 *1 77.97,158.27
X$7062 \$2523 VIA_L1M1_PR_MR
* cell instance $7063 r0 *1 79.35,156.91
X$7063 \$2523 VIA_L1M1_PR_MR
* cell instance $7064 r0 *1 91.77,157.25
X$7064 \$2530 VIA_M1M2_PR
* cell instance $7065 r0 *1 91.77,158.61
X$7065 \$2530 VIA_M1M2_PR
* cell instance $7066 r0 *1 89.93,158.61
X$7066 \$2530 VIA_L1M1_PR_MR
* cell instance $7067 r0 *1 91.77,157.25
X$7067 \$2530 VIA_L1M1_PR_MR
* cell instance $7068 r0 *1 30.59,160.99
X$7068 \$2542 VIA_M1M2_PR
* cell instance $7069 r0 *1 30.59,159.29
X$7069 \$2542 VIA_M1M2_PR
* cell instance $7070 r0 *1 30.59,159.29
X$7070 \$2542 VIA_L1M1_PR_MR
* cell instance $7071 r0 *1 29.67,161.33
X$7071 \$2542 VIA_L1M1_PR_MR
* cell instance $7072 r0 *1 81.65,163.71
X$7072 \$2548 VIA_M1M2_PR
* cell instance $7073 r0 *1 81.65,162.69
X$7073 \$2548 VIA_M1M2_PR
* cell instance $7074 r0 *1 76.59,162.35
X$7074 \$2548 VIA_L1M1_PR_MR
* cell instance $7075 r0 *1 85.79,163.71
X$7075 \$2548 VIA_L1M1_PR_MR
* cell instance $7076 r0 *1 81.19,162.69
X$7076 \$2548 VIA_L1M1_PR_MR
* cell instance $7077 r0 *1 93.15,238.34
X$7077 clk VIA_M2M3_PR
* cell instance $7078 r0 *1 93.15,164.39
X$7078 clk VIA_M1M2_PR
* cell instance $7079 r0 *1 105.11,164.39
X$7079 clk VIA_L1M1_PR_MR
* cell instance $7080 r0 *1 182.39,173.06
X$7080 \$2566 VIA_M2M3_PR
* cell instance $7081 r0 *1 163.53,173.06
X$7081 \$2566 VIA_M2M3_PR
* cell instance $7082 r0 *1 171.81,173.06
X$7082 \$2566 VIA_M2M3_PR
* cell instance $7083 r0 *1 182.39,186.15
X$7083 \$2566 VIA_M1M2_PR
* cell instance $7084 r0 *1 171.81,166.77
X$7084 \$2566 VIA_M1M2_PR
* cell instance $7085 r0 *1 163.53,172.89
X$7085 \$2566 VIA_M1M2_PR
* cell instance $7086 r0 *1 184.23,186.15
X$7086 \$2566 VIA_L1M1_PR_MR
* cell instance $7087 r0 *1 163.53,172.89
X$7087 \$2566 VIA_L1M1_PR_MR
* cell instance $7088 r0 *1 171.81,166.77
X$7088 \$2566 VIA_L1M1_PR_MR
* cell instance $7089 r0 *1 169.51,167.11
X$7089 \$2566 VIA_L1M1_PR_MR
* cell instance $7090 r0 *1 169.97,165.41
X$7090 \$2567 VIA_M1M2_PR
* cell instance $7091 r0 *1 169.97,169.83
X$7091 \$2567 VIA_M1M2_PR
* cell instance $7092 r0 *1 169.97,172.55
X$7092 \$2567 VIA_M1M2_PR
* cell instance $7093 r0 *1 180.09,172.89
X$7093 \$2567 VIA_L1M1_PR_MR
* cell instance $7094 r0 *1 169.97,169.83
X$7094 \$2567 VIA_L1M1_PR_MR
* cell instance $7095 r0 *1 170.43,165.41
X$7095 \$2567 VIA_L1M1_PR_MR
* cell instance $7096 r0 *1 161.23,169.15
X$7096 \$2568 VIA_M1M2_PR
* cell instance $7097 r0 *1 161.23,188.87
X$7097 \$2568 VIA_M1M2_PR
* cell instance $7098 r0 *1 178.71,170.51
X$7098 \$2568 VIA_L1M1_PR_MR
* cell instance $7099 r0 *1 160.31,189.21
X$7099 \$2568 VIA_L1M1_PR_MR
* cell instance $7100 r0 *1 178.71,167.11
X$7100 \$2569 VIA_M1M2_PR
* cell instance $7101 r0 *1 178.71,169.49
X$7101 \$2569 VIA_M1M2_PR
* cell instance $7102 r0 *1 172.73,164.39
X$7102 \$2569 VIA_M1M2_PR
* cell instance $7103 r0 *1 172.73,167.45
X$7103 \$2569 VIA_M1M2_PR
* cell instance $7104 r0 *1 172.73,169.83
X$7104 \$2569 VIA_M1M2_PR
* cell instance $7105 r0 *1 172.73,175.95
X$7105 \$2569 VIA_M1M2_PR
* cell instance $7106 r0 *1 184.23,175.27
X$7106 \$2569 VIA_L1M1_PR_MR
* cell instance $7107 r0 *1 176.41,167.11
X$7107 \$2569 VIA_L1M1_PR_MR
* cell instance $7108 r0 *1 180.09,169.83
X$7108 \$2569 VIA_L1M1_PR_MR
* cell instance $7109 r0 *1 176.41,175.61
X$7109 \$2569 VIA_L1M1_PR_MR
* cell instance $7110 r0 *1 163.07,176.29
X$7110 \$2569 VIA_L1M1_PR_MR
* cell instance $7111 r0 *1 173.19,169.83
X$7111 \$2569 VIA_L1M1_PR_MR
* cell instance $7112 r0 *1 173.19,164.39
X$7112 \$2569 VIA_L1M1_PR_MR
* cell instance $7113 r0 *1 28.29,161.67
X$7113 \$2578 VIA_M1M2_PR
* cell instance $7114 r0 *1 28.29,156.91
X$7114 \$2578 VIA_M1M2_PR
* cell instance $7115 r0 *1 28.29,156.91
X$7115 \$2578 VIA_L1M1_PR_MR
* cell instance $7116 r0 *1 29.21,161.67
X$7116 \$2578 VIA_L1M1_PR_MR
* cell instance $7117 r0 *1 186.07,164.73
X$7117 \$2579 VIA_M1M2_PR
* cell instance $7118 r0 *1 186.07,177.65
X$7118 \$2579 VIA_M1M2_PR
* cell instance $7119 r0 *1 186.07,183.77
X$7119 \$2579 VIA_M1M2_PR
* cell instance $7120 r0 *1 186.53,177.65
X$7120 \$2579 VIA_L1M1_PR_MR
* cell instance $7121 r0 *1 186.07,183.77
X$7121 \$2579 VIA_L1M1_PR_MR
* cell instance $7122 r0 *1 174.11,164.73
X$7122 \$2579 VIA_L1M1_PR_MR
* cell instance $7123 r0 *1 186.99,169.15
X$7123 \$2587 VIA_M1M2_PR
* cell instance $7124 r0 *1 186.99,194.99
X$7124 \$2587 VIA_M1M2_PR
* cell instance $7125 r0 *1 176.87,169.15
X$7125 \$2587 VIA_L1M1_PR_MR
* cell instance $7126 r0 *1 185.15,194.65
X$7126 \$2587 VIA_L1M1_PR_MR
* cell instance $7127 r0 *1 175.95,169.49
X$7127 \$2588 VIA_M1M2_PR
* cell instance $7128 r0 *1 175.95,168.13
X$7128 \$2588 VIA_M1M2_PR
* cell instance $7129 r0 *1 178.25,169.49
X$7129 \$2588 VIA_L1M1_PR_MR
* cell instance $7130 r0 *1 175.95,168.13
X$7130 \$2588 VIA_L1M1_PR_MR
* cell instance $7131 r0 *1 181.47,178.67
X$7131 \$2592 VIA_M1M2_PR
* cell instance $7132 r0 *1 181.93,186.49
X$7132 \$2592 VIA_M1M2_PR
* cell instance $7133 r0 *1 181.93,191.59
X$7133 \$2592 VIA_M1M2_PR
* cell instance $7134 r0 *1 170.43,170.85
X$7134 \$2592 VIA_M1M2_PR
* cell instance $7135 r0 *1 170.43,164.39
X$7135 \$2592 VIA_M1M2_PR
* cell instance $7136 r0 *1 167.67,170.85
X$7136 \$2592 VIA_M1M2_PR
* cell instance $7137 r0 *1 167.67,177.99
X$7137 \$2592 VIA_M1M2_PR
* cell instance $7138 r0 *1 185.15,186.15
X$7138 \$2592 VIA_L1M1_PR_MR
* cell instance $7139 r0 *1 159.825,178.33
X$7139 \$2592 VIA_L1M1_PR_MR
* cell instance $7140 r0 *1 165.83,170.85
X$7140 \$2592 VIA_L1M1_PR_MR
* cell instance $7141 r0 *1 170.89,164.39
X$7141 \$2592 VIA_L1M1_PR_MR
* cell instance $7142 r0 *1 152.95,190.74
X$7142 \$2594 VIA_M2M3_PR
* cell instance $7143 r0 *1 169.51,190.74
X$7143 \$2594 VIA_M2M3_PR
* cell instance $7144 r0 *1 169.51,193.63
X$7144 \$2594 VIA_M1M2_PR
* cell instance $7145 r0 *1 169.51,183.09
X$7145 \$2594 VIA_M1M2_PR
* cell instance $7146 r0 *1 170.89,183.09
X$7146 \$2594 VIA_M1M2_PR
* cell instance $7147 r0 *1 170.89,167.45
X$7147 \$2594 VIA_M1M2_PR
* cell instance $7148 r0 *1 152.95,189.89
X$7148 \$2594 VIA_M1M2_PR
* cell instance $7149 r0 *1 152.49,189.89
X$7149 \$2594 VIA_L1M1_PR_MR
* cell instance $7150 r0 *1 171.35,193.63
X$7150 \$2594 VIA_L1M1_PR_MR
* cell instance $7151 r0 *1 169.97,167.45
X$7151 \$2594 VIA_L1M1_PR_MR
* cell instance $7152 r0 *1 169.51,164.39
X$7152 \$2596 VIA_M1M2_PR
* cell instance $7153 r0 *1 169.05,170.51
X$7153 \$2596 VIA_M1M2_PR
* cell instance $7154 r0 *1 169.05,177.31
X$7154 \$2596 VIA_M1M2_PR
* cell instance $7155 r0 *1 169.05,185.47
X$7155 \$2596 VIA_M1M2_PR
* cell instance $7156 r0 *1 169.05,185.47
X$7156 \$2596 VIA_L1M1_PR_MR
* cell instance $7157 r0 *1 160.77,178.33
X$7157 \$2596 VIA_L1M1_PR_MR
* cell instance $7158 r0 *1 170.89,170.17
X$7158 \$2596 VIA_L1M1_PR_MR
* cell instance $7159 r0 *1 169.97,164.39
X$7159 \$2596 VIA_L1M1_PR_MR
* cell instance $7160 r0 *1 169.05,168.13
X$7160 \$2600 VIA_M1M2_PR
* cell instance $7161 r0 *1 169.05,169.83
X$7161 \$2600 VIA_M1M2_PR
* cell instance $7162 r0 *1 168.13,169.83
X$7162 \$2600 VIA_L1M1_PR_MR
* cell instance $7163 r0 *1 169.05,169.83
X$7163 \$2600 VIA_L1M1_PR_MR
* cell instance $7164 r0 *1 172.27,168.13
X$7164 \$2600 VIA_L1M1_PR_MR
* cell instance $7165 r0 *1 78.43,162.69
X$7165 \$2602 VIA_M1M2_PR
* cell instance $7166 r0 *1 78.43,164.05
X$7166 \$2602 VIA_M1M2_PR
* cell instance $7167 r0 *1 78.43,164.05
X$7167 \$2602 VIA_L1M1_PR_MR
* cell instance $7168 r0 *1 79.35,162.69
X$7168 \$2602 VIA_L1M1_PR_MR
* cell instance $7169 r0 *1 172.73,183.26
X$7169 \$2639 VIA_M2M3_PR
* cell instance $7170 r0 *1 188.37,183.26
X$7170 \$2639 VIA_M2M3_PR
* cell instance $7171 r0 *1 172.73,183.09
X$7171 \$2639 VIA_M1M2_PR
* cell instance $7172 r0 *1 163.07,182.75
X$7172 \$2639 VIA_M1M2_PR
* cell instance $7173 r0 *1 188.37,186.15
X$7173 \$2639 VIA_M1M2_PR
* cell instance $7174 r0 *1 163.07,173.57
X$7174 \$2639 VIA_M1M2_PR
* cell instance $7175 r0 *1 163.07,172.89
X$7175 \$2639 VIA_M1M2_PR
* cell instance $7176 r0 *1 160.31,172.89
X$7176 \$2639 VIA_M1M2_PR
* cell instance $7177 r0 *1 160.31,177.31
X$7177 \$2639 VIA_M1M2_PR
* cell instance $7178 r0 *1 171.81,183.77
X$7178 \$2639 VIA_L1M1_PR_MR
* cell instance $7179 r0 *1 160.77,172.89
X$7179 \$2639 VIA_L1M1_PR_MR
* cell instance $7180 r0 *1 163.07,173.57
X$7180 \$2639 VIA_L1M1_PR_MR
* cell instance $7181 r0 *1 154.79,177.31
X$7181 \$2639 VIA_L1M1_PR_MR
* cell instance $7182 r0 *1 188.37,186.15
X$7182 \$2639 VIA_L1M1_PR_MR
* cell instance $7183 r0 *1 171.81,194.31
X$7183 \$2640 VIA_M1M2_PR
* cell instance $7184 r0 *1 171.35,177.31
X$7184 \$2640 VIA_M1M2_PR
* cell instance $7185 r0 *1 167.21,177.65
X$7185 \$2640 VIA_M1M2_PR
* cell instance $7186 r0 *1 167.21,174.93
X$7186 \$2640 VIA_M1M2_PR
* cell instance $7187 r0 *1 160.31,178.33
X$7187 \$2640 VIA_M1M2_PR
* cell instance $7188 r0 *1 160.77,175.27
X$7188 \$2640 VIA_M1M2_PR
* cell instance $7189 r0 *1 160.77,173.57
X$7189 \$2640 VIA_M1M2_PR
* cell instance $7190 r0 *1 171.81,194.31
X$7190 \$2640 VIA_L1M1_PR_MR
* cell instance $7191 r0 *1 160.77,173.57
X$7191 \$2640 VIA_L1M1_PR_MR
* cell instance $7192 r0 *1 160.31,178.33
X$7192 \$2640 VIA_L1M1_PR_MR
* cell instance $7193 r0 *1 160.77,175.27
X$7193 \$2640 VIA_L1M1_PR_MR
* cell instance $7194 r0 *1 166.73,177.65
X$7194 \$2640 VIA_L1M1_PR_MR
* cell instance $7195 r0 *1 184.23,189.38
X$7195 \$2646 VIA_M2M3_PR
* cell instance $7196 r0 *1 163.53,189.38
X$7196 \$2646 VIA_M2M3_PR
* cell instance $7197 r0 *1 184.23,187.17
X$7197 \$2646 VIA_M1M2_PR
* cell instance $7198 r0 *1 163.53,173.57
X$7198 \$2646 VIA_M1M2_PR
* cell instance $7199 r0 *1 184.23,187.17
X$7199 \$2646 VIA_L1M1_PR_MR
* cell instance $7200 r0 *1 161.69,173.23
X$7200 \$2646 VIA_L1M1_PR_MR
* cell instance $7201 r0 *1 166.29,185.81
X$7201 \$2648 VIA_M1M2_PR
* cell instance $7202 r0 *1 170.43,183.43
X$7202 \$2648 VIA_M1M2_PR
* cell instance $7203 r0 *1 166.29,178.33
X$7203 \$2648 VIA_M1M2_PR
* cell instance $7204 r0 *1 164.91,169.83
X$7204 \$2648 VIA_M1M2_PR
* cell instance $7205 r0 *1 157.55,188.53
X$7205 \$2648 VIA_M1M2_PR
* cell instance $7206 r0 *1 170.43,185.81
X$7206 \$2648 VIA_M1M2_PR
* cell instance $7207 r0 *1 157.55,185.81
X$7207 \$2648 VIA_M1M2_PR
* cell instance $7208 r0 *1 155.71,188.53
X$7208 \$2648 VIA_L1M1_PR_MR
* cell instance $7209 r0 *1 171.35,183.77
X$7209 \$2648 VIA_L1M1_PR_MR
* cell instance $7210 r0 *1 166.29,178.33
X$7210 \$2648 VIA_L1M1_PR_MR
* cell instance $7211 r0 *1 163.99,169.83
X$7211 \$2648 VIA_L1M1_PR_MR
* cell instance $7212 r0 *1 157.55,194.14
X$7212 \$2651 VIA_M2M3_PR
* cell instance $7213 r0 *1 177.33,194.14
X$7213 \$2651 VIA_M2M3_PR
* cell instance $7214 r0 *1 178.71,194.14
X$7214 \$2651 VIA_M2M3_PR
* cell instance $7215 r0 *1 178.25,175.27
X$7215 \$2651 VIA_M1M2_PR
* cell instance $7216 r0 *1 179.63,197.03
X$7216 \$2651 VIA_M1M2_PR
* cell instance $7217 r0 *1 177.33,197.03
X$7217 \$2651 VIA_M1M2_PR
* cell instance $7218 r0 *1 179.63,199.07
X$7218 \$2651 VIA_M1M2_PR
* cell instance $7219 r0 *1 178.71,186.83
X$7219 \$2651 VIA_M1M2_PR
* cell instance $7220 r0 *1 177.33,186.83
X$7220 \$2651 VIA_M1M2_PR
* cell instance $7221 r0 *1 178.71,188.87
X$7221 \$2651 VIA_M1M2_PR
* cell instance $7222 r0 *1 157.55,189.21
X$7222 \$2651 VIA_M1M2_PR
* cell instance $7223 r0 *1 157.55,194.31
X$7223 \$2651 VIA_M1M2_PR
* cell instance $7224 r0 *1 161.92,194.65
X$7224 \$2651 VIA_L1M1_PR_MR
* cell instance $7225 r0 *1 178.71,175.27
X$7225 \$2651 VIA_L1M1_PR_MR
* cell instance $7226 r0 *1 167.67,175.27
X$7226 \$2651 VIA_L1M1_PR_MR
* cell instance $7227 r0 *1 157.55,189.21
X$7227 \$2651 VIA_L1M1_PR_MR
* cell instance $7228 r0 *1 179.63,197.03
X$7228 \$2651 VIA_L1M1_PR_MR
* cell instance $7229 r0 *1 181.93,199.07
X$7229 \$2651 VIA_L1M1_PR_MR
* cell instance $7230 r0 *1 178.25,188.87
X$7230 \$2651 VIA_L1M1_PR_MR
* cell instance $7231 r0 *1 171.35,170.17
X$7231 \$2654 VIA_M1M2_PR
* cell instance $7232 r0 *1 171.35,172.89
X$7232 \$2654 VIA_M1M2_PR
* cell instance $7233 r0 *1 179.17,172.89
X$7233 \$2654 VIA_L1M1_PR_MR
* cell instance $7234 r0 *1 166.29,173.23
X$7234 \$2654 VIA_L1M1_PR_MR
* cell instance $7235 r0 *1 171.35,170.17
X$7235 \$2654 VIA_L1M1_PR_MR
* cell instance $7236 r0 *1 172.5,173.74
X$7236 \$2655 VIA_M3M4_PR
* cell instance $7237 r0 *1 172.5,193.46
X$7237 \$2655 VIA_M3M4_PR
* cell instance $7238 r0 *1 172.27,173.74
X$7238 \$2655 VIA_M2M3_PR
* cell instance $7239 r0 *1 174.11,193.46
X$7239 \$2655 VIA_M2M3_PR
* cell instance $7240 r0 *1 174.11,207.57
X$7240 \$2655 VIA_M1M2_PR
* cell instance $7241 r0 *1 172.27,173.57
X$7241 \$2655 VIA_M1M2_PR
* cell instance $7242 r0 *1 174.11,207.57
X$7242 \$2655 VIA_L1M1_PR_MR
* cell instance $7243 r0 *1 172.73,173.57
X$7243 \$2655 VIA_L1M1_PR_MR
* cell instance $7244 r0 *1 177.79,205.53
X$7244 \$2657 VIA_M1M2_PR
* cell instance $7245 r0 *1 174.57,193.63
X$7245 \$2657 VIA_M1M2_PR
* cell instance $7246 r0 *1 175.49,172.55
X$7246 \$2657 VIA_M1M2_PR
* cell instance $7247 r0 *1 174.57,186.83
X$7247 \$2657 VIA_M1M2_PR
* cell instance $7248 r0 *1 174.57,189.89
X$7248 \$2657 VIA_M1M2_PR
* cell instance $7249 r0 *1 176.87,193.63
X$7249 \$2657 VIA_M1M2_PR
* cell instance $7250 r0 *1 188.37,194.31
X$7250 \$2657 VIA_M1M2_PR
* cell instance $7251 r0 *1 188.37,191.59
X$7251 \$2657 VIA_M1M2_PR
* cell instance $7252 r0 *1 186.53,191.59
X$7252 \$2657 VIA_M1M2_PR
* cell instance $7253 r0 *1 186.53,189.55
X$7253 \$2657 VIA_M1M2_PR
* cell instance $7254 r0 *1 186.555,191.59
X$7254 \$2657 VIA_L1M1_PR_MR
* cell instance $7255 r0 *1 186.99,188.87
X$7255 \$2657 VIA_L1M1_PR_MR
* cell instance $7256 r0 *1 174.57,193.63
X$7256 \$2657 VIA_L1M1_PR_MR
* cell instance $7257 r0 *1 177.33,172.55
X$7257 \$2657 VIA_L1M1_PR_MR
* cell instance $7258 r0 *1 159.85,186.49
X$7258 \$2657 VIA_L1M1_PR_MR
* cell instance $7259 r0 *1 176.41,205.53
X$7259 \$2657 VIA_L1M1_PR_MR
* cell instance $7260 r0 *1 186.99,194.31
X$7260 \$2657 VIA_L1M1_PR_MR
* cell instance $7261 r0 *1 176.87,169.83
X$7261 \$2660 VIA_M1M2_PR
* cell instance $7262 r0 *1 177.79,180.03
X$7262 \$2660 VIA_M1M2_PR
* cell instance $7263 r0 *1 180.09,180.03
X$7263 \$2660 VIA_M1M2_PR
* cell instance $7264 r0 *1 183.31,196.35
X$7264 \$2660 VIA_M1M2_PR
* cell instance $7265 r0 *1 180.09,182.75
X$7265 \$2660 VIA_M1M2_PR
* cell instance $7266 r0 *1 183.31,183.09
X$7266 \$2660 VIA_M1M2_PR
* cell instance $7267 r0 *1 185.43,183.77
X$7267 \$2660 VIA_L1M1_PR_MR
* cell instance $7268 r0 *1 175.49,169.83
X$7268 \$2660 VIA_L1M1_PR_MR
* cell instance $7269 r0 *1 183.77,196.35
X$7269 \$2660 VIA_L1M1_PR_MR
* cell instance $7270 r0 *1 179.63,173.23
X$7270 \$2662 VIA_M1M2_PR
* cell instance $7271 r0 *1 178.71,182.75
X$7271 \$2662 VIA_M1M2_PR
* cell instance $7272 r0 *1 174.11,182.75
X$7272 \$2662 VIA_L1M1_PR_MR
* cell instance $7273 r0 *1 181.93,172.89
X$7273 \$2662 VIA_L1M1_PR_MR
* cell instance $7274 r0 *1 178.71,205.53
X$7274 \$2666 VIA_M1M2_PR
* cell instance $7275 r0 *1 159.85,204.51
X$7275 \$2666 VIA_M1M2_PR
* cell instance $7276 r0 *1 188.83,175.27
X$7276 \$2666 VIA_M1M2_PR
* cell instance $7277 r0 *1 178.71,202.81
X$7277 \$2666 VIA_M1M2_PR
* cell instance $7278 r0 *1 188.83,202.81
X$7278 \$2666 VIA_M1M2_PR
* cell instance $7279 r0 *1 159.39,189.21
X$7279 \$2666 VIA_M1M2_PR
* cell instance $7280 r0 *1 169.05,204.51
X$7280 \$2666 VIA_L1M1_PR_MR
* cell instance $7281 r0 *1 185.61,175.27
X$7281 \$2666 VIA_L1M1_PR_MR
* cell instance $7282 r0 *1 169.51,205.87
X$7282 \$2666 VIA_L1M1_PR_MR
* cell instance $7283 r0 *1 159.395,189.21
X$7283 \$2666 VIA_L1M1_PR_MR
* cell instance $7284 r0 *1 178.71,205.53
X$7284 \$2666 VIA_L1M1_PR_MR
* cell instance $7285 r0 *1 178.25,202.81
X$7285 \$2666 VIA_L1M1_PR_MR
* cell instance $7286 r0 *1 184.23,180.71
X$7286 \$2667 VIA_M1M2_PR
* cell instance $7287 r0 *1 184.23,175.95
X$7287 \$2667 VIA_M1M2_PR
* cell instance $7288 r0 *1 184.23,180.71
X$7288 \$2667 VIA_L1M1_PR_MR
* cell instance $7289 r0 *1 185.61,175.95
X$7289 \$2667 VIA_L1M1_PR_MR
* cell instance $7290 r0 *1 184.69,174.59
X$7290 \$2670 VIA_M1M2_PR
* cell instance $7291 r0 *1 184.69,177.99
X$7291 \$2670 VIA_M1M2_PR
* cell instance $7292 r0 *1 184.69,188.53
X$7292 \$2670 VIA_M1M2_PR
* cell instance $7293 r0 *1 184.69,177.99
X$7293 \$2670 VIA_L1M1_PR_MR
* cell instance $7294 r0 *1 182.39,188.87
X$7294 \$2670 VIA_L1M1_PR_MR
* cell instance $7295 r0 *1 163.115,174.59
X$7295 \$2670 VIA_L1M1_PR_MR
* cell instance $7296 r0 *1 163.99,187.34
X$7296 \$2679 VIA_M2M3_PR
* cell instance $7297 r0 *1 175.03,186.66
X$7297 \$2679 VIA_M2M3_PR
* cell instance $7298 r0 *1 175.03,175.27
X$7298 \$2679 VIA_M1M2_PR
* cell instance $7299 r0 *1 163.99,186.49
X$7299 \$2679 VIA_M1M2_PR
* cell instance $7300 r0 *1 175.49,186.49
X$7300 \$2679 VIA_M1M2_PR
* cell instance $7301 r0 *1 162.61,186.49
X$7301 \$2679 VIA_L1M1_PR_MR
* cell instance $7302 r0 *1 173.65,175.27
X$7302 \$2679 VIA_L1M1_PR_MR
* cell instance $7303 r0 *1 181.01,186.49
X$7303 \$2679 VIA_L1M1_PR_MR
* cell instance $7304 r0 *1 175.03,172.89
X$7304 \$2681 VIA_M1M2_PR_MR
* cell instance $7305 r0 *1 175.03,170.85
X$7305 \$2681 VIA_M1M2_PR
* cell instance $7306 r0 *1 172.27,170.85
X$7306 \$2681 VIA_L1M1_PR_MR
* cell instance $7307 r0 *1 168.82,203.66
X$7307 \$2687 VIA_M3M4_PR
* cell instance $7308 r0 *1 168.82,186.66
X$7308 \$2687 VIA_M3M4_PR
* cell instance $7309 r0 *1 169.97,186.66
X$7309 \$2687 VIA_M2M3_PR
* cell instance $7310 r0 *1 167.21,203.66
X$7310 \$2687 VIA_M2M3_PR
* cell instance $7311 r0 *1 167.21,213.01
X$7311 \$2687 VIA_M1M2_PR
* cell instance $7312 r0 *1 169.97,175.61
X$7312 \$2687 VIA_M1M2_PR
* cell instance $7313 r0 *1 167.21,213.01
X$7313 \$2687 VIA_L1M1_PR_MR
* cell instance $7314 r0 *1 170.43,175.61
X$7314 \$2687 VIA_L1M1_PR_MR
* cell instance $7315 r0 *1 168.59,170.17
X$7315 \$2689 VIA_L1M1_PR_MR
* cell instance $7316 r0 *1 170.43,170.17
X$7316 \$2689 VIA_L1M1_PR_MR
* cell instance $7317 r0 *1 164.45,172.55
X$7317 \$2691 VIA_L1M1_PR_MR
* cell instance $7318 r0 *1 168.13,172.55
X$7318 \$2691 VIA_L1M1_PR_MR
* cell instance $7319 r0 *1 166.29,175.61
X$7319 \$2694 VIA_L1M1_PR_MR
* cell instance $7320 r0 *1 160.31,175.61
X$7320 \$2694 VIA_L1M1_PR_MR
* cell instance $7321 r0 *1 165.37,172.89
X$7321 \$2697 VIA_M1M2_PR
* cell instance $7322 r0 *1 165.37,170.85
X$7322 \$2697 VIA_M1M2_PR
* cell instance $7323 r0 *1 158.93,170.17
X$7323 \$2697 VIA_M1M2_PR
* cell instance $7324 r0 *1 158.93,175.27
X$7324 \$2697 VIA_M1M2_PR
* cell instance $7325 r0 *1 158.93,175.27
X$7325 \$2697 VIA_L1M1_PR_MR
* cell instance $7326 r0 *1 163.53,170.85
X$7326 \$2697 VIA_L1M1_PR_MR
* cell instance $7327 r0 *1 165.83,172.89
X$7327 \$2697 VIA_L1M1_PR_MR
* cell instance $7328 r0 *1 162.15,170.17
X$7328 \$2697 VIA_L1M1_PR_MR
* cell instance $7329 r0 *1 162.61,187.17
X$7329 \$2702 VIA_M1M2_PR
* cell instance $7330 r0 *1 164.45,187.17
X$7330 \$2702 VIA_M1M2_PR
* cell instance $7331 r0 *1 163.99,189.21
X$7331 \$2702 VIA_M1M2_PR
* cell instance $7332 r0 *1 162.61,175.95
X$7332 \$2702 VIA_M1M2_PR
* cell instance $7333 r0 *1 162.61,189.21
X$7333 \$2702 VIA_L1M1_PR_MR
* cell instance $7334 r0 *1 163.99,175.95
X$7334 \$2702 VIA_L1M1_PR_MR
* cell instance $7335 r0 *1 159.39,175.61
X$7335 \$2705 VIA_M1M2_PR
* cell instance $7336 r0 *1 159.39,179.01
X$7336 \$2705 VIA_M1M2_PR
* cell instance $7337 r0 *1 159.39,183.43
X$7337 \$2705 VIA_M1M2_PR
* cell instance $7338 r0 *1 155.25,183.43
X$7338 \$2705 VIA_L1M1_PR_MR
* cell instance $7339 r0 *1 165.83,178.33
X$7339 \$2705 VIA_L1M1_PR_MR
* cell instance $7340 r0 *1 158.01,175.61
X$7340 \$2705 VIA_L1M1_PR_MR
* cell instance $7341 r0 *1 156.86,177.82
X$7341 O[1] VIA_M3M4_PR
* cell instance $7342 r0 *1 156.86,243.1
X$7342 O[1] VIA_M3M4_PR
* cell instance $7343 r0 *1 178.71,243.1
X$7343 O[1] VIA_M2M3_PR
* cell instance $7344 r0 *1 178.71,242.93
X$7344 O[1] VIA_M1M2_PR
* cell instance $7345 r0 *1 178.71,242.93
X$7345 O[1] VIA_L1M1_PR_MR
* cell instance $7346 r0 *1 168.13,188.87
X$7346 \$2728 VIA_M1M2_PR
* cell instance $7347 r0 *1 172.27,184.45
X$7347 \$2728 VIA_M1M2_PR
* cell instance $7348 r0 *1 168.13,195.33
X$7348 \$2728 VIA_M1M2_PR
* cell instance $7349 r0 *1 168.13,197.03
X$7349 \$2728 VIA_M1M2_PR
* cell instance $7350 r0 *1 168.13,186.49
X$7350 \$2728 VIA_M1M2_PR
* cell instance $7351 r0 *1 165.83,186.49
X$7351 \$2728 VIA_M1M2_PR
* cell instance $7352 r0 *1 168.13,191.59
X$7352 \$2728 VIA_M1M2_PR
* cell instance $7353 r0 *1 168.13,184.45
X$7353 \$2728 VIA_M1M2_PR
* cell instance $7354 r0 *1 172.73,181.05
X$7354 \$2728 VIA_M1M2_PR
* cell instance $7355 r0 *1 165.83,180.37
X$7355 \$2728 VIA_M1M2_PR
* cell instance $7356 r0 *1 158.47,180.37
X$7356 \$2728 VIA_M1M2_PR
* cell instance $7357 r0 *1 158.47,178.67
X$7357 \$2728 VIA_M1M2_PR
* cell instance $7358 r0 *1 168.13,191.59
X$7358 \$2728 VIA_L1M1_PR_MR
* cell instance $7359 r0 *1 168.13,197.03
X$7359 \$2728 VIA_L1M1_PR_MR
* cell instance $7360 r0 *1 167.21,188.87
X$7360 \$2728 VIA_L1M1_PR_MR
* cell instance $7361 r0 *1 177.33,181.05
X$7361 \$2728 VIA_L1M1_PR_MR
* cell instance $7362 r0 *1 160.77,180.37
X$7362 \$2728 VIA_L1M1_PR_MR
* cell instance $7363 r0 *1 157.55,178.67
X$7363 \$2728 VIA_L1M1_PR_MR
* cell instance $7364 r0 *1 183.31,194.65
X$7364 \$2728 VIA_L1M1_PR_MR
* cell instance $7365 r0 *1 175.03,183.77
X$7365 \$2728 VIA_L1M1_PR_MR
* cell instance $7366 r0 *1 177.33,179.86
X$7366 \$2732 VIA_M2M3_PR
* cell instance $7367 r0 *1 167.67,179.86
X$7367 \$2732 VIA_M2M3_PR
* cell instance $7368 r0 *1 179.17,181.05
X$7368 \$2732 VIA_M1M2_PR
* cell instance $7369 r0 *1 177.33,179.01
X$7369 \$2732 VIA_M1M2_PR
* cell instance $7370 r0 *1 167.67,185.47
X$7370 \$2732 VIA_M1M2_PR
* cell instance $7371 r0 *1 167.67,194.31
X$7371 \$2732 VIA_M1M2_PR
* cell instance $7372 r0 *1 182.85,180.37
X$7372 \$2732 VIA_M1M2_PR
* cell instance $7373 r0 *1 182.85,179.01
X$7373 \$2732 VIA_M1M2_PR
* cell instance $7374 r0 *1 178.71,186.15
X$7374 \$2732 VIA_M1M2_PR
* cell instance $7375 r0 *1 167.67,180.37
X$7375 \$2732 VIA_M1M2_PR
* cell instance $7376 r0 *1 166.75,194.65
X$7376 \$2732 VIA_L1M1_PR_MR
* cell instance $7377 r0 *1 182.39,180.71
X$7377 \$2732 VIA_L1M1_PR_MR
* cell instance $7378 r0 *1 186.555,180.71
X$7378 \$2732 VIA_L1M1_PR_MR
* cell instance $7379 r0 *1 181.47,186.15
X$7379 \$2732 VIA_L1M1_PR_MR
* cell instance $7380 r0 *1 177.79,179.01
X$7380 \$2732 VIA_L1M1_PR_MR
* cell instance $7381 r0 *1 166.29,180.71
X$7381 \$2732 VIA_L1M1_PR_MR
* cell instance $7382 r0 *1 156.63,186.15
X$7382 \$2732 VIA_L1M1_PR_MR
* cell instance $7383 r0 *1 173.42,179.18
X$7383 \$2736 VIA_M3M4_PR
* cell instance $7384 r0 *1 173.42,214.54
X$7384 \$2736 VIA_M3M4_PR
* cell instance $7385 r0 *1 173.19,179.18
X$7385 \$2736 VIA_M2M3_PR
* cell instance $7386 r0 *1 174.11,214.54
X$7386 \$2736 VIA_M2M3_PR
* cell instance $7387 r0 *1 174.11,216.41
X$7387 \$2736 VIA_M1M2_PR
* cell instance $7388 r0 *1 173.19,173.23
X$7388 \$2736 VIA_M1M2_PR
* cell instance $7389 r0 *1 174.11,216.41
X$7389 \$2736 VIA_L1M1_PR_MR
* cell instance $7390 r0 *1 173.19,173.23
X$7390 \$2736 VIA_L1M1_PR_MR
* cell instance $7391 r0 *1 179.17,178.5
X$7391 \$2741 VIA_M2M3_PR
* cell instance $7392 r0 *1 190.21,178.5
X$7392 \$2741 VIA_M2M3_PR
* cell instance $7393 r0 *1 190.21,211.31
X$7393 \$2741 VIA_M1M2_PR
* cell instance $7394 r0 *1 179.17,177.99
X$7394 \$2741 VIA_M1M2_PR
* cell instance $7395 r0 *1 179.17,177.99
X$7395 \$2741 VIA_L1M1_PR_MR
* cell instance $7396 r0 *1 175.95,211.31
X$7396 \$2741 VIA_L1M1_PR_MR
* cell instance $7397 r0 *1 175.49,180.71
X$7397 \$2743 VIA_L1M1_PR_MR
* cell instance $7398 r0 *1 187.45,180.03
X$7398 \$2743 VIA_L1M1_PR_MR
* cell instance $7399 r0 *1 186.53,188.7
X$7399 \$2748 VIA_M2M3_PR
* cell instance $7400 r0 *1 164.45,188.7
X$7400 \$2748 VIA_M2M3_PR
* cell instance $7401 r0 *1 164.45,188.87
X$7401 \$2748 VIA_M1M2_PR
* cell instance $7402 r0 *1 186.53,179.01
X$7402 \$2748 VIA_M1M2_PR
* cell instance $7403 r0 *1 163.07,188.87
X$7403 \$2748 VIA_L1M1_PR_MR
* cell instance $7404 r0 *1 186.99,179.01
X$7404 \$2748 VIA_L1M1_PR_MR
* cell instance $7405 r0 *1 163.53,192.1
X$7405 \$2752 VIA_M2M3_PR
* cell instance $7406 r0 *1 166.75,192.1
X$7406 \$2752 VIA_M2M3_PR
* cell instance $7407 r0 *1 168.59,192.1
X$7407 \$2752 VIA_M2M3_PR
* cell instance $7408 r0 *1 189.75,191.42
X$7408 \$2752 VIA_M2M3_PR
* cell instance $7409 r0 *1 177.33,191.42
X$7409 \$2752 VIA_M2M3_PR
* cell instance $7410 r0 *1 187.45,178.33
X$7410 \$2752 VIA_M1M2_PR
* cell instance $7411 r0 *1 168.59,199.75
X$7411 \$2752 VIA_M1M2_PR
* cell instance $7412 r0 *1 163.53,191.59
X$7412 \$2752 VIA_M1M2_PR
* cell instance $7413 r0 *1 166.75,188.53
X$7413 \$2752 VIA_M1M2_PR
* cell instance $7414 r0 *1 166.29,199.75
X$7414 \$2752 VIA_M1M2_PR
* cell instance $7415 r0 *1 166.29,202.13
X$7415 \$2752 VIA_M1M2_PR
* cell instance $7416 r0 *1 189.75,183.77
X$7416 \$2752 VIA_M1M2_PR
* cell instance $7417 r0 *1 187.45,183.77
X$7417 \$2752 VIA_M1M2_PR
* cell instance $7418 r0 *1 177.33,191.25
X$7418 \$2752 VIA_M1M2_PR
* cell instance $7419 r0 *1 150.65,186.15
X$7419 \$2752 VIA_M1M2_PR
* cell instance $7420 r0 *1 150.65,188.53
X$7420 \$2752 VIA_M1M2_PR
* cell instance $7421 r0 *1 165.37,202.47
X$7421 \$2752 VIA_L1M1_PR_MR
* cell instance $7422 r0 *1 163.53,191.59
X$7422 \$2752 VIA_L1M1_PR_MR
* cell instance $7423 r0 *1 150.65,186.15
X$7423 \$2752 VIA_L1M1_PR_MR
* cell instance $7424 r0 *1 182.85,178.33
X$7424 \$2752 VIA_L1M1_PR_MR
* cell instance $7425 r0 *1 168.59,199.75
X$7425 \$2752 VIA_L1M1_PR_MR
* cell instance $7426 r0 *1 161.69,188.87
X$7426 \$2752 VIA_L1M1_PR_MR
* cell instance $7427 r0 *1 177.33,191.25
X$7427 \$2752 VIA_L1M1_PR_MR
* cell instance $7428 r0 *1 187.22,183.77
X$7428 \$2752 VIA_L1M1_PR_MR
* cell instance $7429 r0 *1 181.47,173.23
X$7429 \$2754 VIA_M1M2_PR
* cell instance $7430 r0 *1 181.47,177.99
X$7430 \$2754 VIA_M1M2_PR
* cell instance $7431 r0 *1 181.47,177.99
X$7431 \$2754 VIA_L1M1_PR_MR
* cell instance $7432 r0 *1 181.47,173.23
X$7432 \$2754 VIA_L1M1_PR_MR
* cell instance $7433 r0 *1 164.45,183.09
X$7433 \$2762 VIA_M1M2_PR
* cell instance $7434 r0 *1 164.45,178.67
X$7434 \$2762 VIA_M1M2_PR
* cell instance $7435 r0 *1 170.43,178.67
X$7435 \$2762 VIA_L1M1_PR_MR
* cell instance $7436 r0 *1 158.47,183.09
X$7436 \$2762 VIA_L1M1_PR_MR
* cell instance $7437 r0 *1 168.59,183.77
X$7437 \$2768 VIA_M1M2_PR
* cell instance $7438 r0 *1 168.59,179.01
X$7438 \$2768 VIA_M1M2_PR
* cell instance $7439 r0 *1 168.13,179.01
X$7439 \$2768 VIA_L1M1_PR_MR
* cell instance $7440 r0 *1 161.69,178.33
X$7440 \$2773 VIA_M1M2_PR
* cell instance $7441 r0 *1 161.69,180.03
X$7441 \$2773 VIA_M1M2_PR
* cell instance $7442 r0 *1 161.69,178.33
X$7442 \$2773 VIA_L1M1_PR_MR
* cell instance $7443 r0 *1 155.71,180.03
X$7443 \$2773 VIA_L1M1_PR_MR
* cell instance $7444 r0 *1 155.25,191.59
X$7444 \$2775 VIA_M1M2_PR
* cell instance $7445 r0 *1 155.25,177.65
X$7445 \$2775 VIA_M1M2_PR
* cell instance $7446 r0 *1 154.79,191.59
X$7446 \$2775 VIA_L1M1_PR_MR
* cell instance $7447 r0 *1 158.93,177.65
X$7447 \$2775 VIA_L1M1_PR_MR
* cell instance $7448 r0 *1 114.77,184.45
X$7448 \$2793 VIA_M1M2_PR
* cell instance $7449 r0 *1 114.77,185.81
X$7449 \$2793 VIA_M1M2_PR
* cell instance $7450 r0 *1 115.69,184.11
X$7450 \$2793 VIA_L1M1_PR_MR
* cell instance $7451 r0 *1 114.77,185.81
X$7451 \$2793 VIA_L1M1_PR_MR
* cell instance $7452 r0 *1 153.41,185.81
X$7452 \$2810 VIA_M1M2_PR
* cell instance $7453 r0 *1 153.41,184.45
X$7453 \$2810 VIA_M1M2_PR
* cell instance $7454 r0 *1 157.55,184.11
X$7454 \$2810 VIA_L1M1_PR_MR
* cell instance $7455 r0 *1 149.73,185.81
X$7455 \$2810 VIA_L1M1_PR_MR
* cell instance $7456 r0 *1 181.93,175.27
X$7456 \$2813 VIA_M1M2_PR_MR
* cell instance $7457 r0 *1 181.93,183.94
X$7457 \$2813 VIA_M2M3_PR
* cell instance $7458 r0 *1 168.13,183.94
X$7458 \$2813 VIA_M2M3_PR
* cell instance $7459 r0 *1 168.13,183.43
X$7459 \$2813 VIA_M1M2_PR
* cell instance $7460 r0 *1 185.15,184.45
X$7460 \$2813 VIA_M1M2_PR
* cell instance $7461 r0 *1 181.93,182.75
X$7461 \$2813 VIA_M1M2_PR
* cell instance $7462 r0 *1 185.15,191.59
X$7462 \$2813 VIA_M1M2_PR
* cell instance $7463 r0 *1 160.31,190.91
X$7463 \$2813 VIA_M1M2_PR
* cell instance $7464 r0 *1 159.39,190.91
X$7464 \$2813 VIA_M1M2_PR
* cell instance $7465 r0 *1 159.39,184.11
X$7465 \$2813 VIA_M1M2_PR
* cell instance $7466 r0 *1 159.39,186.15
X$7466 \$2813 VIA_M1M2_PR
* cell instance $7467 r0 *1 159.39,191.59
X$7467 \$2813 VIA_M1M2_PR
* cell instance $7468 r0 *1 166.75,183.43
X$7468 \$2813 VIA_L1M1_PR_MR
* cell instance $7469 r0 *1 165.83,183.77
X$7469 \$2813 VIA_L1M1_PR_MR
* cell instance $7470 r0 *1 183.77,182.75
X$7470 \$2813 VIA_L1M1_PR_MR
* cell instance $7471 r0 *1 184.97,191.59
X$7471 \$2813 VIA_L1M1_PR_MR
* cell instance $7472 r0 *1 183.77,184.45
X$7472 \$2813 VIA_L1M1_PR_MR
* cell instance $7473 r0 *1 159.59,191.59
X$7473 \$2813 VIA_L1M1_PR_MR
* cell instance $7474 r0 *1 159.39,186.15
X$7474 \$2813 VIA_L1M1_PR_MR
* cell instance $7475 r0 *1 166.75,186.15
X$7475 \$2815 VIA_M1M2_PR
* cell instance $7476 r0 *1 185.61,181.39
X$7476 \$2815 VIA_M1M2_PR
* cell instance $7477 r0 *1 185.61,180.71
X$7477 \$2815 VIA_M1M2_PR
* cell instance $7478 r0 *1 185.61,189.21
X$7478 \$2815 VIA_M1M2_PR
* cell instance $7479 r0 *1 169.51,172.89
X$7479 \$2815 VIA_M1M2_PR
* cell instance $7480 r0 *1 169.51,181.73
X$7480 \$2815 VIA_M1M2_PR
* cell instance $7481 r0 *1 166.75,181.73
X$7481 \$2815 VIA_M1M2_PR
* cell instance $7482 r0 *1 166.75,186.15
X$7482 \$2815 VIA_L1M1_PR_MR
* cell instance $7483 r0 *1 185.61,180.71
X$7483 \$2815 VIA_L1M1_PR_MR
* cell instance $7484 r0 *1 168.59,181.73
X$7484 \$2815 VIA_L1M1_PR_MR
* cell instance $7485 r0 *1 169.51,172.89
X$7485 \$2815 VIA_L1M1_PR_MR
* cell instance $7486 r0 *1 171.58,185.98
X$7486 \$2816 VIA_M3M4_PR
* cell instance $7487 r0 *1 171.58,200.26
X$7487 \$2816 VIA_M3M4_PR
* cell instance $7488 r0 *1 170.89,185.98
X$7488 \$2816 VIA_M2M3_PR
* cell instance $7489 r0 *1 172.73,200.26
X$7489 \$2816 VIA_M2M3_PR
* cell instance $7490 r0 *1 172.73,210.97
X$7490 \$2816 VIA_M1M2_PR
* cell instance $7491 r0 *1 170.89,183.77
X$7491 \$2816 VIA_M1M2_PR
* cell instance $7492 r0 *1 170.89,183.77
X$7492 \$2816 VIA_L1M1_PR_MR
* cell instance $7493 r0 *1 172.73,210.97
X$7493 \$2816 VIA_L1M1_PR_MR
* cell instance $7494 r0 *1 176.41,185.98
X$7494 \$2827 VIA_M2M3_PR
* cell instance $7495 r0 *1 187.45,185.98
X$7495 \$2827 VIA_M2M3_PR
* cell instance $7496 r0 *1 187.45,190.91
X$7496 \$2827 VIA_M1M2_PR
* cell instance $7497 r0 *1 176.41,184.11
X$7497 \$2827 VIA_M1M2_PR
* cell instance $7498 r0 *1 176.41,184.11
X$7498 \$2827 VIA_L1M1_PR_MR
* cell instance $7499 r0 *1 187.45,190.91
X$7499 \$2827 VIA_L1M1_PR_MR
* cell instance $7500 r0 *1 180.55,192.61
X$7500 \$2834 VIA_M1M2_PR
* cell instance $7501 r0 *1 185.15,180.71
X$7501 \$2834 VIA_M1M2_PR
* cell instance $7502 r0 *1 180.55,191.25
X$7502 \$2834 VIA_M1M2_PR
* cell instance $7503 r0 *1 185.15,183.09
X$7503 \$2834 VIA_M1M2_PR
* cell instance $7504 r0 *1 186.07,184.45
X$7504 \$2834 VIA_M1M2_PR
* cell instance $7505 r0 *1 185.61,191.25
X$7505 \$2834 VIA_M1M2_PR
* cell instance $7506 r0 *1 155.71,185.81
X$7506 \$2834 VIA_M1M2_PR
* cell instance $7507 r0 *1 161.23,192.61
X$7507 \$2834 VIA_M1M2_PR
* cell instance $7508 r0 *1 155.71,193.97
X$7508 \$2834 VIA_M1M2_PR
* cell instance $7509 r0 *1 161.23,200.09
X$7509 \$2834 VIA_M1M2_PR
* cell instance $7510 r0 *1 161.23,193.97
X$7510 \$2834 VIA_M1M2_PR
* cell instance $7511 r0 *1 161.23,191.59
X$7511 \$2834 VIA_M1M2_PR
* cell instance $7512 r0 *1 163.07,200.09
X$7512 \$2834 VIA_L1M1_PR_MR
* cell instance $7513 r0 *1 163.71,194.65
X$7513 \$2834 VIA_L1M1_PR_MR
* cell instance $7514 r0 *1 155.71,185.81
X$7514 \$2834 VIA_L1M1_PR_MR
* cell instance $7515 r0 *1 155.71,193.97
X$7515 \$2834 VIA_L1M1_PR_MR
* cell instance $7516 r0 *1 184.97,180.71
X$7516 \$2834 VIA_L1M1_PR_MR
* cell instance $7517 r0 *1 185.61,191.25
X$7517 \$2834 VIA_L1M1_PR_MR
* cell instance $7518 r0 *1 184.69,183.77
X$7518 \$2834 VIA_L1M1_PR_MR
* cell instance $7519 r0 *1 161.69,191.59
X$7519 \$2834 VIA_L1M1_PR_MR
* cell instance $7520 r0 *1 122.13,189.21
X$7520 \$2851 VIA_M1M2_PR
* cell instance $7521 r0 *1 122.13,184.45
X$7521 \$2851 VIA_M1M2_PR
* cell instance $7522 r0 *1 121.67,187.17
X$7522 \$2851 VIA_M1M2_PR
* cell instance $7523 r0 *1 117.07,188.53
X$7523 \$2851 VIA_M1M2_PR
* cell instance $7524 r0 *1 118.45,187.17
X$7524 \$2851 VIA_M1M2_PR
* cell instance $7525 r0 *1 117.07,188.53
X$7525 \$2851 VIA_L1M1_PR_MR
* cell instance $7526 r0 *1 122.13,189.21
X$7526 \$2851 VIA_L1M1_PR_MR
* cell instance $7527 r0 *1 115.69,186.15
X$7527 \$2851 VIA_L1M1_PR_MR
* cell instance $7528 r0 *1 123.05,184.45
X$7528 \$2851 VIA_L1M1_PR_MR
* cell instance $7529 r0 *1 165.37,211.31
X$7529 \$2860 VIA_M1M2_PR
* cell instance $7530 r0 *1 165.37,184.45
X$7530 \$2860 VIA_M1M2_PR
* cell instance $7531 r0 *1 164.45,184.45
X$7531 \$2860 VIA_L1M1_PR_MR
* cell instance $7532 r0 *1 169.05,211.31
X$7532 \$2860 VIA_L1M1_PR_MR
* cell instance $7533 r0 *1 164.91,183.77
X$7533 \$2861 VIA_M1M2_PR
* cell instance $7534 r0 *1 164.91,194.99
X$7534 \$2861 VIA_M1M2_PR
* cell instance $7535 r0 *1 173.19,193.63
X$7535 \$2861 VIA_L1M1_PR_MR
* cell instance $7536 r0 *1 161.23,183.77
X$7536 \$2861 VIA_L1M1_PR_MR
* cell instance $7537 r0 *1 163.07,183.43
X$7537 \$2862 VIA_M1M2_PR
* cell instance $7538 r0 *1 163.07,191.25
X$7538 \$2862 VIA_M1M2_PR
* cell instance $7539 r0 *1 178.25,191.93
X$7539 \$2862 VIA_L1M1_PR_MR
* cell instance $7540 r0 *1 161.69,183.43
X$7540 \$2862 VIA_L1M1_PR_MR
* cell instance $7541 r0 *1 158.93,188.87
X$7541 \$2863 VIA_M1M2_PR
* cell instance $7542 r0 *1 158.93,180.71
X$7542 \$2863 VIA_M1M2_PR
* cell instance $7543 r0 *1 158.93,188.87
X$7543 \$2863 VIA_L1M1_PR_MR
* cell instance $7544 r0 *1 162.15,180.71
X$7544 \$2863 VIA_L1M1_PR_MR
* cell instance $7545 r0 *1 158.01,184.45
X$7545 \$2872 VIA_M1M2_PR
* cell instance $7546 r0 *1 158.01,202.13
X$7546 \$2872 VIA_M1M2_PR
* cell instance $7547 r0 *1 164.45,202.13
X$7547 \$2872 VIA_L1M1_PR_MR
* cell instance $7548 r0 *1 157.09,184.45
X$7548 \$2872 VIA_L1M1_PR_MR
* cell instance $7549 r0 *1 154.79,184.11
X$7549 \$2877 VIA_M1M2_PR
* cell instance $7550 r0 *1 154.79,185.47
X$7550 \$2877 VIA_M1M2_PR
* cell instance $7551 r0 *1 155.71,184.11
X$7551 \$2877 VIA_L1M1_PR_MR
* cell instance $7552 r0 *1 153.83,185.47
X$7552 \$2877 VIA_L1M1_PR_MR
* cell instance $7553 r0 *1 114.31,189.21
X$7553 \$2889 VIA_M1M2_PR
* cell instance $7554 r0 *1 114.31,191.25
X$7554 \$2889 VIA_M1M2_PR
* cell instance $7555 r0 *1 114.31,186.49
X$7555 \$2889 VIA_M1M2_PR
* cell instance $7556 r0 *1 116.61,191.59
X$7556 \$2889 VIA_L1M1_PR_MR
* cell instance $7557 r0 *1 121.67,188.53
X$7557 \$2889 VIA_L1M1_PR_MR
* cell instance $7558 r0 *1 114.31,186.49
X$7558 \$2889 VIA_L1M1_PR_MR
* cell instance $7559 r0 *1 125.35,191.25
X$7559 \$2895 VIA_M1M2_PR
* cell instance $7560 r0 *1 125.35,189.55
X$7560 \$2895 VIA_M1M2_PR
* cell instance $7561 r0 *1 125.35,187.17
X$7561 \$2895 VIA_M1M2_PR
* cell instance $7562 r0 *1 123.51,191.25
X$7562 \$2895 VIA_L1M1_PR_MR
* cell instance $7563 r0 *1 125.35,187.17
X$7563 \$2895 VIA_L1M1_PR_MR
* cell instance $7564 r0 *1 118.91,189.55
X$7564 \$2895 VIA_L1M1_PR_MR
* cell instance $7565 r0 *1 119.37,191.59
X$7565 \$2895 VIA_L1M1_PR_MR
* cell instance $7566 r0 *1 121.21,190.91
X$7566 \$2896 VIA_M1M2_PR
* cell instance $7567 r0 *1 121.67,189.21
X$7567 \$2896 VIA_M1M2_PR
* cell instance $7568 r0 *1 120.75,189.21
X$7568 \$2896 VIA_L1M1_PR_MR
* cell instance $7569 r0 *1 121.21,190.91
X$7569 \$2896 VIA_L1M1_PR_MR
* cell instance $7570 r0 *1 177.79,189.21
X$7570 \$2900 VIA_M1M2_PR_MR
* cell instance $7571 r0 *1 173.65,188.02
X$7571 \$2900 VIA_M2M3_PR
* cell instance $7572 r0 *1 165.83,188.02
X$7572 \$2900 VIA_M2M3_PR
* cell instance $7573 r0 *1 151.57,188.02
X$7573 \$2900 VIA_M2M3_PR
* cell instance $7574 r0 *1 173.65,189.21
X$7574 \$2900 VIA_M1M2_PR
* cell instance $7575 r0 *1 165.83,202.47
X$7575 \$2900 VIA_M1M2_PR
* cell instance $7576 r0 *1 177.79,186.15
X$7576 \$2900 VIA_M1M2_PR
* cell instance $7577 r0 *1 151.57,186.15
X$7577 \$2900 VIA_M1M2_PR
* cell instance $7578 r0 *1 165.83,202.47
X$7578 \$2900 VIA_L1M1_PR_MR
* cell instance $7579 r0 *1 151.57,186.15
X$7579 \$2900 VIA_L1M1_PR_MR
* cell instance $7580 r0 *1 178.25,186.15
X$7580 \$2900 VIA_L1M1_PR_MR
* cell instance $7581 r0 *1 163.07,192.27
X$7581 \$2904 VIA_M1M2_PR
* cell instance $7582 r0 *1 163.99,201.79
X$7582 \$2904 VIA_M1M2_PR
* cell instance $7583 r0 *1 153.87,191.59
X$7583 \$2904 VIA_L1M1_PR_MR
* cell instance $7584 r0 *1 169.05,202.13
X$7584 \$2904 VIA_L1M1_PR_MR
* cell instance $7585 r0 *1 156.63,191.25
X$7585 \$2904 VIA_L1M1_PR_MR
* cell instance $7586 r0 *1 157.55,192.27
X$7586 \$2904 VIA_L1M1_PR_MR
* cell instance $7587 r0 *1 160.77,203.49
X$7587 \$2906 VIA_M1M2_PR
* cell instance $7588 r0 *1 158.47,186.49
X$7588 \$2906 VIA_M1M2_PR
* cell instance $7589 r0 *1 160.77,188.19
X$7589 \$2906 VIA_M1M2_PR
* cell instance $7590 r0 *1 158.93,191.25
X$7590 \$2906 VIA_M1M2_PR
* cell instance $7591 r0 *1 160.77,186.15
X$7591 \$2906 VIA_M1M2_PR
* cell instance $7592 r0 *1 160.77,191.59
X$7592 \$2906 VIA_M1M2_PR
* cell instance $7593 r0 *1 164.45,186.15
X$7593 \$2906 VIA_L1M1_PR_MR
* cell instance $7594 r0 *1 162.61,191.59
X$7594 \$2906 VIA_L1M1_PR_MR
* cell instance $7595 r0 *1 154.765,186.15
X$7595 \$2906 VIA_L1M1_PR_MR
* cell instance $7596 r0 *1 171.81,202.81
X$7596 \$2906 VIA_L1M1_PR_MR
* cell instance $7597 r0 *1 160.77,191.59
X$7597 \$2906 VIA_L1M1_PR_MR
* cell instance $7598 r0 *1 175.95,188.19
X$7598 \$2906 VIA_L1M1_PR_MR
* cell instance $7599 r0 *1 156.63,184.45
X$7599 \$2907 VIA_M1M2_PR
* cell instance $7600 r0 *1 157.09,196.35
X$7600 \$2907 VIA_M1M2_PR
* cell instance $7601 r0 *1 157.09,195.33
X$7601 \$2907 VIA_M1M2_PR
* cell instance $7602 r0 *1 159.85,195.33
X$7602 \$2907 VIA_L1M1_PR_MR
* cell instance $7603 r0 *1 159.39,196.35
X$7603 \$2907 VIA_L1M1_PR_MR
* cell instance $7604 r0 *1 156.63,184.45
X$7604 \$2907 VIA_L1M1_PR_MR
* cell instance $7605 r0 *1 187.45,205.19
X$7605 \$2910 VIA_M1M2_PR
* cell instance $7606 r0 *1 161.69,204.85
X$7606 \$2910 VIA_M1M2_PR
* cell instance $7607 r0 *1 187.45,193.97
X$7607 \$2910 VIA_M1M2_PR
* cell instance $7608 r0 *1 161.69,189.55
X$7608 \$2910 VIA_M1M2_PR
* cell instance $7609 r0 *1 165.83,204.85
X$7609 \$2910 VIA_L1M1_PR_MR
* cell instance $7610 r0 *1 158.47,188.87
X$7610 \$2910 VIA_L1M1_PR_MR
* cell instance $7611 r0 *1 160.77,189.21
X$7611 \$2910 VIA_L1M1_PR_MR
* cell instance $7612 r0 *1 186.53,193.97
X$7612 \$2910 VIA_L1M1_PR_MR
* cell instance $7613 r0 *1 163.99,190.06
X$7613 \$2920 VIA_M2M3_PR
* cell instance $7614 r0 *1 169.97,190.06
X$7614 \$2920 VIA_M2M3_PR
* cell instance $7615 r0 *1 169.97,191.59
X$7615 \$2920 VIA_M1M2_PR
* cell instance $7616 r0 *1 163.99,189.89
X$7616 \$2920 VIA_M1M2_PR
* cell instance $7617 r0 *1 163.99,189.89
X$7617 \$2920 VIA_L1M1_PR_MR
* cell instance $7618 r0 *1 169.97,191.59
X$7618 \$2920 VIA_L1M1_PR_MR
* cell instance $7619 r0 *1 167.21,190.91
X$7619 \$2924 VIA_M1M2_PR
* cell instance $7620 r0 *1 166.75,197.03
X$7620 \$2924 VIA_M1M2_PR
* cell instance $7621 r0 *1 167.21,180.71
X$7621 \$2924 VIA_M1M2_PR
* cell instance $7622 r0 *1 166.29,197.03
X$7622 \$2924 VIA_L1M1_PR_MR
* cell instance $7623 r0 *1 167.67,190.91
X$7623 \$2924 VIA_L1M1_PR_MR
* cell instance $7624 r0 *1 167.21,180.71
X$7624 \$2924 VIA_L1M1_PR_MR
* cell instance $7625 r0 *1 182.85,181.05
X$7625 \$2955 VIA_M1M2_PR
* cell instance $7626 r0 *1 182.85,188.87
X$7626 \$2955 VIA_M1M2_PR
* cell instance $7627 r0 *1 182.85,181.05
X$7627 \$2955 VIA_L1M1_PR_MR
* cell instance $7628 r0 *1 182.85,188.87
X$7628 \$2955 VIA_L1M1_PR_MR
* cell instance $7629 r0 *1 174.11,186.15
X$7629 \$2972 VIA_L1M1_PR_MR
* cell instance $7630 r0 *1 175.03,186.15
X$7630 \$2972 VIA_L1M1_PR_MR
* cell instance $7631 r0 *1 117.99,186.49
X$7631 \$2974 VIA_M1M2_PR
* cell instance $7632 r0 *1 117.99,188.19
X$7632 \$2974 VIA_M1M2_PR
* cell instance $7633 r0 *1 117.99,186.49
X$7633 \$2974 VIA_L1M1_PR_MR
* cell instance $7634 r0 *1 119.83,188.19
X$7634 \$2974 VIA_L1M1_PR_MR
* cell instance $7635 r0 *1 171.81,175.27
X$7635 \$2981 VIA_M1M2_PR
* cell instance $7636 r0 *1 171.81,186.49
X$7636 \$2981 VIA_M1M2_PR
* cell instance $7637 r0 *1 168.59,186.49
X$7637 \$2981 VIA_L1M1_PR_MR
* cell instance $7638 r0 *1 171.81,175.27
X$7638 \$2981 VIA_L1M1_PR_MR
* cell instance $7639 r0 *1 166.29,189.21
X$7639 \$2988 VIA_M1M2_PR
* cell instance $7640 r0 *1 166.29,193.63
X$7640 \$2988 VIA_M1M2_PR
* cell instance $7641 r0 *1 158.01,193.63
X$7641 \$2988 VIA_L1M1_PR_MR
* cell instance $7642 r0 *1 169.05,189.21
X$7642 \$2988 VIA_L1M1_PR_MR
* cell instance $7643 r0 *1 171.35,193.46
X$7643 \$3042 VIA_M2M3_PR
* cell instance $7644 r0 *1 152.49,193.46
X$7644 \$3042 VIA_M2M3_PR
* cell instance $7645 r0 *1 171.35,194.65
X$7645 \$3042 VIA_M1M2_PR
* cell instance $7646 r0 *1 171.35,201.79
X$7646 \$3042 VIA_M1M2_PR
* cell instance $7647 r0 *1 152.49,184.45
X$7647 \$3042 VIA_M1M2_PR
* cell instance $7648 r0 *1 167.985,202.47
X$7648 \$3042 VIA_L1M1_PR_MR
* cell instance $7649 r0 *1 152.49,184.45
X$7649 \$3042 VIA_L1M1_PR_MR
* cell instance $7650 r0 *1 171.35,194.65
X$7650 \$3042 VIA_L1M1_PR_MR
* cell instance $7651 r0 *1 164.45,202.81
X$7651 \$3046 VIA_M1M2_PR
* cell instance $7652 r0 *1 164.45,191.93
X$7652 \$3046 VIA_M1M2_PR
* cell instance $7653 r0 *1 154.33,192.61
X$7653 \$3046 VIA_L1M1_PR_MR
* cell instance $7654 r0 *1 165.37,258.91
X$7654 \$3048 VIA_M1M2_PR
* cell instance $7655 r0 *1 164.91,205.53
X$7655 \$3048 VIA_M1M2_PR
* cell instance $7656 r0 *1 164.91,197.71
X$7656 \$3048 VIA_M1M2_PR
* cell instance $7657 r0 *1 158.47,194.65
X$7657 \$3048 VIA_M1M2_PR
* cell instance $7658 r0 *1 158.93,197.71
X$7658 \$3048 VIA_M1M2_PR
* cell instance $7659 r0 *1 157.09,194.65
X$7659 \$3048 VIA_L1M1_PR_MR
* cell instance $7660 r0 *1 159.85,197.71
X$7660 \$3048 VIA_L1M1_PR_MR
* cell instance $7661 r0 *1 166.75,205.53
X$7661 \$3048 VIA_L1M1_PR_MR
* cell instance $7662 r0 *1 169.97,205.19
X$7662 \$3048 VIA_L1M1_PR_MR
* cell instance $7663 r0 *1 172.73,258.91
X$7663 \$3048 VIA_L1M1_PR_MR
* cell instance $7664 r0 *1 167.67,195.33
X$7664 \$3052 VIA_M1M2_PR
* cell instance $7665 r0 *1 167.67,196.69
X$7665 \$3052 VIA_M1M2_PR
* cell instance $7666 r0 *1 161.23,195.33
X$7666 \$3052 VIA_L1M1_PR_MR
* cell instance $7667 r0 *1 169.51,196.69
X$7667 \$3052 VIA_L1M1_PR_MR
* cell instance $7668 r0 *1 174.57,205.53
X$7668 \$3056 VIA_M1M2_PR
* cell instance $7669 r0 *1 174.57,198.05
X$7669 \$3056 VIA_M1M2_PR
* cell instance $7670 r0 *1 169.97,200.09
X$7670 \$3056 VIA_M1M2_PR
* cell instance $7671 r0 *1 169.97,198.05
X$7671 \$3056 VIA_M1M2_PR
* cell instance $7672 r0 *1 162.61,199.75
X$7672 \$3056 VIA_M1M2_PR
* cell instance $7673 r0 *1 163.07,194.65
X$7673 \$3056 VIA_M1M2_PR
* cell instance $7674 r0 *1 177.79,192.27
X$7674 \$3056 VIA_M1M2_PR
* cell instance $7675 r0 *1 177.79,196.35
X$7675 \$3056 VIA_M1M2_PR
* cell instance $7676 r0 *1 164.45,200.09
X$7676 \$3056 VIA_L1M1_PR_MR
* cell instance $7677 r0 *1 163.07,194.65
X$7677 \$3056 VIA_L1M1_PR_MR
* cell instance $7678 r0 *1 182.39,191.93
X$7678 \$3056 VIA_L1M1_PR_MR
* cell instance $7679 r0 *1 176.87,196.35
X$7679 \$3056 VIA_L1M1_PR_MR
* cell instance $7680 r0 *1 176.87,198.05
X$7680 \$3056 VIA_L1M1_PR_MR
* cell instance $7681 r0 *1 173.65,204.85
X$7681 \$3060 VIA_M1M2_PR
* cell instance $7682 r0 *1 173.65,193.97
X$7682 \$3060 VIA_M1M2_PR
* cell instance $7683 r0 *1 164.45,194.65
X$7683 \$3060 VIA_L1M1_PR_MR
* cell instance $7684 r0 *1 177.79,204.85
X$7684 \$3060 VIA_L1M1_PR_MR
* cell instance $7685 r0 *1 167.21,203.15
X$7685 \$3062 VIA_M1M2_PR
* cell instance $7686 r0 *1 166.29,194.31
X$7686 \$3062 VIA_M1M2_PR
* cell instance $7687 r0 *1 166.29,194.31
X$7687 \$3062 VIA_L1M1_PR_MR
* cell instance $7688 r0 *1 167.21,203.15
X$7688 \$3062 VIA_L1M1_PR_MR
* cell instance $7689 r0 *1 171.81,205.19
X$7689 \$3065 VIA_M1M2_PR
* cell instance $7690 r0 *1 171.81,197.37
X$7690 \$3065 VIA_M1M2_PR
* cell instance $7691 r0 *1 167.21,197.03
X$7691 \$3065 VIA_L1M1_PR_MR
* cell instance $7692 r0 *1 171.81,205.19
X$7692 \$3065 VIA_L1M1_PR_MR
* cell instance $7693 r0 *1 179.17,197.37
X$7693 \$3065 VIA_L1M1_PR_MR
* cell instance $7694 r0 *1 169.74,223.38
X$7694 \$3066 VIA_M3M4_PR
* cell instance $7695 r0 *1 169.74,199.58
X$7695 \$3066 VIA_M3M4_PR
* cell instance $7696 r0 *1 167.21,223.38
X$7696 \$3066 VIA_M2M3_PR
* cell instance $7697 r0 *1 173.19,199.58
X$7697 \$3066 VIA_M2M3_PR
* cell instance $7698 r0 *1 122.59,224.57
X$7698 \$3066 VIA_M1M2_PR
* cell instance $7699 r0 *1 169.05,251.43
X$7699 \$3066 VIA_M1M2_PR
* cell instance $7700 r0 *1 167.21,243.27
X$7700 \$3066 VIA_M1M2_PR
* cell instance $7701 r0 *1 169.05,243.27
X$7701 \$3066 VIA_M1M2_PR
* cell instance $7702 r0 *1 167.21,223.55
X$7702 \$3066 VIA_M1M2_PR
* cell instance $7703 r0 *1 173.19,199.75
X$7703 \$3066 VIA_M1M2_PR
* cell instance $7704 r0 *1 122.59,213.69
X$7704 \$3066 VIA_M1M2_PR
* cell instance $7705 r0 *1 123.05,208.59
X$7705 \$3066 VIA_M1M2_PR
* cell instance $7706 r0 *1 123.05,205.53
X$7706 \$3066 VIA_M1M2_PR
* cell instance $7707 r0 *1 150.19,224.57
X$7707 \$3066 VIA_L1M1_PR_MR
* cell instance $7708 r0 *1 169.05,243.27
X$7708 \$3066 VIA_L1M1_PR_MR
* cell instance $7709 r0 *1 150.65,223.89
X$7709 \$3066 VIA_L1M1_PR_MR
* cell instance $7710 r0 *1 173.19,199.75
X$7710 \$3066 VIA_L1M1_PR_MR
* cell instance $7711 r0 *1 169.97,251.43
X$7711 \$3066 VIA_L1M1_PR_MR
* cell instance $7712 r0 *1 122.59,213.69
X$7712 \$3066 VIA_L1M1_PR_MR
* cell instance $7713 r0 *1 123.05,205.53
X$7713 \$3066 VIA_L1M1_PR_MR
* cell instance $7714 r0 *1 116.15,208.25
X$7714 \$3066 VIA_L1M1_PR_MR
* cell instance $7715 r0 *1 156.63,199.41
X$7715 \$3070 VIA_M1M2_PR
* cell instance $7716 r0 *1 156.63,189.55
X$7716 \$3070 VIA_M1M2_PR
* cell instance $7717 r0 *1 156.63,189.55
X$7717 \$3070 VIA_L1M1_PR_MR
* cell instance $7718 r0 *1 175.03,200.09
X$7718 \$3070 VIA_L1M1_PR_MR
* cell instance $7719 r0 *1 183.77,202.47
X$7719 \$3079 VIA_M1M2_PR
* cell instance $7720 r0 *1 183.77,197.37
X$7720 \$3079 VIA_M1M2_PR
* cell instance $7721 r0 *1 183.77,175.61
X$7721 \$3079 VIA_M1M2_PR
* cell instance $7722 r0 *1 183.77,175.61
X$7722 \$3079 VIA_L1M1_PR_MR
* cell instance $7723 r0 *1 184.69,197.37
X$7723 \$3079 VIA_L1M1_PR_MR
* cell instance $7724 r0 *1 181.01,202.47
X$7724 \$3079 VIA_L1M1_PR_MR
* cell instance $7725 r0 *1 186.53,196.35
X$7725 \$3080 VIA_M1M2_PR
* cell instance $7726 r0 *1 186.53,192.27
X$7726 \$3080 VIA_M1M2_PR
* cell instance $7727 r0 *1 184.23,191.59
X$7727 \$3080 VIA_L1M1_PR_MR
* cell instance $7728 r0 *1 186.53,196.35
X$7728 \$3080 VIA_L1M1_PR_MR
* cell instance $7729 r0 *1 187.91,184.45
X$7729 \$3084 VIA_M1M2_PR
* cell instance $7730 r0 *1 187.91,194.65
X$7730 \$3084 VIA_M1M2_PR
* cell instance $7731 r0 *1 185.61,194.65
X$7731 \$3084 VIA_L1M1_PR_MR
* cell instance $7732 r0 *1 187.91,184.45
X$7732 \$3084 VIA_L1M1_PR_MR
* cell instance $7733 r0 *1 181.93,194.31
X$7733 \$3100 VIA_L1M1_PR_MR
* cell instance $7734 r0 *1 184.23,194.31
X$7734 \$3100 VIA_L1M1_PR_MR
* cell instance $7735 r0 *1 181.47,200.77
X$7735 \$3101 VIA_M1M2_PR
* cell instance $7736 r0 *1 181.47,197.03
X$7736 \$3101 VIA_M1M2_PR
* cell instance $7737 r0 *1 181.47,202.13
X$7737 \$3101 VIA_M1M2_PR
* cell instance $7738 r0 *1 172.73,200.43
X$7738 \$3101 VIA_L1M1_PR_MR
* cell instance $7739 r0 *1 184.23,197.03
X$7739 \$3101 VIA_L1M1_PR_MR
* cell instance $7740 r0 *1 180.09,202.47
X$7740 \$3101 VIA_L1M1_PR_MR
* cell instance $7741 r0 *1 120.29,191.59
X$7741 \$3116 VIA_M1M2_PR
* cell instance $7742 r0 *1 120.29,194.31
X$7742 \$3116 VIA_M1M2_PR
* cell instance $7743 r0 *1 121.67,191.59
X$7743 \$3116 VIA_L1M1_PR_MR
* cell instance $7744 r0 *1 120.29,194.31
X$7744 \$3116 VIA_L1M1_PR_MR
* cell instance $7745 r0 *1 120.29,191.59
X$7745 \$3116 VIA_L1M1_PR_MR
* cell instance $7746 r0 *1 158.93,192.61
X$7746 \$3139 VIA_M1M2_PR
* cell instance $7747 r0 *1 158.93,194.65
X$7747 \$3139 VIA_M1M2_PR
* cell instance $7748 r0 *1 158.93,194.65
X$7748 \$3139 VIA_L1M1_PR_MR
* cell instance $7749 r0 *1 158.93,192.61
X$7749 \$3139 VIA_L1M1_PR_MR
* cell instance $7750 r0 *1 162.15,199.07
X$7750 \$3145 VIA_M1M2_PR
* cell instance $7751 r0 *1 162.15,189.21
X$7751 \$3145 VIA_M1M2_PR
* cell instance $7752 r0 *1 162.15,199.07
X$7752 \$3145 VIA_L1M1_PR_MR
* cell instance $7753 r0 *1 162.15,189.21
X$7753 \$3145 VIA_L1M1_PR_MR
* cell instance $7754 r0 *1 160.31,194.99
X$7754 \$3148 VIA_M1M2_PR
* cell instance $7755 r0 *1 160.31,196.69
X$7755 \$3148 VIA_M1M2_PR
* cell instance $7756 r0 *1 160.31,194.99
X$7756 \$3148 VIA_L1M1_PR_MR
* cell instance $7757 r0 *1 162.15,196.69
X$7757 \$3148 VIA_L1M1_PR_MR
* cell instance $7758 r0 *1 129.03,281.69
X$7758 \$3159 VIA_M1M2_PR
* cell instance $7759 r0 *1 129.03,265.37
X$7759 \$3159 VIA_M1M2_PR
* cell instance $7760 r0 *1 170.43,278.97
X$7760 \$3159 VIA_M1M2_PR
* cell instance $7761 r0 *1 170.43,281.35
X$7761 \$3159 VIA_M1M2_PR
* cell instance $7762 r0 *1 34.27,200.43
X$7762 \$3159 VIA_M1M2_PR
* cell instance $7763 r0 *1 34.27,203.49
X$7763 \$3159 VIA_M1M2_PR
* cell instance $7764 r0 *1 34.27,205.53
X$7764 \$3159 VIA_M1M2_PR
* cell instance $7765 r0 *1 34.27,265.37
X$7765 \$3159 VIA_M1M2_PR
* cell instance $7766 r0 *1 33.81,205.53
X$7766 \$3159 VIA_L1M1_PR_MR
* cell instance $7767 r0 *1 169.97,281.35
X$7767 \$3159 VIA_L1M1_PR_MR
* cell instance $7768 r0 *1 169.05,281.69
X$7768 \$3159 VIA_L1M1_PR_MR
* cell instance $7769 r0 *1 167.67,282.03
X$7769 \$3159 VIA_L1M1_PR_MR
* cell instance $7770 r0 *1 30.59,203.49
X$7770 \$3159 VIA_L1M1_PR_MR
* cell instance $7771 r0 *1 32.89,200.43
X$7771 \$3159 VIA_L1M1_PR_MR
* cell instance $7772 r0 *1 170.43,278.97
X$7772 \$3159 VIA_L1M1_PR_MR
* cell instance $7773 r0 *1 109.71,202.3
X$7773 \$3168 VIA_M2M3_PR
* cell instance $7774 r0 *1 117.99,202.3
X$7774 \$3168 VIA_M2M3_PR
* cell instance $7775 r0 *1 109.71,210.97
X$7775 \$3168 VIA_M1M2_PR
* cell instance $7776 r0 *1 124.89,207.23
X$7776 \$3168 VIA_M1M2_PR
* cell instance $7777 r0 *1 109.71,202.47
X$7777 \$3168 VIA_M1M2_PR
* cell instance $7778 r0 *1 117.99,202.47
X$7778 \$3168 VIA_M1M2_PR
* cell instance $7779 r0 *1 124.89,202.81
X$7779 \$3168 VIA_M1M2_PR
* cell instance $7780 r0 *1 117.99,202.47
X$7780 \$3168 VIA_L1M1_PR_MR
* cell instance $7781 r0 *1 110.17,202.47
X$7781 \$3168 VIA_L1M1_PR_MR
* cell instance $7782 r0 *1 124.89,207.23
X$7782 \$3168 VIA_L1M1_PR_MR
* cell instance $7783 r0 *1 109.71,210.97
X$7783 \$3168 VIA_L1M1_PR_MR
* cell instance $7784 r0 *1 116.61,203.15
X$7784 \$3172 VIA_L1M1_PR_MR
* cell instance $7785 r0 *1 111.55,202.81
X$7785 \$3172 VIA_L1M1_PR_MR
* cell instance $7786 r0 *1 111.55,202.13
X$7786 \$3173 VIA_M1M2_PR
* cell instance $7787 r0 *1 111.55,200.77
X$7787 \$3173 VIA_M1M2_PR
* cell instance $7788 r0 *1 117.53,202.47
X$7788 \$3173 VIA_L1M1_PR_MR
* cell instance $7789 r0 *1 111.55,200.77
X$7789 \$3173 VIA_L1M1_PR_MR
* cell instance $7790 r0 *1 110.63,202.47
X$7790 \$3173 VIA_L1M1_PR_MR
* cell instance $7791 r0 *1 112.47,200.43
X$7791 \$3174 VIA_M1M2_PR
* cell instance $7792 r0 *1 112.47,201.79
X$7792 \$3174 VIA_M1M2_PR
* cell instance $7793 r0 *1 117.53,200.43
X$7793 \$3174 VIA_M1M2_PR
* cell instance $7794 r0 *1 117.53,201.79
X$7794 \$3174 VIA_M1M2_PR
* cell instance $7795 r0 *1 117.53,200.43
X$7795 \$3174 VIA_L1M1_PR_MR
* cell instance $7796 r0 *1 114.31,202.13
X$7796 \$3174 VIA_L1M1_PR_MR
* cell instance $7797 r0 *1 112.01,200.09
X$7797 \$3174 VIA_L1M1_PR_MR
* cell instance $7798 r0 *1 114.77,200.77
X$7798 \$3175 VIA_M1M2_PR
* cell instance $7799 r0 *1 114.77,202.47
X$7799 \$3175 VIA_M1M2_PR
* cell instance $7800 r0 *1 114.77,200.77
X$7800 \$3175 VIA_L1M1_PR_MR
* cell instance $7801 r0 *1 115.23,202.47
X$7801 \$3175 VIA_L1M1_PR_MR
* cell instance $7802 r0 *1 112.93,200.09
X$7802 \$3175 VIA_L1M1_PR_MR
* cell instance $7803 r0 *1 114.77,203.49
X$7803 \$3176 VIA_M1M2_PR
* cell instance $7804 r0 *1 117.99,203.49
X$7804 \$3176 VIA_M1M2_PR
* cell instance $7805 r0 *1 117.99,207.57
X$7805 \$3176 VIA_M1M2_PR
* cell instance $7806 r0 *1 113.85,202.47
X$7806 \$3176 VIA_M1M2_PR
* cell instance $7807 r0 *1 112.47,202.47
X$7807 \$3176 VIA_L1M1_PR_MR
* cell instance $7808 r0 *1 117.53,207.57
X$7808 \$3176 VIA_L1M1_PR_MR
* cell instance $7809 r0 *1 115.23,204.51
X$7809 \$3178 VIA_M1M2_PR
* cell instance $7810 r0 *1 112.01,206.21
X$7810 \$3178 VIA_M1M2_PR
* cell instance $7811 r0 *1 112.01,207.91
X$7811 \$3178 VIA_M1M2_PR
* cell instance $7812 r0 *1 115.69,202.47
X$7812 \$3178 VIA_M1M2_PR
* cell instance $7813 r0 *1 115.69,202.47
X$7813 \$3178 VIA_L1M1_PR_MR
* cell instance $7814 r0 *1 118.91,202.47
X$7814 \$3178 VIA_L1M1_PR_MR
* cell instance $7815 r0 *1 109.25,207.91
X$7815 \$3178 VIA_L1M1_PR_MR
* cell instance $7816 r0 *1 114.31,206.21
X$7816 \$3178 VIA_L1M1_PR_MR
* cell instance $7817 r0 *1 114.31,204.51
X$7817 \$3178 VIA_L1M1_PR_MR
* cell instance $7818 r0 *1 183.31,204.34
X$7818 O[0] VIA_M2M3_PR
* cell instance $7819 r0 *1 183.31,245.99
X$7819 O[0] VIA_M1M2_PR
* cell instance $7820 r0 *1 180.55,245.99
X$7820 O[0] VIA_L1M1_PR_MR
* cell instance $7821 r0 *1 185.61,201.79
X$7821 \$3212 VIA_M1M2_PR
* cell instance $7822 r0 *1 185.61,197.37
X$7822 \$3212 VIA_M1M2_PR
* cell instance $7823 r0 *1 180.09,201.79
X$7823 \$3212 VIA_L1M1_PR_MR
* cell instance $7824 r0 *1 185.61,197.37
X$7824 \$3212 VIA_L1M1_PR_MR
* cell instance $7825 r0 *1 37.95,202.81
X$7825 \$3217 VIA_M1M2_PR
* cell instance $7826 r0 *1 37.95,204.85
X$7826 \$3217 VIA_M1M2_PR
* cell instance $7827 r0 *1 31.05,204.85
X$7827 \$3217 VIA_L1M1_PR_MR
* cell instance $7828 r0 *1 37.95,202.81
X$7828 \$3217 VIA_L1M1_PR_MR
* cell instance $7829 r0 *1 175.03,213.01
X$7829 \$3227 VIA_M1M2_PR
* cell instance $7830 r0 *1 175.03,202.81
X$7830 \$3227 VIA_M1M2_PR
* cell instance $7831 r0 *1 175.03,213.01
X$7831 \$3227 VIA_L1M1_PR_MR
* cell instance $7832 r0 *1 175.49,202.81
X$7832 \$3227 VIA_L1M1_PR_MR
* cell instance $7833 r0 *1 178.25,205.53
X$7833 \$3229 VIA_M1M2_PR
* cell instance $7834 r0 *1 178.25,181.05
X$7834 \$3229 VIA_M1M2_PR
* cell instance $7835 r0 *1 178.25,181.05
X$7835 \$3229 VIA_L1M1_PR_MR
* cell instance $7836 r0 *1 178.25,205.53
X$7836 \$3229 VIA_L1M1_PR_MR
* cell instance $7837 r0 *1 108.33,207.91
X$7837 \$3248 VIA_M1M2_PR
* cell instance $7838 r0 *1 108.33,203.49
X$7838 \$3248 VIA_M1M2_PR
* cell instance $7839 r0 *1 108.33,209.95
X$7839 \$3248 VIA_M1M2_PR
* cell instance $7840 r0 *1 109.25,209.95
X$7840 \$3248 VIA_L1M1_PR_MR
* cell instance $7841 r0 *1 108.33,207.91
X$7841 \$3248 VIA_L1M1_PR_MR
* cell instance $7842 r0 *1 114.31,203.49
X$7842 \$3248 VIA_L1M1_PR_MR
* cell instance $7843 r0 *1 116.15,210.63
X$7843 \$3250 VIA_M1M2_PR
* cell instance $7844 r0 *1 113.85,230.01
X$7844 \$3250 VIA_M1M2_PR
* cell instance $7845 r0 *1 113.85,216.41
X$7845 \$3250 VIA_M1M2_PR
* cell instance $7846 r0 *1 113.85,240.89
X$7846 \$3250 VIA_M1M2_PR
* cell instance $7847 r0 *1 113.85,232.73
X$7847 \$3250 VIA_M1M2_PR
* cell instance $7848 r0 *1 112.01,219.81
X$7848 \$3250 VIA_M1M2_PR
* cell instance $7849 r0 *1 115.69,214.03
X$7849 \$3250 VIA_M1M2_PR
* cell instance $7850 r0 *1 113.85,214.03
X$7850 \$3250 VIA_M1M2_PR
* cell instance $7851 r0 *1 112.01,229.33
X$7851 \$3250 VIA_M1M2_PR
* cell instance $7852 r0 *1 113.85,219.81
X$7852 \$3250 VIA_M1M2_PR
* cell instance $7853 r0 *1 113.39,205.87
X$7853 \$3250 VIA_M1M2_PR
* cell instance $7854 r0 *1 113.39,207.57
X$7854 \$3250 VIA_M1M2_PR
* cell instance $7855 r0 *1 111.55,207.57
X$7855 \$3250 VIA_L1M1_PR_MR
* cell instance $7856 r0 *1 112.47,205.87
X$7856 \$3250 VIA_L1M1_PR_MR
* cell instance $7857 r0 *1 116.61,219.13
X$7857 \$3250 VIA_L1M1_PR_MR
* cell instance $7858 r0 *1 114.31,216.41
X$7858 \$3250 VIA_L1M1_PR_MR
* cell instance $7859 r0 *1 116.185,210.63
X$7859 \$3250 VIA_L1M1_PR_MR
* cell instance $7860 r0 *1 116.15,240.89
X$7860 \$3250 VIA_L1M1_PR_MR
* cell instance $7861 r0 *1 113.85,232.73
X$7861 \$3250 VIA_L1M1_PR_MR
* cell instance $7862 r0 *1 116.15,230.01
X$7862 \$3250 VIA_L1M1_PR_MR
* cell instance $7863 r0 *1 119.83,203.49
X$7863 \$3264 VIA_M1M2_PR
* cell instance $7864 r0 *1 119.83,205.19
X$7864 \$3264 VIA_M1M2_PR
* cell instance $7865 r0 *1 119.83,203.49
X$7865 \$3264 VIA_L1M1_PR_MR
* cell instance $7866 r0 *1 121.67,205.19
X$7866 \$3264 VIA_L1M1_PR_MR
* cell instance $7867 r0 *1 110.17,210.29
X$7867 \$3284 VIA_M1M2_PR
* cell instance $7868 r0 *1 110.17,213.01
X$7868 \$3284 VIA_M1M2_PR
* cell instance $7869 r0 *1 110.63,210.29
X$7869 \$3284 VIA_L1M1_PR_MR
* cell instance $7870 r0 *1 110.17,213.01
X$7870 \$3284 VIA_L1M1_PR_MR
* cell instance $7871 r0 *1 114.31,210.29
X$7871 \$3284 VIA_L1M1_PR_MR
* cell instance $7872 r0 *1 111.55,211.14
X$7872 \$3285 VIA_M2M3_PR
* cell instance $7873 r0 *1 125.35,211.14
X$7873 \$3285 VIA_M2M3_PR
* cell instance $7874 r0 *1 125.35,212.67
X$7874 \$3285 VIA_M1M2_PR
* cell instance $7875 r0 *1 111.55,210.97
X$7875 \$3285 VIA_M1M2_PR
* cell instance $7876 r0 *1 111.55,210.97
X$7876 \$3285 VIA_L1M1_PR_MR
* cell instance $7877 r0 *1 125.35,212.67
X$7877 \$3285 VIA_L1M1_PR_MR
* cell instance $7878 r0 *1 123.97,213.35
X$7878 \$3292 VIA_M1M2_PR
* cell instance $7879 r0 *1 119.37,207.23
X$7879 \$3292 VIA_M1M2_PR
* cell instance $7880 r0 *1 119.37,209.95
X$7880 \$3292 VIA_M1M2_PR
* cell instance $7881 r0 *1 123.97,209.95
X$7881 \$3292 VIA_M1M2_PR
* cell instance $7882 r0 *1 114.77,207.23
X$7882 \$3292 VIA_L1M1_PR_MR
* cell instance $7883 r0 *1 123.97,213.35
X$7883 \$3292 VIA_L1M1_PR_MR
* cell instance $7884 r0 *1 115.69,210.97
X$7884 \$3292 VIA_L1M1_PR_MR
* cell instance $7885 r0 *1 178.25,207.91
X$7885 \$3301 VIA_M1M2_PR
* cell instance $7886 r0 *1 178.25,210.97
X$7886 \$3301 VIA_M1M2_PR
* cell instance $7887 r0 *1 178.25,209.95
X$7887 \$3301 VIA_M1M2_PR
* cell instance $7888 r0 *1 176.41,213.35
X$7888 \$3301 VIA_M1M2_PR
* cell instance $7889 r0 *1 181.47,209.95
X$7889 \$3301 VIA_M1M2_PR
* cell instance $7890 r0 *1 181.47,208.93
X$7890 \$3301 VIA_M1M2_PR
* cell instance $7891 r0 *1 176.41,210.97
X$7891 \$3301 VIA_M1M2_PR
* cell instance $7892 r0 *1 171.81,210.97
X$7892 \$3301 VIA_M1M2_PR
* cell instance $7893 r0 *1 171.81,207.91
X$7893 \$3301 VIA_M1M2_PR
* cell instance $7894 r0 *1 171.81,212.67
X$7894 \$3301 VIA_M1M2_PR
* cell instance $7895 r0 *1 181.01,214.37
X$7895 \$3301 VIA_M1M2_PR
* cell instance $7896 r0 *1 181.01,215.39
X$7896 \$3301 VIA_M1M2_PR
* cell instance $7897 r0 *1 167.67,210.97
X$7897 \$3301 VIA_M1M2_PR
* cell instance $7898 r0 *1 166.75,215.39
X$7898 \$3301 VIA_M1M2_PR
* cell instance $7899 r0 *1 166.75,210.97
X$7899 \$3301 VIA_M1M2_PR
* cell instance $7900 r0 *1 166.75,213.35
X$7900 \$3301 VIA_M1M2_PR
* cell instance $7901 r0 *1 163.53,209.95
X$7901 \$3301 VIA_M1M2_PR
* cell instance $7902 r0 *1 163.53,213.35
X$7902 \$3301 VIA_M1M2_PR
* cell instance $7903 r0 *1 166.75,209.95
X$7903 \$3301 VIA_M1M2_PR
* cell instance $7904 r0 *1 167.67,208.59
X$7904 \$3301 VIA_M1M2_PR
* cell instance $7905 r0 *1 172.01,210.97
X$7905 \$3301 VIA_L1M1_PR_MR
* cell instance $7906 r0 *1 171.15,207.91
X$7906 \$3301 VIA_L1M1_PR_MR
* cell instance $7907 r0 *1 166.29,215.39
X$7907 \$3301 VIA_L1M1_PR_MR
* cell instance $7908 r0 *1 163.53,213.35
X$7908 \$3301 VIA_L1M1_PR_MR
* cell instance $7909 r0 *1 167.21,208.93
X$7909 \$3301 VIA_L1M1_PR_MR
* cell instance $7910 r0 *1 171.81,212.67
X$7910 \$3301 VIA_L1M1_PR_MR
* cell instance $7911 r0 *1 166.725,213.35
X$7911 \$3301 VIA_L1M1_PR_MR
* cell instance $7912 r0 *1 168.33,210.97
X$7912 \$3301 VIA_L1M1_PR_MR
* cell instance $7913 r0 *1 164.45,209.95
X$7913 \$3301 VIA_L1M1_PR_MR
* cell instance $7914 r0 *1 174.83,207.91
X$7914 \$3301 VIA_L1M1_PR_MR
* cell instance $7915 r0 *1 174.83,216.41
X$7915 \$3301 VIA_L1M1_PR_MR
* cell instance $7916 r0 *1 176.67,210.97
X$7916 \$3301 VIA_L1M1_PR_MR
* cell instance $7917 r0 *1 180.55,208.93
X$7917 \$3301 VIA_L1M1_PR_MR
* cell instance $7918 r0 *1 180.55,209.95
X$7918 \$3301 VIA_L1M1_PR_MR
* cell instance $7919 r0 *1 175.75,213.35
X$7919 \$3301 VIA_L1M1_PR_MR
* cell instance $7920 r0 *1 181.01,215.39
X$7920 \$3301 VIA_L1M1_PR_MR
* cell instance $7921 r0 *1 181.01,214.37
X$7921 \$3301 VIA_L1M1_PR_MR
* cell instance $7922 r0 *1 179.17,214.37
X$7922 \$3301 VIA_L1M1_PR_MR
* cell instance $7923 r0 *1 178.25,213.35
X$7923 \$3303 VIA_M1M2_PR
* cell instance $7924 r0 *1 180.09,213.35
X$7924 \$3303 VIA_M1M2_PR
* cell instance $7925 r0 *1 181.93,210.97
X$7925 \$3303 VIA_M1M2_PR
* cell instance $7926 r0 *1 181.93,213.69
X$7926 \$3303 VIA_M1M2_PR
* cell instance $7927 r0 *1 181.93,207.91
X$7927 \$3303 VIA_M1M2_PR
* cell instance $7928 r0 *1 180.09,216.41
X$7928 \$3303 VIA_M1M2_PR
* cell instance $7929 r0 *1 178.25,214.03
X$7929 \$3303 VIA_M1M2_PR
* cell instance $7930 r0 *1 165.37,214.03
X$7930 \$3303 VIA_M1M2_PR
* cell instance $7931 r0 *1 165.37,216.41
X$7931 \$3303 VIA_M1M2_PR
* cell instance $7932 r0 *1 165.37,218.11
X$7932 \$3303 VIA_M1M2_PR
* cell instance $7933 r0 *1 164.91,210.97
X$7933 \$3303 VIA_M1M2_PR
* cell instance $7934 r0 *1 165.37,213.35
X$7934 \$3303 VIA_M1M2_PR
* cell instance $7935 r0 *1 164.91,207.91
X$7935 \$3303 VIA_M1M2_PR
* cell instance $7936 r0 *1 164.45,210.97
X$7936 \$3303 VIA_L1M1_PR_MR
* cell instance $7937 r0 *1 164.45,213.35
X$7937 \$3303 VIA_L1M1_PR_MR
* cell instance $7938 r0 *1 166.29,207.91
X$7938 \$3303 VIA_L1M1_PR_MR
* cell instance $7939 r0 *1 165.37,218.11
X$7939 \$3303 VIA_L1M1_PR_MR
* cell instance $7940 r0 *1 165.37,216.41
X$7940 \$3303 VIA_L1M1_PR_MR
* cell instance $7941 r0 *1 178.25,213.35
X$7941 \$3303 VIA_L1M1_PR_MR
* cell instance $7942 r0 *1 180.55,207.91
X$7942 \$3303 VIA_L1M1_PR_MR
* cell instance $7943 r0 *1 180.09,216.41
X$7943 \$3303 VIA_L1M1_PR_MR
* cell instance $7944 r0 *1 180.55,210.97
X$7944 \$3303 VIA_L1M1_PR_MR
* cell instance $7945 r0 *1 181.01,213.35
X$7945 \$3303 VIA_L1M1_PR_MR
* cell instance $7946 r0 *1 169.05,208.93
X$7946 \$3310 VIA_M1M2_PR
* cell instance $7947 r0 *1 169.51,222.53
X$7947 \$3310 VIA_M1M2_PR
* cell instance $7948 r0 *1 169.51,223.55
X$7948 \$3310 VIA_M1M2_PR
* cell instance $7949 r0 *1 167.21,222.53
X$7949 \$3310 VIA_M1M2_PR
* cell instance $7950 r0 *1 168.59,224.23
X$7950 \$3310 VIA_L1M1_PR_MR
* cell instance $7951 r0 *1 178.71,207.23
X$7951 \$3310 VIA_L1M1_PR_MR
* cell instance $7952 r0 *1 169.97,211.31
X$7952 \$3311 VIA_M1M2_PR
* cell instance $7953 r0 *1 169.97,213.69
X$7953 \$3311 VIA_M1M2_PR
* cell instance $7954 r0 *1 174.11,213.35
X$7954 \$3311 VIA_M1M2_PR
* cell instance $7955 r0 *1 169.97,207.91
X$7955 \$3311 VIA_M1M2_PR
* cell instance $7956 r0 *1 173.65,216.75
X$7956 \$3311 VIA_M1M2_PR
* cell instance $7957 r0 *1 169.51,216.75
X$7957 \$3311 VIA_L1M1_PR_MR
* cell instance $7958 r0 *1 173.65,216.75
X$7958 \$3311 VIA_L1M1_PR_MR
* cell instance $7959 r0 *1 169.97,207.91
X$7959 \$3311 VIA_L1M1_PR_MR
* cell instance $7960 r0 *1 173.65,207.57
X$7960 \$3311 VIA_L1M1_PR_MR
* cell instance $7961 r0 *1 169.51,211.31
X$7961 \$3311 VIA_L1M1_PR_MR
* cell instance $7962 r0 *1 167.67,213.35
X$7962 \$3311 VIA_L1M1_PR_MR
* cell instance $7963 r0 *1 173.19,211.31
X$7963 \$3311 VIA_L1M1_PR_MR
* cell instance $7964 r0 *1 174.57,213.35
X$7964 \$3311 VIA_L1M1_PR_MR
* cell instance $7965 r0 *1 175.49,211.31
X$7965 \$3311 VIA_L1M1_PR_MR
* cell instance $7966 r0 *1 178.71,208.93
X$7966 \$3328 VIA_M1M2_PR
* cell instance $7967 r0 *1 178.71,215.73
X$7967 \$3328 VIA_M1M2_PR
* cell instance $7968 r0 *1 175.49,208.93
X$7968 \$3328 VIA_L1M1_PR_MR
* cell instance $7969 r0 *1 178.71,215.73
X$7969 \$3328 VIA_L1M1_PR_MR
* cell instance $7970 r0 *1 177.79,209.95
X$7970 \$3331 VIA_M1M2_PR
* cell instance $7971 r0 *1 177.79,219.13
X$7971 \$3331 VIA_M1M2_PR
* cell instance $7972 r0 *1 177.33,209.95
X$7972 \$3331 VIA_L1M1_PR_MR
* cell instance $7973 r0 *1 175.03,219.13
X$7973 \$3331 VIA_L1M1_PR_MR
* cell instance $7974 r0 *1 77.51,156.91
X$7974 \$3333 VIA_M1M2_PR
* cell instance $7975 r0 *1 77.51,207.23
X$7975 \$3333 VIA_M1M2_PR
* cell instance $7976 r0 *1 77.51,156.91
X$7976 \$3333 VIA_L1M1_PR_MR
* cell instance $7977 r0 *1 107.41,207.23
X$7977 \$3333 VIA_L1M1_PR_MR
* cell instance $7978 r0 *1 173.19,208.93
X$7978 \$3339 VIA_M1M2_PR
* cell instance $7979 r0 *1 173.19,219.47
X$7979 \$3339 VIA_M1M2_PR
* cell instance $7980 r0 *1 171.81,208.93
X$7980 \$3339 VIA_L1M1_PR_MR
* cell instance $7981 r0 *1 180.55,219.47
X$7981 \$3339 VIA_L1M1_PR_MR
* cell instance $7982 r0 *1 169.05,209.95
X$7982 \$3353 VIA_M1M2_PR
* cell instance $7983 r0 *1 169.05,224.23
X$7983 \$3353 VIA_M1M2_PR
* cell instance $7984 r0 *1 169.05,224.23
X$7984 \$3353 VIA_L1M1_PR_MR
* cell instance $7985 r0 *1 167.67,209.95
X$7985 \$3353 VIA_L1M1_PR_MR
* cell instance $7986 r0 *1 170.43,207.57
X$7986 \$3354 VIA_M1M2_PR
* cell instance $7987 r0 *1 170.43,194.31
X$7987 \$3354 VIA_M1M2_PR
* cell instance $7988 r0 *1 170.43,207.57
X$7988 \$3354 VIA_L1M1_PR_MR
* cell instance $7989 r0 *1 170.43,194.31
X$7989 \$3354 VIA_L1M1_PR_MR
* cell instance $7990 r0 *1 172.27,226.1
X$7990 \$3369 VIA_M2M3_PR
* cell instance $7991 r0 *1 169.05,226.1
X$7991 \$3369 VIA_M2M3_PR
* cell instance $7992 r0 *1 168.59,208.93
X$7992 \$3369 VIA_M1M2_PR
* cell instance $7993 r0 *1 172.73,226.95
X$7993 \$3369 VIA_M1M2_PR
* cell instance $7994 r0 *1 174.57,227.29
X$7994 \$3369 VIA_L1M1_PR_MR
* cell instance $7995 r0 *1 168.13,208.93
X$7995 \$3369 VIA_L1M1_PR_MR
* cell instance $7996 r0 *1 110.17,213.69
X$7996 \$3381 VIA_M1M2_PR
* cell instance $7997 r0 *1 110.17,216.41
X$7997 \$3381 VIA_M1M2_PR
* cell instance $7998 r0 *1 109.71,211.65
X$7998 \$3381 VIA_M1M2_PR
* cell instance $7999 r0 *1 110.63,213.35
X$7999 \$3381 VIA_L1M1_PR_MR
* cell instance $8000 r0 *1 110.63,212.67
X$8000 \$3381 VIA_L1M1_PR_MR
* cell instance $8001 r0 *1 110.17,216.41
X$8001 \$3381 VIA_L1M1_PR_MR
* cell instance $8002 r0 *1 110.17,210.97
X$8002 \$3381 VIA_L1M1_PR_MR
* cell instance $8003 r0 *1 113.85,212.67
X$8003 \$3381 VIA_L1M1_PR_MR
* cell instance $8004 r0 *1 112.01,216.41
X$8004 \$3384 VIA_M1M2_PR
* cell instance $8005 r0 *1 112.01,214.37
X$8005 \$3384 VIA_M1M2_PR
* cell instance $8006 r0 *1 112.01,216.41
X$8006 \$3384 VIA_L1M1_PR_MR
* cell instance $8007 r0 *1 109.71,216.07
X$8007 \$3384 VIA_L1M1_PR_MR
* cell instance $8008 r0 *1 123.05,214.37
X$8008 \$3384 VIA_L1M1_PR_MR
* cell instance $8009 r0 *1 112.47,213.18
X$8009 \$3385 VIA_M2M3_PR
* cell instance $8010 r0 *1 121.21,213.18
X$8010 \$3385 VIA_M2M3_PR
* cell instance $8011 r0 *1 112.47,211.65
X$8011 \$3385 VIA_M1M2_PR
* cell instance $8012 r0 *1 121.21,213.01
X$8012 \$3385 VIA_M1M2_PR
* cell instance $8013 r0 *1 112.47,211.65
X$8013 \$3385 VIA_L1M1_PR_MR
* cell instance $8014 r0 *1 121.21,213.01
X$8014 \$3385 VIA_L1M1_PR_MR
* cell instance $8015 r0 *1 124.89,215.39
X$8015 \$3387 VIA_M1M2_PR
* cell instance $8016 r0 *1 121.67,213.01
X$8016 \$3387 VIA_M1M2_PR
* cell instance $8017 r0 *1 121.67,211.65
X$8017 \$3387 VIA_M1M2_PR
* cell instance $8018 r0 *1 124.89,213.01
X$8018 \$3387 VIA_M1M2_PR
* cell instance $8019 r0 *1 123.05,213.01
X$8019 \$3387 VIA_L1M1_PR_MR
* cell instance $8020 r0 *1 114.77,210.97
X$8020 \$3387 VIA_L1M1_PR_MR
* cell instance $8021 r0 *1 125.35,215.39
X$8021 \$3387 VIA_L1M1_PR_MR
* cell instance $8022 r0 *1 112.93,216.07
X$8022 \$3388 VIA_M1M2_PR
* cell instance $8023 r0 *1 112.93,213.35
X$8023 \$3388 VIA_M1M2_PR
* cell instance $8024 r0 *1 124.43,212.67
X$8024 \$3388 VIA_M1M2_PR
* cell instance $8025 r0 *1 124.43,213.35
X$8025 \$3388 VIA_M1M2_PR
* cell instance $8026 r0 *1 124.43,211.65
X$8026 \$3388 VIA_M1M2_PR
* cell instance $8027 r0 *1 111.55,213.35
X$8027 \$3388 VIA_L1M1_PR_MR
* cell instance $8028 r0 *1 124.89,211.65
X$8028 \$3388 VIA_L1M1_PR_MR
* cell instance $8029 r0 *1 124.43,213.35
X$8029 \$3388 VIA_L1M1_PR_MR
* cell instance $8030 r0 *1 112.93,216.07
X$8030 \$3388 VIA_L1M1_PR_MR
* cell instance $8031 r0 *1 163.99,256.19
X$8031 \$3401 VIA_M1M2_PR
* cell instance $8032 r0 *1 169.51,213.35
X$8032 \$3401 VIA_M1M2_PR
* cell instance $8033 r0 *1 169.97,216.41
X$8033 \$3401 VIA_M1M2_PR
* cell instance $8034 r0 *1 165.37,218.79
X$8034 \$3401 VIA_M1M2_PR
* cell instance $8035 r0 *1 169.51,218.79
X$8035 \$3401 VIA_M1M2_PR
* cell instance $8036 r0 *1 165.83,221.85
X$8036 \$3401 VIA_M1M2_PR
* cell instance $8037 r0 *1 163.53,220.83
X$8037 \$3401 VIA_M1M2_PR
* cell instance $8038 r0 *1 165.37,220.83
X$8038 \$3401 VIA_M1M2_PR
* cell instance $8039 r0 *1 169.97,216.41
X$8039 \$3401 VIA_L1M1_PR_MR
* cell instance $8040 r0 *1 169.51,213.35
X$8040 \$3401 VIA_L1M1_PR_MR
* cell instance $8041 r0 *1 166.75,218.79
X$8041 \$3401 VIA_L1M1_PR_MR
* cell instance $8042 r0 *1 168.13,218.79
X$8042 \$3401 VIA_L1M1_PR_MR
* cell instance $8043 r0 *1 166.75,221.85
X$8043 \$3401 VIA_L1M1_PR_MR
* cell instance $8044 r0 *1 165.83,256.19
X$8044 \$3401 VIA_L1M1_PR_MR
* cell instance $8045 r0 *1 179.63,214.37
X$8045 \$3418 VIA_M1M2_PR
* cell instance $8046 r0 *1 179.63,216.41
X$8046 \$3418 VIA_M1M2_PR
* cell instance $8047 r0 *1 180.09,214.37
X$8047 \$3418 VIA_L1M1_PR_MR
* cell instance $8048 r0 *1 179.17,216.41
X$8048 \$3418 VIA_L1M1_PR_MR
* cell instance $8049 r0 *1 175.03,214.37
X$8049 \$3426 VIA_M1M2_PR
* cell instance $8050 r0 *1 175.03,221.17
X$8050 \$3426 VIA_M1M2_PR
* cell instance $8051 r0 *1 175.03,221.17
X$8051 \$3426 VIA_L1M1_PR_MR
* cell instance $8052 r0 *1 176.41,214.37
X$8052 \$3426 VIA_L1M1_PR_MR
* cell instance $8053 r0 *1 174.57,211.65
X$8053 \$3428 VIA_M1M2_PR
* cell instance $8054 r0 *1 174.57,218.11
X$8054 \$3428 VIA_M1M2_PR
* cell instance $8055 r0 *1 175.49,218.79
X$8055 \$3428 VIA_L1M1_PR_MR
* cell instance $8056 r0 *1 178.71,211.65
X$8056 \$3428 VIA_L1M1_PR_MR
* cell instance $8057 r0 *1 172.73,224.23
X$8057 \$3435 VIA_M1M2_PR
* cell instance $8058 r0 *1 172.73,215.39
X$8058 \$3435 VIA_M1M2_PR
* cell instance $8059 r0 *1 172.73,224.23
X$8059 \$3435 VIA_L1M1_PR_MR
* cell instance $8060 r0 *1 175.49,215.39
X$8060 \$3435 VIA_L1M1_PR_MR
* cell instance $8061 r0 *1 170.89,213.35
X$8061 \$3439 VIA_M1M2_PR
* cell instance $8062 r0 *1 170.89,218.45
X$8062 \$3439 VIA_M1M2_PR
* cell instance $8063 r0 *1 165.83,245.31
X$8063 \$3439 VIA_M1M2_PR
* cell instance $8064 r0 *1 164.91,221.85
X$8064 \$3439 VIA_M1M2_PR
* cell instance $8065 r0 *1 170.89,216.41
X$8065 \$3439 VIA_M1M2_PR
* cell instance $8066 r0 *1 164.91,219.13
X$8066 \$3439 VIA_M1M2_PR
* cell instance $8067 r0 *1 171.81,218.79
X$8067 \$3439 VIA_L1M1_PR_MR
* cell instance $8068 r0 *1 165.83,245.31
X$8068 \$3439 VIA_L1M1_PR_MR
* cell instance $8069 r0 *1 171.81,216.41
X$8069 \$3439 VIA_L1M1_PR_MR
* cell instance $8070 r0 *1 164.91,219.13
X$8070 \$3439 VIA_L1M1_PR_MR
* cell instance $8071 r0 *1 165.37,221.85
X$8071 \$3439 VIA_L1M1_PR_MR
* cell instance $8072 r0 *1 173.19,213.35
X$8072 \$3439 VIA_L1M1_PR_MR
* cell instance $8073 r0 *1 116.15,213.69
X$8073 \$3441 VIA_M1M2_PR
* cell instance $8074 r0 *1 116.15,211.31
X$8074 \$3441 VIA_M1M2_PR
* cell instance $8075 r0 *1 112.47,213.69
X$8075 \$3441 VIA_L1M1_PR_MR
* cell instance $8076 r0 *1 117.53,211.31
X$8076 \$3441 VIA_L1M1_PR_MR
* cell instance $8077 r0 *1 171.81,226.61
X$8077 \$3445 VIA_M1M2_PR
* cell instance $8078 r0 *1 171.81,214.37
X$8078 \$3445 VIA_M1M2_PR
* cell instance $8079 r0 *1 175.03,226.61
X$8079 \$3445 VIA_L1M1_PR_MR
* cell instance $8080 r0 *1 165.83,214.37
X$8080 \$3445 VIA_L1M1_PR_MR
* cell instance $8081 r0 *1 177.33,218.79
X$8081 \$3467 VIA_M1M2_PR
* cell instance $8082 r0 *1 177.33,216.41
X$8082 \$3467 VIA_M1M2_PR
* cell instance $8083 r0 *1 170.89,224.23
X$8083 \$3467 VIA_M1M2_PR
* cell instance $8084 r0 *1 174.11,218.79
X$8084 \$3467 VIA_M1M2_PR
* cell instance $8085 r0 *1 174.11,217.09
X$8085 \$3467 VIA_M1M2_PR
* cell instance $8086 r0 *1 174.11,227.63
X$8086 \$3467 VIA_M1M2_PR
* cell instance $8087 r0 *1 163.99,212.67
X$8087 \$3467 VIA_M1M2_PR
* cell instance $8088 r0 *1 170.89,221.85
X$8088 \$3467 VIA_M1M2_PR
* cell instance $8089 r0 *1 170.89,219.81
X$8089 \$3467 VIA_M1M2_PR
* cell instance $8090 r0 *1 174.11,221.85
X$8090 \$3467 VIA_M1M2_PR
* cell instance $8091 r0 *1 163.99,219.81
X$8091 \$3467 VIA_M1M2_PR
* cell instance $8092 r0 *1 174.11,224.23
X$8092 \$3467 VIA_M1M2_PR
* cell instance $8093 r0 *1 173.65,224.23
X$8093 \$3467 VIA_L1M1_PR_MR
* cell instance $8094 r0 *1 174.11,221.85
X$8094 \$3467 VIA_L1M1_PR_MR
* cell instance $8095 r0 *1 170.89,221.85
X$8095 \$3467 VIA_L1M1_PR_MR
* cell instance $8096 r0 *1 174.11,218.79
X$8096 \$3467 VIA_L1M1_PR_MR
* cell instance $8097 r0 *1 169.97,224.23
X$8097 \$3467 VIA_L1M1_PR_MR
* cell instance $8098 r0 *1 175.95,227.29
X$8098 \$3467 VIA_L1M1_PR_MR
* cell instance $8099 r0 *1 163.53,212.67
X$8099 \$3467 VIA_L1M1_PR_MR
* cell instance $8100 r0 *1 179.63,218.79
X$8100 \$3467 VIA_L1M1_PR_MR
* cell instance $8101 r0 *1 177.79,216.41
X$8101 \$3467 VIA_L1M1_PR_MR
* cell instance $8102 r0 *1 112.47,219.47
X$8102 \$3476 VIA_M1M2_PR
* cell instance $8103 r0 *1 112.47,218.79
X$8103 \$3476 VIA_M1M2_PR
* cell instance $8104 r0 *1 112.47,224.23
X$8104 \$3476 VIA_M1M2_PR
* cell instance $8105 r0 *1 116.15,217.09
X$8105 \$3476 VIA_M1M2_PR
* cell instance $8106 r0 *1 116.15,219.47
X$8106 \$3476 VIA_M1M2_PR
* cell instance $8107 r0 *1 112.47,218.79
X$8107 \$3476 VIA_L1M1_PR_MR
* cell instance $8108 r0 *1 123.05,217.09
X$8108 \$3476 VIA_L1M1_PR_MR
* cell instance $8109 r0 *1 114.77,219.47
X$8109 \$3476 VIA_L1M1_PR_MR
* cell instance $8110 r0 *1 112.93,224.23
X$8110 \$3476 VIA_L1M1_PR_MR
* cell instance $8111 r0 *1 118.45,218.45
X$8111 \$3482 VIA_M1M2_PR
* cell instance $8112 r0 *1 123.51,221.17
X$8112 \$3482 VIA_M1M2_PR
* cell instance $8113 r0 *1 118.45,221.85
X$8113 \$3482 VIA_M1M2_PR
* cell instance $8114 r0 *1 123.51,219.81
X$8114 \$3482 VIA_M1M2_PR
* cell instance $8115 r0 *1 118.45,221.17
X$8115 \$3482 VIA_M1M2_PR
* cell instance $8116 r0 *1 116.15,218.45
X$8116 \$3482 VIA_L1M1_PR_MR
* cell instance $8117 r0 *1 118.91,221.85
X$8117 \$3482 VIA_L1M1_PR_MR
* cell instance $8118 r0 *1 123.51,221.85
X$8118 \$3482 VIA_L1M1_PR_MR
* cell instance $8119 r0 *1 125.35,219.81
X$8119 \$3482 VIA_L1M1_PR_MR
* cell instance $8120 r0 *1 162.61,209.95
X$8120 \$3491 VIA_M1M2_PR
* cell instance $8121 r0 *1 162.61,221.51
X$8121 \$3491 VIA_M1M2_PR
* cell instance $8122 r0 *1 169.51,221.85
X$8122 \$3491 VIA_L1M1_PR_MR
* cell instance $8123 r0 *1 162.61,209.95
X$8123 \$3491 VIA_L1M1_PR_MR
* cell instance $8124 r0 *1 167.67,246.67
X$8124 \$3492 VIA_M1M2_PR
* cell instance $8125 r0 *1 170.43,213.35
X$8125 \$3492 VIA_M1M2_PR
* cell instance $8126 r0 *1 168.13,221.51
X$8126 \$3492 VIA_M1M2_PR
* cell instance $8127 r0 *1 168.13,216.41
X$8127 \$3492 VIA_M1M2_PR
* cell instance $8128 r0 *1 168.13,219.47
X$8128 \$3492 VIA_M1M2_PR
* cell instance $8129 r0 *1 170.43,218.79
X$8129 \$3492 VIA_M1M2_PR
* cell instance $8130 r0 *1 167.67,221.51
X$8130 \$3492 VIA_L1M1_PR_MR
* cell instance $8131 r0 *1 169.97,218.79
X$8131 \$3492 VIA_L1M1_PR_MR
* cell instance $8132 r0 *1 168.13,216.41
X$8132 \$3492 VIA_L1M1_PR_MR
* cell instance $8133 r0 *1 167.67,219.13
X$8133 \$3492 VIA_L1M1_PR_MR
* cell instance $8134 r0 *1 170.43,213.35
X$8134 \$3492 VIA_L1M1_PR_MR
* cell instance $8135 r0 *1 163.53,246.67
X$8135 \$3492 VIA_L1M1_PR_MR
* cell instance $8136 r0 *1 181.93,247.01
X$8136 \$3497 VIA_M1M2_PR
* cell instance $8137 r0 *1 181.93,219.81
X$8137 \$3497 VIA_M1M2_PR
* cell instance $8138 r0 *1 172.73,218.79
X$8138 \$3497 VIA_L1M1_PR_MR
* cell instance $8139 r0 *1 181.93,247.01
X$8139 \$3497 VIA_L1M1_PR_MR
* cell instance $8140 r0 *1 173.65,224.91
X$8140 \$3500 VIA_M1M2_PR
* cell instance $8141 r0 *1 173.65,219.13
X$8141 \$3500 VIA_M1M2_PR
* cell instance $8142 r0 *1 174.57,218.79
X$8142 \$3500 VIA_L1M1_PR_MR
* cell instance $8143 r0 *1 164.91,224.91
X$8143 \$3500 VIA_L1M1_PR_MR
* cell instance $8144 r0 *1 169.97,248.37
X$8144 \$3504 VIA_M1M2_PR
* cell instance $8145 r0 *1 178.71,219.13
X$8145 \$3504 VIA_M1M2_PR
* cell instance $8146 r0 *1 177.79,226.27
X$8146 \$3504 VIA_M1M2_PR
* cell instance $8147 r0 *1 169.51,226.95
X$8147 \$3504 VIA_M1M2_PR
* cell instance $8148 r0 *1 166.29,248.03
X$8148 \$3504 VIA_L1M1_PR_MR
* cell instance $8149 r0 *1 178.71,219.13
X$8149 \$3504 VIA_L1M1_PR_MR
* cell instance $8150 r0 *1 181.47,224.91
X$8150 \$3506 VIA_M1M2_PR
* cell instance $8151 r0 *1 181.47,219.13
X$8151 \$3506 VIA_M1M2_PR
* cell instance $8152 r0 *1 181.01,224.91
X$8152 \$3506 VIA_L1M1_PR_MR
* cell instance $8153 r0 *1 180.09,218.79
X$8153 \$3506 VIA_L1M1_PR_MR
* cell instance $8154 r0 *1 181.93,217.09
X$8154 \$3508 VIA_M1M2_PR
* cell instance $8155 r0 *1 181.93,218.79
X$8155 \$3508 VIA_M1M2_PR
* cell instance $8156 r0 *1 181.93,217.09
X$8156 \$3508 VIA_L1M1_PR_MR
* cell instance $8157 r0 *1 181.01,218.79
X$8157 \$3508 VIA_L1M1_PR_MR
* cell instance $8158 r0 *1 182.39,246.67
X$8158 \$3515 VIA_M1M2_PR
* cell instance $8159 r0 *1 182.39,216.75
X$8159 \$3515 VIA_M1M2_PR
* cell instance $8160 r0 *1 175.95,247.01
X$8160 \$3515 VIA_L1M1_PR_MR
* cell instance $8161 r0 *1 176.87,216.75
X$8161 \$3515 VIA_L1M1_PR_MR
* cell instance $8162 r0 *1 178.25,216.41
X$8162 \$3516 VIA_M1M2_PR
* cell instance $8163 r0 *1 178.25,220.83
X$8163 \$3516 VIA_M1M2_PR
* cell instance $8164 r0 *1 178.25,216.41
X$8164 \$3516 VIA_L1M1_PR_MR
* cell instance $8165 r0 *1 179.17,220.83
X$8165 \$3516 VIA_L1M1_PR_MR
* cell instance $8166 r0 *1 113.39,222.19
X$8166 \$3532 VIA_M1M2_PR
* cell instance $8167 r0 *1 113.39,224.23
X$8167 \$3532 VIA_M1M2_PR
* cell instance $8168 r0 *1 113.39,219.13
X$8168 \$3532 VIA_M1M2_PR
* cell instance $8169 r0 *1 111.09,219.13
X$8169 \$3532 VIA_L1M1_PR_MR
* cell instance $8170 r0 *1 113.39,224.23
X$8170 \$3532 VIA_L1M1_PR_MR
* cell instance $8171 r0 *1 116.61,221.85
X$8171 \$3532 VIA_L1M1_PR_MR
* cell instance $8172 r0 *1 115.69,216.75
X$8172 \$3535 VIA_M1M2_PR
* cell instance $8173 r0 *1 115.69,218.45
X$8173 \$3535 VIA_M1M2_PR
* cell instance $8174 r0 *1 111.55,218.45
X$8174 \$3535 VIA_L1M1_PR_MR
* cell instance $8175 r0 *1 115.69,216.75
X$8175 \$3535 VIA_L1M1_PR_MR
* cell instance $8176 r0 *1 171.35,209.95
X$8176 \$3540 VIA_M1M2_PR
* cell instance $8177 r0 *1 171.35,221.17
X$8177 \$3540 VIA_M1M2_PR
* cell instance $8178 r0 *1 169.97,221.17
X$8178 \$3540 VIA_L1M1_PR_MR
* cell instance $8179 r0 *1 171.35,209.95
X$8179 \$3540 VIA_L1M1_PR_MR
* cell instance $8180 r0 *1 115.69,221.51
X$8180 \$3541 VIA_M1M2_PR
* cell instance $8181 r0 *1 115.69,223.89
X$8181 \$3541 VIA_M1M2_PR
* cell instance $8182 r0 *1 114.31,224.23
X$8182 \$3541 VIA_L1M1_PR_MR
* cell instance $8183 r0 *1 120.75,221.51
X$8183 \$3541 VIA_L1M1_PR_MR
* cell instance $8184 r0 *1 172.27,217.09
X$8184 \$3546 VIA_M1M2_PR
* cell instance $8185 r0 *1 172.27,224.23
X$8185 \$3546 VIA_M1M2_PR
* cell instance $8186 r0 *1 172.27,224.23
X$8186 \$3546 VIA_L1M1_PR_MR
* cell instance $8187 r0 *1 167.21,217.09
X$8187 \$3546 VIA_L1M1_PR_MR
* cell instance $8188 r0 *1 165.37,223.38
X$8188 \$3548 VIA_M2M3_PR
* cell instance $8189 r0 *1 167.67,222.7
X$8189 \$3548 VIA_M2M3_PR
* cell instance $8190 r0 *1 178.71,228.99
X$8190 \$3548 VIA_M1M2_PR
* cell instance $8191 r0 *1 178.71,224.23
X$8191 \$3548 VIA_M1M2_PR
* cell instance $8192 r0 *1 178.71,221.85
X$8192 \$3548 VIA_M1M2_PR
* cell instance $8193 r0 *1 172.27,229.67
X$8193 \$3548 VIA_M1M2_PR
* cell instance $8194 r0 *1 170.43,227.29
X$8194 \$3548 VIA_M1M2_PR
* cell instance $8195 r0 *1 172.27,228.99
X$8195 \$3548 VIA_M1M2_PR
* cell instance $8196 r0 *1 172.27,232.73
X$8196 \$3548 VIA_M1M2_PR
* cell instance $8197 r0 *1 170.43,227.97
X$8197 \$3548 VIA_M1M2_PR
* cell instance $8198 r0 *1 165.37,227.29
X$8198 \$3548 VIA_M1M2_PR
* cell instance $8199 r0 *1 170.43,228.99
X$8199 \$3548 VIA_M1M2_PR
* cell instance $8200 r0 *1 167.67,218.11
X$8200 \$3548 VIA_M1M2_PR
* cell instance $8201 r0 *1 165.37,224.23
X$8201 \$3548 VIA_M1M2_PR
* cell instance $8202 r0 *1 171.55,227.29
X$8202 \$3548 VIA_L1M1_PR_MR
* cell instance $8203 r0 *1 172.295,232.73
X$8203 \$3548 VIA_L1M1_PR_MR
* cell instance $8204 r0 *1 172.295,229.67
X$8204 \$3548 VIA_L1M1_PR_MR
* cell instance $8205 r0 *1 168.105,227.29
X$8205 \$3548 VIA_L1M1_PR_MR
* cell instance $8206 r0 *1 169.51,218.11
X$8206 \$3548 VIA_L1M1_PR_MR
* cell instance $8207 r0 *1 175.975,229.67
X$8207 \$3548 VIA_L1M1_PR_MR
* cell instance $8208 r0 *1 165.57,224.23
X$8208 \$3548 VIA_L1M1_PR_MR
* cell instance $8209 r0 *1 180.115,224.23
X$8209 \$3548 VIA_L1M1_PR_MR
* cell instance $8210 r0 *1 178.51,221.85
X$8210 \$3548 VIA_L1M1_PR_MR
* cell instance $8211 r0 *1 118.91,222.53
X$8211 \$3575 VIA_M1M2_PR
* cell instance $8212 r0 *1 118.91,223.55
X$8212 \$3575 VIA_M1M2_PR
* cell instance $8213 r0 *1 119.83,221.85
X$8213 \$3575 VIA_L1M1_PR_MR
* cell instance $8214 r0 *1 119.37,223.55
X$8214 \$3575 VIA_L1M1_PR_MR
* cell instance $8215 r0 *1 121.67,222.19
X$8215 \$3575 VIA_L1M1_PR_MR
* cell instance $8216 r0 *1 172.27,284.41
X$8216 \$3588 VIA_M1M2_PR
* cell instance $8217 r0 *1 172.27,273.53
X$8217 \$3588 VIA_M1M2_PR
* cell instance $8218 r0 *1 172.27,281.35
X$8218 \$3588 VIA_M1M2_PR
* cell instance $8219 r0 *1 164.91,249.05
X$8219 \$3588 VIA_M1M2_PR
* cell instance $8220 r0 *1 172.27,254.83
X$8220 \$3588 VIA_M1M2_PR
* cell instance $8221 r0 *1 172.27,249.05
X$8221 \$3588 VIA_M1M2_PR
* cell instance $8222 r0 *1 158.93,224.23
X$8222 \$3588 VIA_M1M2_PR
* cell instance $8223 r0 *1 158.93,226.95
X$8223 \$3588 VIA_M1M2_PR
* cell instance $8224 r0 *1 164.91,226.95
X$8224 \$3588 VIA_M1M2_PR
* cell instance $8225 r0 *1 160.77,226.95
X$8225 \$3588 VIA_L1M1_PR_MR
* cell instance $8226 r0 *1 158.93,224.23
X$8226 \$3588 VIA_L1M1_PR_MR
* cell instance $8227 r0 *1 176.41,254.49
X$8227 \$3588 VIA_L1M1_PR_MR
* cell instance $8228 r0 *1 168.13,273.53
X$8228 \$3588 VIA_L1M1_PR_MR
* cell instance $8229 r0 *1 168.13,284.41
X$8229 \$3588 VIA_L1M1_PR_MR
* cell instance $8230 r0 *1 172.27,281.35
X$8230 \$3588 VIA_L1M1_PR_MR
* cell instance $8231 r0 *1 175.49,249.05
X$8231 \$3588 VIA_L1M1_PR_MR
* cell instance $8232 r0 *1 177.33,223.89
X$8232 \$3592 VIA_M1M2_PR
* cell instance $8233 r0 *1 179.17,223.89
X$8233 \$3592 VIA_M1M2_PR
* cell instance $8234 r0 *1 177.33,221.85
X$8234 \$3592 VIA_M1M2_PR
* cell instance $8235 r0 *1 179.17,227.97
X$8235 \$3592 VIA_M1M2_PR
* cell instance $8236 r0 *1 171.35,232.73
X$8236 \$3592 VIA_M1M2_PR
* cell instance $8237 r0 *1 171.35,227.97
X$8237 \$3592 VIA_M1M2_PR
* cell instance $8238 r0 *1 171.35,229.33
X$8238 \$3592 VIA_M1M2_PR
* cell instance $8239 r0 *1 166.75,227.63
X$8239 \$3592 VIA_M1M2_PR
* cell instance $8240 r0 *1 166.75,223.89
X$8240 \$3592 VIA_M1M2_PR
* cell instance $8241 r0 *1 166.75,222.53
X$8241 \$3592 VIA_M1M2_PR
* cell instance $8242 r0 *1 166.75,222.53
X$8242 \$3592 VIA_L1M1_PR_MR
* cell instance $8243 r0 *1 169.05,227.63
X$8243 \$3592 VIA_L1M1_PR_MR
* cell instance $8244 r0 *1 171.35,229.33
X$8244 \$3592 VIA_L1M1_PR_MR
* cell instance $8245 r0 *1 172.73,227.63
X$8245 \$3592 VIA_L1M1_PR_MR
* cell instance $8246 r0 *1 171.35,232.73
X$8246 \$3592 VIA_L1M1_PR_MR
* cell instance $8247 r0 *1 166.75,223.89
X$8247 \$3592 VIA_L1M1_PR_MR
* cell instance $8248 r0 *1 175.03,229.33
X$8248 \$3592 VIA_L1M1_PR_MR
* cell instance $8249 r0 *1 179.17,223.89
X$8249 \$3592 VIA_L1M1_PR_MR
* cell instance $8250 r0 *1 177.33,221.85
X$8250 \$3592 VIA_L1M1_PR_MR
* cell instance $8251 r0 *1 175.49,222.53
X$8251 \$3607 VIA_M1M2_PR
* cell instance $8252 r0 *1 175.49,221.85
X$8252 \$3607 VIA_M1M2_PR
* cell instance $8253 r0 *1 182.85,214.37
X$8253 \$3607 VIA_M1M2_PR
* cell instance $8254 r0 *1 182.85,222.53
X$8254 \$3607 VIA_M1M2_PR
* cell instance $8255 r0 *1 175.49,221.85
X$8255 \$3607 VIA_L1M1_PR_MR
* cell instance $8256 r0 *1 182.85,214.37
X$8256 \$3607 VIA_L1M1_PR_MR
* cell instance $8257 r0 *1 178.25,253.47
X$8257 \$3621 VIA_M1M2_PR
* cell instance $8258 r0 *1 178.25,225.25
X$8258 \$3621 VIA_M1M2_PR
* cell instance $8259 r0 *1 174.57,225.25
X$8259 \$3621 VIA_L1M1_PR_MR
* cell instance $8260 r0 *1 177.79,253.47
X$8260 \$3621 VIA_L1M1_PR_MR
* cell instance $8261 r0 *1 175.03,237.15
X$8261 \$3623 VIA_M1M2_PR
* cell instance $8262 r0 *1 175.03,222.53
X$8262 \$3623 VIA_M1M2_PR
* cell instance $8263 r0 *1 173.19,222.53
X$8263 \$3623 VIA_L1M1_PR_MR
* cell instance $8264 r0 *1 175.03,237.15
X$8264 \$3623 VIA_L1M1_PR_MR
* cell instance $8265 r0 *1 171.81,248.03
X$8265 \$3627 VIA_M1M2_PR
* cell instance $8266 r0 *1 171.35,222.53
X$8266 \$3627 VIA_M1M2_PR
* cell instance $8267 r0 *1 171.81,222.53
X$8267 \$3627 VIA_L1M1_PR_MR
* cell instance $8268 r0 *1 181.47,248.03
X$8268 \$3627 VIA_L1M1_PR_MR
* cell instance $8269 r0 *1 117.99,224.23
X$8269 \$3635 VIA_M1M2_PR
* cell instance $8270 r0 *1 117.99,219.13
X$8270 \$3635 VIA_M1M2_PR
* cell instance $8271 r0 *1 115.23,224.23
X$8271 \$3635 VIA_L1M1_PR_MR
* cell instance $8272 r0 *1 117.99,219.13
X$8272 \$3635 VIA_L1M1_PR_MR
* cell instance $8273 r0 *1 170.43,226.27
X$8273 \$3637 VIA_M1M2_PR
* cell instance $8274 r0 *1 170.43,221.85
X$8274 \$3637 VIA_M1M2_PR
* cell instance $8275 r0 *1 170.43,221.85
X$8275 \$3637 VIA_L1M1_PR_MR
* cell instance $8276 r0 *1 170.89,226.27
X$8276 \$3637 VIA_L1M1_PR_MR
* cell instance $8277 r0 *1 169.51,226.27
X$8277 \$3658 VIA_M1M2_PR
* cell instance $8278 r0 *1 169.51,224.23
X$8278 \$3658 VIA_M1M2_PR
* cell instance $8279 r0 *1 169.51,224.23
X$8279 \$3658 VIA_L1M1_PR_MR
* cell instance $8280 r0 *1 167.21,226.27
X$8280 \$3658 VIA_L1M1_PR_MR
* cell instance $8281 r0 *1 124.89,232.73
X$8281 \$3691 VIA_M1M2_PR
* cell instance $8282 r0 *1 124.89,230.69
X$8282 \$3691 VIA_M1M2_PR
* cell instance $8283 r0 *1 116.61,230.69
X$8283 \$3691 VIA_M1M2_PR
* cell instance $8284 r0 *1 116.61,227.97
X$8284 \$3691 VIA_M1M2_PR
* cell instance $8285 r0 *1 111.09,237.83
X$8285 \$3691 VIA_M1M2_PR
* cell instance $8286 r0 *1 111.09,232.73
X$8286 \$3691 VIA_M1M2_PR
* cell instance $8287 r0 *1 111.09,227.97
X$8287 \$3691 VIA_M1M2_PR
* cell instance $8288 r0 *1 112.93,237.83
X$8288 \$3691 VIA_L1M1_PR_MR
* cell instance $8289 r0 *1 124.89,232.73
X$8289 \$3691 VIA_L1M1_PR_MR
* cell instance $8290 r0 *1 111.55,232.73
X$8290 \$3691 VIA_L1M1_PR_MR
* cell instance $8291 r0 *1 124.89,230.69
X$8291 \$3691 VIA_L1M1_PR_MR
* cell instance $8292 r0 *1 112.47,229.67
X$8292 \$3692 VIA_M1M2_PR
* cell instance $8293 r0 *1 112.47,234.43
X$8293 \$3692 VIA_M1M2_PR
* cell instance $8294 r0 *1 112.47,231.71
X$8294 \$3692 VIA_M1M2_PR
* cell instance $8295 r0 *1 112.93,229.67
X$8295 \$3692 VIA_L1M1_PR_MR
* cell instance $8296 r0 *1 112.47,232.73
X$8296 \$3692 VIA_L1M1_PR_MR
* cell instance $8297 r0 *1 108.79,235.11
X$8297 \$3692 VIA_L1M1_PR_MR
* cell instance $8298 r0 *1 122.59,231.71
X$8298 \$3692 VIA_L1M1_PR_MR
* cell instance $8299 r0 *1 121.67,233.41
X$8299 \$3694 VIA_M1M2_PR
* cell instance $8300 r0 *1 121.67,234.77
X$8300 \$3694 VIA_M1M2_PR
* cell instance $8301 r0 *1 113.39,230.01
X$8301 \$3694 VIA_M1M2_PR
* cell instance $8302 r0 *1 112.93,233.07
X$8302 \$3694 VIA_M1M2_PR
* cell instance $8303 r0 *1 112.93,233.07
X$8303 \$3694 VIA_L1M1_PR_MR
* cell instance $8304 r0 *1 113.39,230.01
X$8304 \$3694 VIA_L1M1_PR_MR
* cell instance $8305 r0 *1 121.67,234.77
X$8305 \$3694 VIA_L1M1_PR_MR
* cell instance $8306 r0 *1 123.97,231.71
X$8306 \$3698 VIA_M1M2_PR
* cell instance $8307 r0 *1 123.97,228.99
X$8307 \$3698 VIA_M1M2_PR
* cell instance $8308 r0 *1 125.81,231.71
X$8308 \$3698 VIA_L1M1_PR_MR
* cell instance $8309 r0 *1 114.31,229.67
X$8309 \$3698 VIA_L1M1_PR_MR
* cell instance $8310 r0 *1 110.63,231.71
X$8310 \$3700 VIA_M1M2_PR
* cell instance $8311 r0 *1 110.63,230.35
X$8311 \$3700 VIA_M1M2_PR
* cell instance $8312 r0 *1 110.63,231.71
X$8312 \$3700 VIA_L1M1_PR_MR
* cell instance $8313 r0 *1 117.53,230.01
X$8313 \$3700 VIA_L1M1_PR_MR
* cell instance $8314 r0 *1 115.69,234.43
X$8314 \$3705 VIA_M1M2_PR
* cell instance $8315 r0 *1 115.69,232.39
X$8315 \$3705 VIA_M1M2_PR
* cell instance $8316 r0 *1 112.93,234.43
X$8316 \$3705 VIA_M1M2_PR
* cell instance $8317 r0 *1 112.93,238.51
X$8317 \$3705 VIA_M1M2_PR
* cell instance $8318 r0 *1 112.93,236.13
X$8318 \$3705 VIA_M1M2_PR
* cell instance $8319 r0 *1 108.33,235.79
X$8319 \$3705 VIA_L1M1_PR_MR
* cell instance $8320 r0 *1 112.01,238.17
X$8320 \$3705 VIA_L1M1_PR_MR
* cell instance $8321 r0 *1 123.51,231.71
X$8321 \$3705 VIA_L1M1_PR_MR
* cell instance $8322 r0 *1 123.51,232.39
X$8322 \$3706 VIA_M1M2_PR
* cell instance $8323 r0 *1 123.51,227.97
X$8323 \$3706 VIA_M1M2_PR
* cell instance $8324 r0 *1 123.05,235.11
X$8324 \$3706 VIA_M1M2_PR
* cell instance $8325 r0 *1 123.05,235.11
X$8325 \$3706 VIA_L1M1_PR_MR
* cell instance $8326 r0 *1 123.97,232.39
X$8326 \$3706 VIA_L1M1_PR_MR
* cell instance $8327 r0 *1 119.37,227.97
X$8327 \$3706 VIA_L1M1_PR_MR
* cell instance $8328 r0 *1 175.49,230.35
X$8328 \$3732 VIA_M1M2_PR
* cell instance $8329 r0 *1 175.49,227.29
X$8329 \$3732 VIA_M1M2_PR
* cell instance $8330 r0 *1 176.87,230.35
X$8330 \$3732 VIA_L1M1_PR_MR
* cell instance $8331 r0 *1 175.49,227.29
X$8331 \$3732 VIA_L1M1_PR_MR
* cell instance $8332 r0 *1 177.79,247.01
X$8332 \$3734 VIA_M1M2_PR
* cell instance $8333 r0 *1 177.79,227.29
X$8333 \$3734 VIA_M1M2_PR
* cell instance $8334 r0 *1 177.33,227.29
X$8334 \$3734 VIA_L1M1_PR_MR
* cell instance $8335 r0 *1 179.17,247.01
X$8335 \$3734 VIA_L1M1_PR_MR
* cell instance $8336 r0 *1 174.57,221.85
X$8336 \$3736 VIA_M1M2_PR
* cell instance $8337 r0 *1 174.57,230.35
X$8337 \$3736 VIA_M1M2_PR
* cell instance $8338 r0 *1 173.19,230.35
X$8338 \$3736 VIA_L1M1_PR_MR
* cell instance $8339 r0 *1 174.57,221.85
X$8339 \$3736 VIA_L1M1_PR_MR
* cell instance $8340 r0 *1 173.19,231.71
X$8340 \$3742 VIA_M1M2_PR
* cell instance $8341 r0 *1 173.19,224.23
X$8341 \$3742 VIA_M1M2_PR
* cell instance $8342 r0 *1 173.19,231.71
X$8342 \$3742 VIA_L1M1_PR_MR
* cell instance $8343 r0 *1 173.19,224.23
X$8343 \$3742 VIA_L1M1_PR_MR
* cell instance $8344 r0 *1 113.39,230.69
X$8344 \$3749 VIA_M1M2_PR
* cell instance $8345 r0 *1 113.39,232.39
X$8345 \$3749 VIA_M1M2_PR
* cell instance $8346 r0 *1 115.23,230.69
X$8346 \$3749 VIA_L1M1_PR_MR
* cell instance $8347 r0 *1 115.23,232.39
X$8347 \$3749 VIA_L1M1_PR_MR
* cell instance $8348 r0 *1 112.01,240.55
X$8348 \$3785 VIA_M1M2_PR
* cell instance $8349 r0 *1 112.01,235.11
X$8349 \$3785 VIA_M1M2_PR
* cell instance $8350 r0 *1 112.01,237.15
X$8350 \$3785 VIA_M1M2_PR
* cell instance $8351 r0 *1 112.93,240.55
X$8351 \$3785 VIA_L1M1_PR_MR
* cell instance $8352 r0 *1 109.71,235.11
X$8352 \$3785 VIA_L1M1_PR_MR
* cell instance $8353 r0 *1 114.31,237.15
X$8353 \$3785 VIA_L1M1_PR_MR
* cell instance $8354 r0 *1 111.09,241.23
X$8354 \$3785 VIA_L1M1_PR_MR
* cell instance $8355 r0 *1 111.55,236.13
X$8355 \$3788 VIA_M1M2_PR
* cell instance $8356 r0 *1 111.55,237.49
X$8356 \$3788 VIA_M1M2_PR
* cell instance $8357 r0 *1 121.67,237.83
X$8357 \$3788 VIA_L1M1_PR_MR
* cell instance $8358 r0 *1 111.55,236.13
X$8358 \$3788 VIA_L1M1_PR_MR
* cell instance $8359 r0 *1 122.59,238.85
X$8359 \$3790 VIA_M1M2_PR
* cell instance $8360 r0 *1 122.59,239.87
X$8360 \$3790 VIA_M1M2_PR
* cell instance $8361 r0 *1 123.97,238.85
X$8361 \$3790 VIA_L1M1_PR_MR
* cell instance $8362 r0 *1 114.31,240.55
X$8362 \$3790 VIA_L1M1_PR_MR
* cell instance $8363 r0 *1 126.27,236.13
X$8363 \$3791 VIA_M1M2_PR
* cell instance $8364 r0 *1 126.27,238.51
X$8364 \$3791 VIA_M1M2_PR
* cell instance $8365 r0 *1 126.27,239.87
X$8365 \$3791 VIA_M1M2_PR
* cell instance $8366 r0 *1 126.27,238.51
X$8366 \$3791 VIA_L1M1_PR_MR
* cell instance $8367 r0 *1 124.89,240.89
X$8367 \$3791 VIA_L1M1_PR_MR
* cell instance $8368 r0 *1 124.89,239.87
X$8368 \$3791 VIA_L1M1_PR_MR
* cell instance $8369 r0 *1 112.47,240.89
X$8369 \$3791 VIA_L1M1_PR_MR
* cell instance $8370 r0 *1 115.23,235.11
X$8370 \$3791 VIA_L1M1_PR_MR
* cell instance $8371 r0 *1 124.43,238.17
X$8371 \$3793 VIA_M1M2_PR
* cell instance $8372 r0 *1 124.43,235.79
X$8372 \$3793 VIA_M1M2_PR
* cell instance $8373 r0 *1 117.99,235.45
X$8373 \$3793 VIA_L1M1_PR_MR
* cell instance $8374 r0 *1 124.43,238.17
X$8374 \$3793 VIA_L1M1_PR_MR
* cell instance $8375 r0 *1 116.61,235.11
X$8375 \$3793 VIA_L1M1_PR_MR
* cell instance $8376 r0 *1 123.51,233.07
X$8376 \$3797 VIA_M1M2_PR
* cell instance $8377 r0 *1 123.51,235.45
X$8377 \$3797 VIA_M1M2_PR
* cell instance $8378 r0 *1 123.97,235.45
X$8378 \$3797 VIA_L1M1_PR_MR
* cell instance $8379 r0 *1 123.51,233.07
X$8379 \$3797 VIA_L1M1_PR_MR
* cell instance $8380 r0 *1 122.59,235.11
X$8380 \$3797 VIA_L1M1_PR_MR
* cell instance $8381 r0 *1 74.29,154.19
X$8381 \$3812 VIA_M1M2_PR
* cell instance $8382 r0 *1 74.29,239.87
X$8382 \$3812 VIA_M1M2_PR
* cell instance $8383 r0 *1 74.29,154.19
X$8383 \$3812 VIA_L1M1_PR_MR
* cell instance $8384 r0 *1 110.17,239.87
X$8384 \$3812 VIA_L1M1_PR_MR
* cell instance $8385 r0 *1 173.19,282.03
X$8385 \$3813 VIA_M1M2_PR
* cell instance $8386 r0 *1 176.87,257.21
X$8386 \$3813 VIA_M1M2_PR
* cell instance $8387 r0 *1 176.87,254.83
X$8387 \$3813 VIA_M1M2_PR
* cell instance $8388 r0 *1 181.01,249.39
X$8388 \$3813 VIA_M1M2_PR
* cell instance $8389 r0 *1 173.19,283.39
X$8389 \$3813 VIA_M1M2_PR
* cell instance $8390 r0 *1 173.19,279.31
X$8390 \$3813 VIA_M1M2_PR
* cell instance $8391 r0 *1 163.99,249.39
X$8391 \$3813 VIA_M1M2_PR
* cell instance $8392 r0 *1 174.57,251.09
X$8392 \$3813 VIA_M1M2_PR
* cell instance $8393 r0 *1 173.19,251.09
X$8393 \$3813 VIA_M1M2_PR
* cell instance $8394 r0 *1 174.11,259.93
X$8394 \$3813 VIA_M1M2_PR
* cell instance $8395 r0 *1 174.11,257.21
X$8395 \$3813 VIA_M1M2_PR
* cell instance $8396 r0 *1 176.87,243.95
X$8396 \$3813 VIA_M1M2_PR
* cell instance $8397 r0 *1 176.87,245.65
X$8397 \$3813 VIA_M1M2_PR
* cell instance $8398 r0 *1 181.01,245.65
X$8398 \$3813 VIA_M1M2_PR
* cell instance $8399 r0 *1 163.99,245.31
X$8399 \$3813 VIA_M1M2_PR
* cell instance $8400 r0 *1 163.99,243.61
X$8400 \$3813 VIA_M1M2_PR
* cell instance $8401 r0 *1 173.19,240.89
X$8401 \$3813 VIA_M1M2_PR
* cell instance $8402 r0 *1 173.19,238.51
X$8402 \$3813 VIA_M1M2_PR
* cell instance $8403 r0 *1 173.19,245.65
X$8403 \$3813 VIA_M1M2_PR
* cell instance $8404 r0 *1 174.11,238.51
X$8404 \$3813 VIA_L1M1_PR_MR
* cell instance $8405 r0 *1 165.37,243.61
X$8405 \$3813 VIA_L1M1_PR_MR
* cell instance $8406 r0 *1 175.03,245.65
X$8406 \$3813 VIA_L1M1_PR_MR
* cell instance $8407 r0 *1 175.03,240.89
X$8407 \$3813 VIA_L1M1_PR_MR
* cell instance $8408 r0 *1 176.87,254.83
X$8408 \$3813 VIA_L1M1_PR_MR
* cell instance $8409 r0 *1 181.93,251.09
X$8409 \$3813 VIA_L1M1_PR_MR
* cell instance $8410 r0 *1 176.87,283.39
X$8410 \$3813 VIA_L1M1_PR_MR
* cell instance $8411 r0 *1 175.03,257.21
X$8411 \$3813 VIA_L1M1_PR_MR
* cell instance $8412 r0 *1 166.75,281.69
X$8412 \$3813 VIA_L1M1_PR_MR
* cell instance $8413 r0 *1 180.55,249.39
X$8413 \$3813 VIA_L1M1_PR_MR
* cell instance $8414 r0 *1 169.05,278.97
X$8414 \$3813 VIA_L1M1_PR_MR
* cell instance $8415 r0 *1 165.37,249.39
X$8415 \$3813 VIA_L1M1_PR_MR
* cell instance $8416 r0 *1 171.35,281.69
X$8416 \$3813 VIA_L1M1_PR_MR
* cell instance $8417 r0 *1 174.11,259.93
X$8417 \$3813 VIA_L1M1_PR_MR
* cell instance $8418 r0 *1 181.01,245.65
X$8418 \$3813 VIA_L1M1_PR_MR
* cell instance $8419 r0 *1 176.87,243.95
X$8419 \$3813 VIA_L1M1_PR_MR
* cell instance $8420 r0 *1 178.25,245.65
X$8420 \$3813 VIA_L1M1_PR_MR
* cell instance $8421 r0 *1 113.39,236.13
X$8421 \$3824 VIA_M1M2_PR
* cell instance $8422 r0 *1 113.39,240.55
X$8422 \$3824 VIA_M1M2_PR
* cell instance $8423 r0 *1 114.31,236.13
X$8423 \$3824 VIA_L1M1_PR_MR
* cell instance $8424 r0 *1 113.39,240.55
X$8424 \$3824 VIA_L1M1_PR_MR
* cell instance $8425 r0 *1 113.39,235.45
X$8425 \$3824 VIA_L1M1_PR_MR
* cell instance $8426 r0 *1 111.09,235.45
X$8426 \$3824 VIA_L1M1_PR_MR
* cell instance $8427 r0 *1 123.51,276.25
X$8427 \$3828 VIA_M1M2_PR
* cell instance $8428 r0 *1 123.51,286.79
X$8428 \$3828 VIA_M1M2_PR
* cell instance $8429 r0 *1 123.51,257.21
X$8429 \$3828 VIA_M1M2_PR
* cell instance $8430 r0 *1 123.97,238.17
X$8430 \$3828 VIA_M1M2_PR
* cell instance $8431 r0 *1 123.97,248.71
X$8431 \$3828 VIA_M1M2_PR
* cell instance $8432 r0 *1 123.97,246.33
X$8432 \$3828 VIA_M1M2_PR
* cell instance $8433 r0 *1 116.15,257.21
X$8433 \$3828 VIA_L1M1_PR_MR
* cell instance $8434 r0 *1 123.97,248.71
X$8434 \$3828 VIA_L1M1_PR_MR
* cell instance $8435 r0 *1 123.05,276.25
X$8435 \$3828 VIA_L1M1_PR_MR
* cell instance $8436 r0 *1 123.05,238.17
X$8436 \$3828 VIA_L1M1_PR_MR
* cell instance $8437 r0 *1 128.57,249.05
X$8437 \$3828 VIA_L1M1_PR_MR
* cell instance $8438 r0 *1 125.81,246.33
X$8438 \$3828 VIA_L1M1_PR_MR
* cell instance $8439 r0 *1 123.05,286.79
X$8439 \$3828 VIA_L1M1_PR_MR
* cell instance $8440 r0 *1 115.69,245.31
X$8440 \$3848 VIA_M1M2_PR
* cell instance $8441 r0 *1 115.69,243.95
X$8441 \$3848 VIA_M1M2_PR
* cell instance $8442 r0 *1 115.69,243.95
X$8442 \$3848 VIA_L1M1_PR_MR
* cell instance $8443 r0 *1 114.77,245.65
X$8443 \$3848 VIA_L1M1_PR_MR
* cell instance $8444 r0 *1 167.21,256.53
X$8444 \$3860 VIA_M1M2_PR
* cell instance $8445 r0 *1 167.21,244.29
X$8445 \$3860 VIA_M1M2_PR
* cell instance $8446 r0 *1 166.29,243.61
X$8446 \$3860 VIA_L1M1_PR_MR
* cell instance $8447 r0 *1 168.59,256.53
X$8447 \$3860 VIA_L1M1_PR_MR
* cell instance $8448 r0 *1 166.29,254.15
X$8448 \$3861 VIA_M1M2_PR
* cell instance $8449 r0 *1 166.75,243.61
X$8449 \$3861 VIA_M1M2_PR
* cell instance $8450 r0 *1 166.75,240.89
X$8450 \$3861 VIA_M1M2_PR
* cell instance $8451 r0 *1 166.75,243.61
X$8451 \$3861 VIA_L1M1_PR_MR
* cell instance $8452 r0 *1 171.81,240.89
X$8452 \$3861 VIA_L1M1_PR_MR
* cell instance $8453 r0 *1 166.29,254.15
X$8453 \$3861 VIA_L1M1_PR_MR
* cell instance $8454 r0 *1 177.79,251.43
X$8454 \$3868 VIA_M1M2_PR
* cell instance $8455 r0 *1 177.79,248.71
X$8455 \$3868 VIA_M1M2_PR
* cell instance $8456 r0 *1 179.17,251.43
X$8456 \$3868 VIA_M1M2_PR
* cell instance $8457 r0 *1 172.73,251.43
X$8457 \$3868 VIA_M1M2_PR
* cell instance $8458 r0 *1 172.73,249.39
X$8458 \$3868 VIA_M1M2_PR
* cell instance $8459 r0 *1 174.11,255.17
X$8459 \$3868 VIA_M1M2_PR
* cell instance $8460 r0 *1 173.65,259.93
X$8460 \$3868 VIA_M1M2_PR
* cell instance $8461 r0 *1 173.65,257.21
X$8461 \$3868 VIA_M1M2_PR
* cell instance $8462 r0 *1 179.17,255.17
X$8462 \$3868 VIA_M1M2_PR
* cell instance $8463 r0 *1 179.17,248.71
X$8463 \$3868 VIA_M1M2_PR
* cell instance $8464 r0 *1 179.17,245.31
X$8464 \$3868 VIA_M1M2_PR
* cell instance $8465 r0 *1 175.03,238.85
X$8465 \$3868 VIA_M1M2_PR
* cell instance $8466 r0 *1 175.03,244.29
X$8466 \$3868 VIA_M1M2_PR
* cell instance $8467 r0 *1 177.33,245.31
X$8467 \$3868 VIA_M1M2_PR
* cell instance $8468 r0 *1 177.33,244.29
X$8468 \$3868 VIA_M1M2_PR
* cell instance $8469 r0 *1 177.79,244.29
X$8469 \$3868 VIA_L1M1_PR_MR
* cell instance $8470 r0 *1 175.95,245.31
X$8470 \$3868 VIA_L1M1_PR_MR
* cell instance $8471 r0 *1 181.93,245.31
X$8471 \$3868 VIA_L1M1_PR_MR
* cell instance $8472 r0 *1 179.17,251.43
X$8472 \$3868 VIA_L1M1_PR_MR
* cell instance $8473 r0 *1 177.79,248.71
X$8473 \$3868 VIA_L1M1_PR_MR
* cell instance $8474 r0 *1 181.47,249.39
X$8474 \$3868 VIA_L1M1_PR_MR
* cell instance $8475 r0 *1 179.17,248.71
X$8475 \$3868 VIA_L1M1_PR_MR
* cell instance $8476 r0 *1 177.79,255.17
X$8476 \$3868 VIA_L1M1_PR_MR
* cell instance $8477 r0 *1 166.29,249.39
X$8477 \$3868 VIA_L1M1_PR_MR
* cell instance $8478 r0 *1 171.81,257.21
X$8478 \$3868 VIA_L1M1_PR_MR
* cell instance $8479 r0 *1 173.65,259.93
X$8479 \$3868 VIA_L1M1_PR_MR
* cell instance $8480 r0 *1 179.17,245.31
X$8480 \$3868 VIA_L1M1_PR_MR
* cell instance $8481 r0 *1 175.03,238.85
X$8481 \$3868 VIA_L1M1_PR_MR
* cell instance $8482 r0 *1 179.17,241.57
X$8482 \$3874 VIA_M1M2_PR
* cell instance $8483 r0 *1 179.17,242.59
X$8483 \$3874 VIA_M1M2_PR
* cell instance $8484 r0 *1 170.89,225.25
X$8484 \$3874 VIA_M1M2_PR
* cell instance $8485 r0 *1 170.89,241.57
X$8485 \$3874 VIA_M1M2_PR
* cell instance $8486 r0 *1 170.89,225.25
X$8486 \$3874 VIA_L1M1_PR_MR
* cell instance $8487 r0 *1 177.79,242.59
X$8487 \$3874 VIA_L1M1_PR_MR
* cell instance $8488 r0 *1 172.73,241.23
X$8488 \$3882 VIA_M1M2_PR
* cell instance $8489 r0 *1 172.73,243.61
X$8489 \$3882 VIA_M1M2_PR
* cell instance $8490 r0 *1 170.385,243.61
X$8490 \$3882 VIA_L1M1_PR_MR
* cell instance $8491 r0 *1 173.65,241.23
X$8491 \$3882 VIA_L1M1_PR_MR
* cell instance $8492 r0 *1 169.51,240.55
X$8492 \$3886 VIA_L1M1_PR_MR
* cell instance $8493 r0 *1 172.27,240.55
X$8493 \$3886 VIA_L1M1_PR_MR
* cell instance $8494 r0 *1 116.15,281.35
X$8494 \$3889 VIA_M1M2_PR
* cell instance $8495 r0 *1 116.15,284.07
X$8495 \$3889 VIA_M1M2_PR
* cell instance $8496 r0 *1 113.85,281.35
X$8496 \$3889 VIA_M1M2_PR
* cell instance $8497 r0 *1 113.85,273.53
X$8497 \$3889 VIA_M1M2_PR
* cell instance $8498 r0 *1 113.85,278.97
X$8498 \$3889 VIA_M1M2_PR
* cell instance $8499 r0 *1 113.85,243.61
X$8499 \$3889 VIA_M1M2_PR
* cell instance $8500 r0 *1 113.85,251.43
X$8500 \$3889 VIA_M1M2_PR
* cell instance $8501 r0 *1 113.85,259.59
X$8501 \$3889 VIA_M1M2_PR
* cell instance $8502 r0 *1 117.99,251.43
X$8502 \$3889 VIA_L1M1_PR_MR
* cell instance $8503 r0 *1 113.85,259.59
X$8503 \$3889 VIA_L1M1_PR_MR
* cell instance $8504 r0 *1 115.23,251.43
X$8504 \$3889 VIA_L1M1_PR_MR
* cell instance $8505 r0 *1 114.31,243.61
X$8505 \$3889 VIA_L1M1_PR_MR
* cell instance $8506 r0 *1 116.15,281.35
X$8506 \$3889 VIA_L1M1_PR_MR
* cell instance $8507 r0 *1 116.15,284.07
X$8507 \$3889 VIA_L1M1_PR_MR
* cell instance $8508 r0 *1 114.31,273.53
X$8508 \$3889 VIA_L1M1_PR_MR
* cell instance $8509 r0 *1 116.61,278.97
X$8509 \$3889 VIA_L1M1_PR_MR
* cell instance $8510 r0 *1 115.23,240.21
X$8510 \$3892 VIA_L1M1_PR_MR
* cell instance $8511 r0 *1 117.53,240.21
X$8511 \$3892 VIA_L1M1_PR_MR
* cell instance $8512 r0 *1 115.69,245.99
X$8512 \$3902 VIA_M1M2_PR
* cell instance $8513 r0 *1 115.69,248.37
X$8513 \$3902 VIA_M1M2_PR
* cell instance $8514 r0 *1 123.05,244.29
X$8514 \$3902 VIA_M1M2_PR
* cell instance $8515 r0 *1 123.05,248.37
X$8515 \$3902 VIA_M1M2_PR
* cell instance $8516 r0 *1 123.05,249.05
X$8516 \$3902 VIA_M1M2_PR
* cell instance $8517 r0 *1 124.89,249.05
X$8517 \$3902 VIA_L1M1_PR_MR
* cell instance $8518 r0 *1 117.53,248.37
X$8518 \$3902 VIA_L1M1_PR_MR
* cell instance $8519 r0 *1 123.05,244.29
X$8519 \$3902 VIA_L1M1_PR_MR
* cell instance $8520 r0 *1 115.69,245.99
X$8520 \$3902 VIA_L1M1_PR_MR
* cell instance $8521 r0 *1 118.91,248.71
X$8521 \$3906 VIA_M1M2_PR
* cell instance $8522 r0 *1 118.91,247.01
X$8522 \$3906 VIA_M1M2_PR
* cell instance $8523 r0 *1 118.91,254.49
X$8523 \$3906 VIA_M1M2_PR
* cell instance $8524 r0 *1 118.91,252.11
X$8524 \$3906 VIA_M1M2_PR
* cell instance $8525 r0 *1 118.91,248.71
X$8525 \$3906 VIA_L1M1_PR_MR
* cell instance $8526 r0 *1 122.59,251.43
X$8526 \$3906 VIA_L1M1_PR_MR
* cell instance $8527 r0 *1 117.07,247.01
X$8527 \$3906 VIA_L1M1_PR_MR
* cell instance $8528 r0 *1 118.91,254.49
X$8528 \$3906 VIA_L1M1_PR_MR
* cell instance $8529 r0 *1 117.99,246.33
X$8529 \$3907 VIA_M1M2_PR
* cell instance $8530 r0 *1 117.99,253.47
X$8530 \$3907 VIA_M1M2_PR
* cell instance $8531 r0 *1 117.99,248.03
X$8531 \$3907 VIA_M1M2_PR
* cell instance $8532 r0 *1 117.99,253.47
X$8532 \$3907 VIA_L1M1_PR_MR
* cell instance $8533 r0 *1 114.31,246.33
X$8533 \$3907 VIA_L1M1_PR_MR
* cell instance $8534 r0 *1 125.35,248.37
X$8534 \$3907 VIA_L1M1_PR_MR
* cell instance $8535 r0 *1 181.47,285.94
X$8535 success VIA_M2M3_PR
* cell instance $8536 r0 *1 171.81,278.29
X$8536 success VIA_M1M2_PR
* cell instance $8537 r0 *1 162.61,249.39
X$8537 success VIA_M1M2_PR
* cell instance $8538 r0 *1 162.61,251.77
X$8538 success VIA_M1M2_PR
* cell instance $8539 r0 *1 171.81,252.45
X$8539 success VIA_M1M2_PR
* cell instance $8540 r0 *1 181.47,282.37
X$8540 success VIA_M1M2_PR
* cell instance $8541 r0 *1 181.47,278.29
X$8541 success VIA_M1M2_PR
* cell instance $8542 r0 *1 181.01,282.37
X$8542 success VIA_L1M1_PR_MR
* cell instance $8543 r0 *1 174.67,278.63
X$8543 success VIA_L1M1_PR_MR
* cell instance $8544 r0 *1 163.99,251.77
X$8544 success VIA_L1M1_PR_MR
* cell instance $8545 r0 *1 163.07,249.05
X$8545 success VIA_L1M1_PR_MR
* cell instance $8546 r0 *1 165.37,252.45
X$8546 success VIA_L1M1_PR_MR
* cell instance $8547 r0 *1 165.83,250.75
X$8547 \$3913 VIA_M1M2_PR
* cell instance $8548 r0 *1 165.83,246.33
X$8548 \$3913 VIA_M1M2_PR
* cell instance $8549 r0 *1 163.99,245.99
X$8549 \$3913 VIA_L1M1_PR_MR
* cell instance $8550 r0 *1 166.75,250.75
X$8550 \$3913 VIA_L1M1_PR_MR
* cell instance $8551 r0 *1 173.65,256.19
X$8551 \$3918 VIA_M1M2_PR
* cell instance $8552 r0 *1 174.11,249.05
X$8552 \$3918 VIA_M1M2_PR
* cell instance $8553 r0 *1 173.65,256.19
X$8553 \$3918 VIA_L1M1_PR_MR
* cell instance $8554 r0 *1 174.155,249.05
X$8554 \$3918 VIA_L1M1_PR_MR
* cell instance $8555 r0 *1 178.71,251.77
X$8555 \$3942 VIA_M1M2_PR
* cell instance $8556 r0 *1 178.71,246.33
X$8556 \$3942 VIA_M1M2_PR
* cell instance $8557 r0 *1 178.71,251.77
X$8557 \$3942 VIA_L1M1_PR_MR
* cell instance $8558 r0 *1 174.57,246.33
X$8558 \$3942 VIA_L1M1_PR_MR
* cell instance $8559 r0 *1 124.43,248.03
X$8559 \$3951 VIA_M1M2_PR
* cell instance $8560 r0 *1 124.43,245.65
X$8560 \$3951 VIA_M1M2_PR
* cell instance $8561 r0 *1 124.43,245.65
X$8561 \$3951 VIA_L1M1_PR_MR
* cell instance $8562 r0 *1 127.19,248.03
X$8562 \$3951 VIA_L1M1_PR_MR
* cell instance $8563 r0 *1 166.75,248.71
X$8563 \$3955 VIA_M1M2_PR
* cell instance $8564 r0 *1 166.75,245.99
X$8564 \$3955 VIA_M1M2_PR
* cell instance $8565 r0 *1 166.75,245.99
X$8565 \$3955 VIA_L1M1_PR_MR
* cell instance $8566 r0 *1 162.61,248.71
X$8566 \$3955 VIA_L1M1_PR_MR
* cell instance $8567 r0 *1 174.57,275.57
X$8567 \$3981 VIA_M1M2_PR
* cell instance $8568 r0 *1 174.57,274.21
X$8568 \$3981 VIA_M1M2_PR
* cell instance $8569 r0 *1 167.67,275.57
X$8569 \$3981 VIA_M1M2_PR
* cell instance $8570 r0 *1 167.67,251.43
X$8570 \$3981 VIA_M1M2_PR
* cell instance $8571 r0 *1 168.13,245.99
X$8571 \$3981 VIA_M1M2_PR
* cell instance $8572 r0 *1 176.87,274.21
X$8572 \$3981 VIA_L1M1_PR_MR
* cell instance $8573 r0 *1 172.645,275.91
X$8573 \$3981 VIA_L1M1_PR_MR
* cell instance $8574 r0 *1 168.13,245.99
X$8574 \$3981 VIA_L1M1_PR_MR
* cell instance $8575 r0 *1 167.67,251.43
X$8575 \$3981 VIA_L1M1_PR_MR
* cell instance $8576 r0 *1 163.225,251.43
X$8576 \$3981 VIA_L1M1_PR_MR
* cell instance $8577 r0 *1 175.03,252.11
X$8577 \$3994 VIA_M1M2_PR
* cell instance $8578 r0 *1 175.03,254.49
X$8578 \$3994 VIA_M1M2_PR
* cell instance $8579 r0 *1 175.075,254.49
X$8579 \$3994 VIA_L1M1_PR_MR
* cell instance $8580 r0 *1 180.55,252.11
X$8580 \$3994 VIA_L1M1_PR_MR
* cell instance $8581 r0 *1 168.59,251.09
X$8581 \$4002 VIA_M1M2_PR
* cell instance $8582 r0 *1 168.59,243.95
X$8582 \$4002 VIA_M1M2_PR
* cell instance $8583 r0 *1 168.59,243.95
X$8583 \$4002 VIA_L1M1_PR_MR
* cell instance $8584 r0 *1 171.195,251.09
X$8584 \$4002 VIA_L1M1_PR_MR
* cell instance $8585 r0 *1 123.05,251.43
X$8585 \$4020 VIA_M1M2_PR
* cell instance $8586 r0 *1 122.59,254.15
X$8586 \$4020 VIA_M1M2_PR
* cell instance $8587 r0 *1 124.43,251.43
X$8587 \$4020 VIA_L1M1_PR_MR
* cell instance $8588 r0 *1 121.67,254.15
X$8588 \$4020 VIA_L1M1_PR_MR
* cell instance $8589 r0 *1 120.29,254.49
X$8589 \$4020 VIA_L1M1_PR_MR
* cell instance $8590 r0 *1 126.27,248.71
X$8590 \$4022 VIA_M1M2_PR
* cell instance $8591 r0 *1 126.27,250.75
X$8591 \$4022 VIA_M1M2_PR
* cell instance $8592 r0 *1 124.89,250.75
X$8592 \$4022 VIA_L1M1_PR_MR
* cell instance $8593 r0 *1 126.27,248.71
X$8593 \$4022 VIA_L1M1_PR_MR
* cell instance $8594 r0 *1 117.53,256.53
X$8594 \$4030 VIA_L1M1_PR_MR
* cell instance $8595 r0 *1 108.79,257.55
X$8595 \$4030 VIA_L1M1_PR_MR
* cell instance $8596 r0 *1 112.93,257.89
X$8596 \$4031 VIA_M1M2_PR
* cell instance $8597 r0 *1 112.93,259.59
X$8597 \$4031 VIA_M1M2_PR
* cell instance $8598 r0 *1 124.89,261.97
X$8598 \$4031 VIA_M1M2_PR
* cell instance $8599 r0 *1 124.89,257.89
X$8599 \$4031 VIA_M1M2_PR
* cell instance $8600 r0 *1 124.89,257.89
X$8600 \$4031 VIA_L1M1_PR_MR
* cell instance $8601 r0 *1 120.29,261.97
X$8601 \$4031 VIA_L1M1_PR_MR
* cell instance $8602 r0 *1 114.77,256.87
X$8602 \$4031 VIA_L1M1_PR_MR
* cell instance $8603 r0 *1 112.93,259.59
X$8603 \$4031 VIA_L1M1_PR_MR
* cell instance $8604 r0 *1 122.59,254.66
X$8604 \$4032 VIA_M2M3_PR
* cell instance $8605 r0 *1 124.89,254.66
X$8605 \$4032 VIA_M2M3_PR
* cell instance $8606 r0 *1 118.45,254.83
X$8606 \$4032 VIA_M1M2_PR
* cell instance $8607 r0 *1 115.69,254.83
X$8607 \$4032 VIA_M1M2_PR
* cell instance $8608 r0 *1 118.45,261.97
X$8608 \$4032 VIA_M1M2_PR
* cell instance $8609 r0 *1 115.69,256.87
X$8609 \$4032 VIA_M1M2_PR
* cell instance $8610 r0 *1 122.59,254.83
X$8610 \$4032 VIA_M1M2_PR
* cell instance $8611 r0 *1 124.89,254.83
X$8611 \$4032 VIA_M1M2_PR
* cell instance $8612 r0 *1 118.45,261.97
X$8612 \$4032 VIA_L1M1_PR_MR
* cell instance $8613 r0 *1 115.69,256.87
X$8613 \$4032 VIA_L1M1_PR_MR
* cell instance $8614 r0 *1 125.35,254.83
X$8614 \$4032 VIA_L1M1_PR_MR
* cell instance $8615 r0 *1 161.69,256.53
X$8615 \$4041 VIA_M1M2_PR
* cell instance $8616 r0 *1 161.69,250.75
X$8616 \$4041 VIA_M1M2_PR
* cell instance $8617 r0 *1 166.29,256.87
X$8617 \$4041 VIA_L1M1_PR_MR
* cell instance $8618 r0 *1 161.69,250.75
X$8618 \$4041 VIA_L1M1_PR_MR
* cell instance $8619 r0 *1 111.09,259.25
X$8619 \$4090 VIA_M1M2_PR
* cell instance $8620 r0 *1 111.09,256.87
X$8620 \$4090 VIA_M1M2_PR
* cell instance $8621 r0 *1 116.61,260.61
X$8621 \$4090 VIA_M1M2_PR
* cell instance $8622 r0 *1 116.61,262.31
X$8622 \$4090 VIA_M1M2_PR
* cell instance $8623 r0 *1 122.59,260.61
X$8623 \$4090 VIA_L1M1_PR_MR
* cell instance $8624 r0 *1 116.61,262.31
X$8624 \$4090 VIA_L1M1_PR_MR
* cell instance $8625 r0 *1 111.09,256.87
X$8625 \$4090 VIA_L1M1_PR_MR
* cell instance $8626 r0 *1 111.55,259.25
X$8626 \$4090 VIA_L1M1_PR_MR
* cell instance $8627 r0 *1 109.71,257.21
X$8627 \$4119 VIA_M1M2_PR
* cell instance $8628 r0 *1 109.71,262.65
X$8628 \$4119 VIA_M1M2_PR
* cell instance $8629 r0 *1 117.53,262.65
X$8629 \$4119 VIA_L1M1_PR_MR
* cell instance $8630 r0 *1 109.71,257.21
X$8630 \$4119 VIA_L1M1_PR_MR
* cell instance $8631 r0 *1 115.23,257.89
X$8631 \$4123 VIA_M1M2_PR
* cell instance $8632 r0 *1 115.23,262.31
X$8632 \$4123 VIA_M1M2_PR
* cell instance $8633 r0 *1 115.23,262.31
X$8633 \$4123 VIA_L1M1_PR_MR
* cell instance $8634 r0 *1 115.23,257.89
X$8634 \$4123 VIA_L1M1_PR_MR
* cell instance $8635 r0 *1 110.63,257.21
X$8635 \$4123 VIA_L1M1_PR_MR
* cell instance $8636 r0 *1 112.47,257.21
X$8636 \$4123 VIA_L1M1_PR_MR
* cell instance $8637 r0 *1 115.69,261.97
X$8637 \$4127 VIA_M1M2_PR
* cell instance $8638 r0 *1 115.69,260.27
X$8638 \$4127 VIA_M1M2_PR
* cell instance $8639 r0 *1 115.23,260.27
X$8639 \$4127 VIA_L1M1_PR_MR
* cell instance $8640 r0 *1 115.69,261.97
X$8640 \$4127 VIA_L1M1_PR_MR
* cell instance $8641 r0 *1 114.77,267.75
X$8641 \$4142 VIA_M1M2_PR
* cell instance $8642 r0 *1 114.77,271.49
X$8642 \$4142 VIA_M1M2_PR
* cell instance $8643 r0 *1 114.77,272.51
X$8643 \$4142 VIA_M1M2_PR
* cell instance $8644 r0 *1 114.77,267.75
X$8644 \$4142 VIA_L1M1_PR_MR
* cell instance $8645 r0 *1 112.93,273.19
X$8645 \$4142 VIA_L1M1_PR_MR
* cell instance $8646 r0 *1 114.77,271.49
X$8646 \$4142 VIA_L1M1_PR_MR
* cell instance $8647 r0 *1 111.55,272.51
X$8647 \$4148 VIA_M1M2_PR
* cell instance $8648 r0 *1 111.55,271.15
X$8648 \$4148 VIA_M1M2_PR
* cell instance $8649 r0 *1 111.55,272.51
X$8649 \$4148 VIA_L1M1_PR_MR
* cell instance $8650 r0 *1 118.91,270.81
X$8650 \$4148 VIA_L1M1_PR_MR
* cell instance $8651 r0 *1 113.39,276.59
X$8651 \$4168 VIA_M1M2_PR
* cell instance $8652 r0 *1 113.39,281.69
X$8652 \$4168 VIA_M1M2_PR
* cell instance $8653 r0 *1 121.67,270.81
X$8653 \$4168 VIA_M1M2_PR
* cell instance $8654 r0 *1 121.67,282.37
X$8654 \$4168 VIA_M1M2_PR
* cell instance $8655 r0 *1 112.47,276.59
X$8655 \$4168 VIA_L1M1_PR_MR
* cell instance $8656 r0 *1 120.29,270.81
X$8656 \$4168 VIA_L1M1_PR_MR
* cell instance $8657 r0 *1 115.69,281.69
X$8657 \$4168 VIA_L1M1_PR_MR
* cell instance $8658 r0 *1 124.89,282.37
X$8658 \$4168 VIA_L1M1_PR_MR
* cell instance $8659 r0 *1 117.99,281.35
X$8659 \$4171 VIA_M1M2_PR
* cell instance $8660 r0 *1 118.45,271.49
X$8660 \$4171 VIA_M1M2_PR
* cell instance $8661 r0 *1 117.99,271.49
X$8661 \$4171 VIA_L1M1_PR_MR
* cell instance $8662 r0 *1 117.53,281.35
X$8662 \$4171 VIA_L1M1_PR_MR
* cell instance $8663 r0 *1 112.93,270.47
X$8663 \$4173 VIA_M1M2_PR
* cell instance $8664 r0 *1 112.93,276.25
X$8664 \$4173 VIA_M1M2_PR
* cell instance $8665 r0 *1 112.93,268.43
X$8665 \$4173 VIA_M1M2_PR
* cell instance $8666 r0 *1 115.69,268.43
X$8666 \$4173 VIA_L1M1_PR_MR
* cell instance $8667 r0 *1 119.83,270.47
X$8667 \$4173 VIA_L1M1_PR_MR
* cell instance $8668 r0 *1 112.93,276.25
X$8668 \$4173 VIA_L1M1_PR_MR
* cell instance $8669 r0 *1 115.23,267.75
X$8669 \$4180 VIA_M1M2_PR
* cell instance $8670 r0 *1 115.23,272.85
X$8670 \$4180 VIA_M1M2_PR
* cell instance $8671 r0 *1 116.61,267.75
X$8671 \$4180 VIA_L1M1_PR_MR
* cell instance $8672 r0 *1 113.85,272.85
X$8672 \$4180 VIA_L1M1_PR_MR
* cell instance $8673 r0 *1 115.23,267.75
X$8673 \$4180 VIA_L1M1_PR_MR
* cell instance $8674 r0 *1 114.31,274.21
X$8674 \$4187 VIA_M1M2_PR
* cell instance $8675 r0 *1 110.63,277.95
X$8675 \$4187 VIA_M1M2_PR
* cell instance $8676 r0 *1 110.63,274.21
X$8676 \$4187 VIA_M1M2_PR
* cell instance $8677 r0 *1 114.77,282.03
X$8677 \$4187 VIA_M1M2_PR
* cell instance $8678 r0 *1 112.47,274.21
X$8678 \$4187 VIA_L1M1_PR_MR
* cell instance $8679 r0 *1 107.41,278.63
X$8679 \$4187 VIA_L1M1_PR_MR
* cell instance $8680 r0 *1 115.23,282.03
X$8680 \$4187 VIA_L1M1_PR_MR
* cell instance $8681 r0 *1 113.85,274.21
X$8681 \$4187 VIA_L1M1_PR_MR
* cell instance $8682 r0 *1 110.63,276.59
X$8682 \$4188 VIA_L1M1_PR_MR
* cell instance $8683 r0 *1 121.67,276.59
X$8683 \$4188 VIA_L1M1_PR_MR
* cell instance $8684 r0 *1 111.55,276.25
X$8684 \$4189 VIA_M1M2_PR
* cell instance $8685 r0 *1 111.55,277.95
X$8685 \$4189 VIA_M1M2_PR
* cell instance $8686 r0 *1 111.55,273.19
X$8686 \$4189 VIA_M1M2_PR
* cell instance $8687 r0 *1 108.33,278.63
X$8687 \$4189 VIA_L1M1_PR_MR
* cell instance $8688 r0 *1 112.47,273.19
X$8688 \$4189 VIA_L1M1_PR_MR
* cell instance $8689 r0 *1 111.55,276.25
X$8689 \$4189 VIA_L1M1_PR_MR
* cell instance $8690 r0 *1 114.31,275.91
X$8690 \$4189 VIA_L1M1_PR_MR
* cell instance $8691 r0 *1 110.17,278.29
X$8691 \$4192 VIA_M1M2_PR
* cell instance $8692 r0 *1 110.17,273.87
X$8692 \$4192 VIA_M1M2_PR
* cell instance $8693 r0 *1 110.17,278.29
X$8693 \$4192 VIA_L1M1_PR_MR
* cell instance $8694 r0 *1 115.69,273.53
X$8694 \$4192 VIA_L1M1_PR_MR
* cell instance $8695 r0 *1 114.77,274.21
X$8695 \$4196 VIA_M1M2_PR
* cell instance $8696 r0 *1 114.77,275.23
X$8696 \$4196 VIA_M1M2_PR
* cell instance $8697 r0 *1 111.09,278.63
X$8697 \$4196 VIA_M1M2_PR
* cell instance $8698 r0 *1 111.09,275.23
X$8698 \$4196 VIA_M1M2_PR
* cell instance $8699 r0 *1 111.09,281.69
X$8699 \$4196 VIA_M1M2_PR
* cell instance $8700 r0 *1 124.43,275.57
X$8700 \$4196 VIA_M1M2_PR
* cell instance $8701 r0 *1 124.43,274.21
X$8701 \$4196 VIA_M1M2_PR
* cell instance $8702 r0 *1 111.09,278.63
X$8702 \$4196 VIA_L1M1_PR_MR
* cell instance $8703 r0 *1 110.17,281.69
X$8703 \$4196 VIA_L1M1_PR_MR
* cell instance $8704 r0 *1 124.43,275.57
X$8704 \$4196 VIA_L1M1_PR_MR
* cell instance $8705 r0 *1 123.05,274.21
X$8705 \$4196 VIA_L1M1_PR_MR
* cell instance $8706 r0 *1 115.69,278.63
X$8706 \$4197 VIA_M1M2_PR
* cell instance $8707 r0 *1 115.69,277.95
X$8707 \$4197 VIA_M1M2_PR
* cell instance $8708 r0 *1 126.27,281.69
X$8708 \$4197 VIA_M1M2_PR
* cell instance $8709 r0 *1 126.27,276.59
X$8709 \$4197 VIA_M1M2_PR
* cell instance $8710 r0 *1 126.27,277.95
X$8710 \$4197 VIA_M1M2_PR
* cell instance $8711 r0 *1 128.57,281.69
X$8711 \$4197 VIA_L1M1_PR_MR
* cell instance $8712 r0 *1 126.27,276.59
X$8712 \$4197 VIA_L1M1_PR_MR
* cell instance $8713 r0 *1 125.35,277.95
X$8713 \$4197 VIA_L1M1_PR_MR
* cell instance $8714 r0 *1 115.23,278.63
X$8714 \$4197 VIA_L1M1_PR_MR
* cell instance $8715 r0 *1 173.19,271.49
X$8715 \$4203 VIA_M1M2_PR
* cell instance $8716 r0 *1 173.19,275.91
X$8716 \$4203 VIA_M1M2_PR
* cell instance $8717 r0 *1 173.19,277.95
X$8717 \$4203 VIA_M1M2_PR
* cell instance $8718 r0 *1 173.19,271.49
X$8718 \$4203 VIA_L1M1_PR_MR
* cell instance $8719 r0 *1 173.65,275.91
X$8719 \$4203 VIA_L1M1_PR_MR
* cell instance $8720 r0 *1 173.65,277.95
X$8720 \$4203 VIA_L1M1_PR_MR
* cell instance $8721 r0 *1 173.19,276.93
X$8721 \$4210 VIA_L1M1_PR_MR
* cell instance $8722 r0 *1 175.03,276.93
X$8722 \$4210 VIA_L1M1_PR_MR
* cell instance $8723 r0 *1 169.51,275.23
X$8723 \$4214 VIA_M1M2_PR
* cell instance $8724 r0 *1 169.51,272.85
X$8724 \$4214 VIA_M1M2_PR
* cell instance $8725 r0 *1 170.43,275.23
X$8725 \$4214 VIA_L1M1_PR_MR
* cell instance $8726 r0 *1 169.51,272.85
X$8726 \$4214 VIA_L1M1_PR_MR
* cell instance $8727 r0 *1 110.63,281.01
X$8727 \$4238 VIA_M1M2_PR
* cell instance $8728 r0 *1 110.63,278.97
X$8728 \$4238 VIA_M1M2_PR
* cell instance $8729 r0 *1 112.47,278.63
X$8729 \$4238 VIA_L1M1_PR_MR
* cell instance $8730 r0 *1 109.71,278.97
X$8730 \$4238 VIA_L1M1_PR_MR
* cell instance $8731 r0 *1 110.63,281.01
X$8731 \$4238 VIA_L1M1_PR_MR
* cell instance $8732 r0 *1 112.47,281.18
X$8732 \$4240 VIA_M2M3_PR
* cell instance $8733 r0 *1 125.81,281.18
X$8733 \$4240 VIA_M2M3_PR
* cell instance $8734 r0 *1 112.47,281.35
X$8734 \$4240 VIA_M1M2_PR
* cell instance $8735 r0 *1 125.81,281.01
X$8735 \$4240 VIA_M1M2_PR
* cell instance $8736 r0 *1 111.55,281.35
X$8736 \$4240 VIA_L1M1_PR_MR
* cell instance $8737 r0 *1 125.81,281.01
X$8737 \$4240 VIA_L1M1_PR_MR
* cell instance $8738 r0 *1 116.15,279.14
X$8738 \$4242 VIA_M2M3_PR
* cell instance $8739 r0 *1 126.73,279.14
X$8739 \$4242 VIA_M2M3_PR
* cell instance $8740 r0 *1 116.15,278.63
X$8740 \$4242 VIA_M1M2_PR
* cell instance $8741 r0 *1 114.77,284.41
X$8741 \$4242 VIA_M1M2_PR
* cell instance $8742 r0 *1 126.73,282.03
X$8742 \$4242 VIA_M1M2_PR
* cell instance $8743 r0 *1 126.73,282.03
X$8743 \$4242 VIA_L1M1_PR_MR
* cell instance $8744 r0 *1 114.77,284.41
X$8744 \$4242 VIA_L1M1_PR_MR
* cell instance $8745 r0 *1 116.15,278.63
X$8745 \$4242 VIA_L1M1_PR_MR
* cell instance $8746 r0 *1 112.47,279.31
X$8746 \$4245 VIA_M1M2_PR
* cell instance $8747 r0 *1 112.47,280.67
X$8747 \$4245 VIA_M1M2_PR
* cell instance $8748 r0 *1 112.47,280.67
X$8748 \$4245 VIA_L1M1_PR_MR
* cell instance $8749 r0 *1 117.99,278.97
X$8749 \$4245 VIA_L1M1_PR_MR
* cell instance $8750 r0 *1 174.11,278.63
X$8750 \$4252 VIA_M1M2_PR
* cell instance $8751 r0 *1 174.11,276.25
X$8751 \$4252 VIA_M1M2_PR
* cell instance $8752 r0 *1 172.73,278.63
X$8752 \$4252 VIA_L1M1_PR_MR
* cell instance $8753 r0 *1 174.11,276.25
X$8753 \$4252 VIA_L1M1_PR_MR
* cell instance $8754 r0 *1 173.19,278.63
X$8754 \$4252 VIA_L1M1_PR_MR
* cell instance $8755 r0 *1 171.35,278.97
X$8755 \$4255 VIA_M1M2_PR
* cell instance $8756 r0 *1 171.35,280.67
X$8756 \$4255 VIA_M1M2_PR
* cell instance $8757 r0 *1 171.35,276.59
X$8757 \$4255 VIA_M1M2_PR
* cell instance $8758 r0 *1 175.95,278.63
X$8758 \$4255 VIA_L1M1_PR_MR
* cell instance $8759 r0 *1 171.35,276.59
X$8759 \$4255 VIA_L1M1_PR_MR
* cell instance $8760 r0 *1 170.89,280.67
X$8760 \$4255 VIA_L1M1_PR_MR
* cell instance $8761 r0 *1 173.65,279.65
X$8761 \$4257 VIA_M1M2_PR
* cell instance $8762 r0 *1 173.65,281.35
X$8762 \$4257 VIA_M1M2_PR
* cell instance $8763 r0 *1 175.95,279.65
X$8763 \$4257 VIA_L1M1_PR_MR
* cell instance $8764 r0 *1 173.65,281.35
X$8764 \$4257 VIA_L1M1_PR_MR
* cell instance $8765 r0 *1 112.01,287.13
X$8765 \$4285 VIA_M1M2_PR
* cell instance $8766 r0 *1 112.01,285.09
X$8766 \$4285 VIA_M1M2_PR
* cell instance $8767 r0 *1 112.01,284.41
X$8767 \$4285 VIA_M1M2_PR
* cell instance $8768 r0 *1 129.49,287.13
X$8768 \$4285 VIA_M1M2_PR
* cell instance $8769 r0 *1 129.49,285.09
X$8769 \$4285 VIA_M1M2_PR
* cell instance $8770 r0 *1 107.87,283.73
X$8770 \$4285 VIA_L1M1_PR_MR
* cell instance $8771 r0 *1 112.01,287.13
X$8771 \$4285 VIA_L1M1_PR_MR
* cell instance $8772 r0 *1 129.49,287.13
X$8772 \$4285 VIA_L1M1_PR_MR
* cell instance $8773 r0 *1 124.89,285.09
X$8773 \$4285 VIA_L1M1_PR_MR
* cell instance $8774 r0 *1 111.09,285.09
X$8774 \$4287 VIA_M1M2_PR
* cell instance $8775 r0 *1 111.09,286.11
X$8775 \$4287 VIA_M1M2_PR
* cell instance $8776 r0 *1 110.63,285.09
X$8776 \$4287 VIA_L1M1_PR_MR
* cell instance $8777 r0 *1 121.67,286.79
X$8777 \$4287 VIA_L1M1_PR_MR
* cell instance $8778 r0 *1 109.71,284.75
X$8778 \$4290 VIA_M1M2_PR
* cell instance $8779 r0 *1 109.71,286.11
X$8779 \$4290 VIA_M1M2_PR
* cell instance $8780 r0 *1 106.03,286.11
X$8780 \$4290 VIA_L1M1_PR_MR
* cell instance $8781 r0 *1 117.53,284.41
X$8781 \$4290 VIA_L1M1_PR_MR
* cell instance $8782 r0 *1 115.23,287.13
X$8782 \$4294 VIA_M1M2_PR
* cell instance $8783 r0 *1 115.23,286.11
X$8783 \$4294 VIA_M1M2_PR
* cell instance $8784 r0 *1 127.65,284.41
X$8784 \$4294 VIA_M1M2_PR
* cell instance $8785 r0 *1 127.65,287.13
X$8785 \$4294 VIA_M1M2_PR
* cell instance $8786 r0 *1 127.65,284.41
X$8786 \$4294 VIA_L1M1_PR_MR
* cell instance $8787 r0 *1 127.65,287.13
X$8787 \$4294 VIA_L1M1_PR_MR
* cell instance $8788 r0 *1 112.93,287.13
X$8788 \$4294 VIA_L1M1_PR_MR
* cell instance $8789 r0 *1 169.51,283.73
X$8789 \$4316 VIA_M1M2_PR
* cell instance $8790 r0 *1 169.51,282.03
X$8790 \$4316 VIA_M1M2_PR
* cell instance $8791 r0 *1 169.51,283.73
X$8791 \$4316 VIA_L1M1_PR_MR
* cell instance $8792 r0 *1 168.59,282.03
X$8792 \$4316 VIA_L1M1_PR_MR
* cell instance $8793 r0 *1 108.33,287.13
X$8793 \$4318 VIA_M1M2_PR
* cell instance $8794 r0 *1 108.33,284.07
X$8794 \$4318 VIA_M1M2_PR
* cell instance $8795 r0 *1 108.33,284.75
X$8795 \$4318 VIA_M1M2_PR
* cell instance $8796 r0 *1 108.33,286.45
X$8796 \$4318 VIA_M1M2_PR
* cell instance $8797 r0 *1 106.49,284.75
X$8797 \$4318 VIA_L1M1_PR_MR
* cell instance $8798 r0 *1 108.79,284.07
X$8798 \$4318 VIA_L1M1_PR_MR
* cell instance $8799 r0 *1 108.33,287.13
X$8799 \$4318 VIA_L1M1_PR_MR
* cell instance $8800 r0 *1 114.31,286.45
X$8800 \$4318 VIA_L1M1_PR_MR
* cell instance $8801 r0 *1 106.95,287.13
X$8801 \$4346 VIA_L1M1_PR_MR
* cell instance $8802 r0 *1 127.19,287.81
X$8802 \$4346 VIA_L1M1_PR_MR
* cell instance $8803 r0 *1 110.17,284.41
X$8803 \$4352 VIA_M1M2_PR
* cell instance $8804 r0 *1 110.17,286.11
X$8804 \$4352 VIA_M1M2_PR
* cell instance $8805 r0 *1 110.17,284.41
X$8805 \$4352 VIA_L1M1_PR_MR
* cell instance $8806 r0 *1 110.63,286.11
X$8806 \$4352 VIA_L1M1_PR_MR
* cell instance $8807 r0 *1 107.87,286.79
X$8807 \$4352 VIA_L1M1_PR_MR
* cell instance $8808 r0 *1 109.71,286.79
X$8808 \$4352 VIA_L1M1_PR_MR
* cell instance $8809 r0 *1 180.14,10.88
X$8809 VGND VIA_via2_3_2000_480_1_6_320_320
* cell instance $8810 r0 *1 180.14,271.23
X$8810 VGND VIA_via5_6_2000_2000_1_1_1600_1600
* cell instance $8811 r0 *1 60.14,91.23
X$8811 VGND VIA_via5_6_2000_2000_1_1_1600_1600
* cell instance $8812 r0 *1 60.14,211.23
X$8812 VGND VIA_via5_6_2000_2000_1_1_1600_1600
* cell instance $8813 r0 *1 120.14,241.23
X$8813 VGND VIA_via5_6_2000_2000_1_1_1600_1600
* cell instance $8814 r0 *1 180.14,151.23
X$8814 VGND VIA_via5_6_2000_2000_1_1_1600_1600
* cell instance $8815 r0 *1 60.14,31.23
X$8815 VGND VIA_via5_6_2000_2000_1_1_1600_1600
* cell instance $8816 r0 *1 60.14,61.23
X$8816 VGND VIA_via5_6_2000_2000_1_1_1600_1600
* cell instance $8817 r0 *1 30.14,211.23
X$8817 VGND VIA_via5_6_2000_2000_1_1_1600_1600
* cell instance $8818 r0 *1 120.14,181.23
X$8818 VGND VIA_via5_6_2000_2000_1_1_1600_1600
* cell instance $8819 r0 *1 30.14,181.23
X$8819 VGND VIA_via5_6_2000_2000_1_1_1600_1600
* cell instance $8820 r0 *1 30.14,61.23
X$8820 VGND VIA_via5_6_2000_2000_1_1_1600_1600
* cell instance $8821 r0 *1 120.14,211.23
X$8821 VGND VIA_via5_6_2000_2000_1_1_1600_1600
* cell instance $8822 r0 *1 180.14,91.23
X$8822 VGND VIA_via5_6_2000_2000_1_1_1600_1600
* cell instance $8823 r0 *1 60.14,241.23
X$8823 VGND VIA_via5_6_2000_2000_1_1_1600_1600
* cell instance $8824 r0 *1 120.14,31.23
X$8824 VGND VIA_via5_6_2000_2000_1_1_1600_1600
* cell instance $8825 r0 *1 30.14,271.23
X$8825 VGND VIA_via5_6_2000_2000_1_1_1600_1600
* cell instance $8826 r0 *1 30.14,121.23
X$8826 VGND VIA_via5_6_2000_2000_1_1_1600_1600
* cell instance $8827 r0 *1 90.14,91.23
X$8827 VGND VIA_via5_6_2000_2000_1_1_1600_1600
* cell instance $8828 r0 *1 90.14,121.23
X$8828 VGND VIA_via5_6_2000_2000_1_1_1600_1600
* cell instance $8829 r0 *1 120.14,121.23
X$8829 VGND VIA_via5_6_2000_2000_1_1_1600_1600
* cell instance $8830 r0 *1 30.14,91.23
X$8830 VGND VIA_via5_6_2000_2000_1_1_1600_1600
* cell instance $8831 r0 *1 180.14,121.23
X$8831 VGND VIA_via5_6_2000_2000_1_1_1600_1600
* cell instance $8832 r0 *1 150.14,61.23
X$8832 VGND VIA_via5_6_2000_2000_1_1_1600_1600
* cell instance $8833 r0 *1 150.14,271.23
X$8833 VGND VIA_via5_6_2000_2000_1_1_1600_1600
* cell instance $8834 r0 *1 150.14,121.23
X$8834 VGND VIA_via5_6_2000_2000_1_1_1600_1600
* cell instance $8835 r0 *1 150.14,241.23
X$8835 VGND VIA_via5_6_2000_2000_1_1_1600_1600
* cell instance $8836 r0 *1 150.14,211.23
X$8836 VGND VIA_via5_6_2000_2000_1_1_1600_1600
* cell instance $8837 r0 *1 90.14,271.23
X$8837 VGND VIA_via5_6_2000_2000_1_1_1600_1600
* cell instance $8838 r0 *1 150.14,181.23
X$8838 VGND VIA_via5_6_2000_2000_1_1_1600_1600
* cell instance $8839 r0 *1 150.14,151.23
X$8839 VGND VIA_via5_6_2000_2000_1_1_1600_1600
* cell instance $8840 r0 *1 90.14,241.23
X$8840 VGND VIA_via5_6_2000_2000_1_1_1600_1600
* cell instance $8841 r0 *1 90.14,31.23
X$8841 VGND VIA_via5_6_2000_2000_1_1_1600_1600
* cell instance $8842 r0 *1 60.14,271.23
X$8842 VGND VIA_via5_6_2000_2000_1_1_1600_1600
* cell instance $8843 r0 *1 30.14,241.23
X$8843 VGND VIA_via5_6_2000_2000_1_1_1600_1600
* cell instance $8844 r0 *1 150.14,91.23
X$8844 VGND VIA_via5_6_2000_2000_1_1_1600_1600
* cell instance $8845 r0 *1 180.14,31.23
X$8845 VGND VIA_via5_6_2000_2000_1_1_1600_1600
* cell instance $8846 r0 *1 150.14,31.23
X$8846 VGND VIA_via5_6_2000_2000_1_1_1600_1600
* cell instance $8847 r0 *1 30.14,31.23
X$8847 VGND VIA_via5_6_2000_2000_1_1_1600_1600
* cell instance $8848 r0 *1 180.14,181.23
X$8848 VGND VIA_via5_6_2000_2000_1_1_1600_1600
* cell instance $8849 r0 *1 30.14,151.23
X$8849 VGND VIA_via5_6_2000_2000_1_1_1600_1600
* cell instance $8850 r0 *1 90.14,211.23
X$8850 VGND VIA_via5_6_2000_2000_1_1_1600_1600
* cell instance $8851 r0 *1 60.14,181.23
X$8851 VGND VIA_via5_6_2000_2000_1_1_1600_1600
* cell instance $8852 r0 *1 90.14,181.23
X$8852 VGND VIA_via5_6_2000_2000_1_1_1600_1600
* cell instance $8853 r0 *1 120.14,151.23
X$8853 VGND VIA_via5_6_2000_2000_1_1_1600_1600
* cell instance $8854 r0 *1 90.14,61.23
X$8854 VGND VIA_via5_6_2000_2000_1_1_1600_1600
* cell instance $8855 r0 *1 180.14,211.23
X$8855 VGND VIA_via5_6_2000_2000_1_1_1600_1600
* cell instance $8856 r0 *1 180.14,241.23
X$8856 VGND VIA_via5_6_2000_2000_1_1_1600_1600
* cell instance $8857 r0 *1 60.14,121.23
X$8857 VGND VIA_via5_6_2000_2000_1_1_1600_1600
* cell instance $8858 r0 *1 120.14,91.23
X$8858 VGND VIA_via5_6_2000_2000_1_1_1600_1600
* cell instance $8859 r0 *1 180.14,61.23
X$8859 VGND VIA_via5_6_2000_2000_1_1_1600_1600
* cell instance $8860 r0 *1 120.14,61.23
X$8860 VGND VIA_via5_6_2000_2000_1_1_1600_1600
* cell instance $8861 r0 *1 60.14,151.23
X$8861 VGND VIA_via5_6_2000_2000_1_1_1600_1600
* cell instance $8862 r0 *1 120.14,271.23
X$8862 VGND VIA_via5_6_2000_2000_1_1_1600_1600
* cell instance $8863 r0 *1 90.14,151.23
X$8863 VGND VIA_via5_6_2000_2000_1_1_1600_1600
* cell instance $8864 r0 *1 162.15,188.7
X$8864 VGND VIA_M2M3_PR
* cell instance $8865 r0 *1 173.19,207.74
X$8865 VGND VIA_M2M3_PR
* cell instance $8866 r0 *1 162.61,189.38
X$8866 VGND VIA_M2M3_PR
* cell instance $8867 r0 *1 169.05,227.46
X$8867 VGND VIA_M2M3_PR
* cell instance $8868 r0 *1 172.27,227.46
X$8868 VGND VIA_M2M3_PR
* cell instance $8869 r0 *1 161.69,213.86
X$8869 VGND VIA_M2M3_PR
* cell instance $8870 r0 *1 135.47,222.02
X$8870 VGND VIA_M2M3_PR
* cell instance $8871 r0 *1 136.39,207.74
X$8871 VGND VIA_M2M3_PR
* cell instance $8872 r0 *1 166.29,227.46
X$8872 VGND VIA_M2M3_PR
* cell instance $8873 r0 *1 176.41,222.02
X$8873 VGND VIA_M2M3_PR
* cell instance $8874 r0 *1 177.33,213.86
X$8874 VGND VIA_M2M3_PR
* cell instance $8875 r0 *1 136.39,85.85
X$8875 VGND VIA_M1M2_PR
* cell instance $8876 r0 *1 125.81,108.29
X$8876 VGND VIA_M1M2_PR
* cell instance $8877 r0 *1 177.33,213.69
X$8877 VGND VIA_M1M2_PR
* cell instance $8878 r0 *1 173.19,207.91
X$8878 VGND VIA_M1M2_PR
* cell instance $8879 r0 *1 176.41,220.83
X$8879 VGND VIA_M1M2_PR
* cell instance $8880 r0 *1 161.69,213.69
X$8880 VGND VIA_M1M2_PR
* cell instance $8881 r0 *1 160.31,226.27
X$8881 VGND VIA_M1M2_PR
* cell instance $8882 r0 *1 169.05,234.43
X$8882 VGND VIA_M1M2_PR
* cell instance $8883 r0 *1 172.27,227.29
X$8883 VGND VIA_M1M2_PR
* cell instance $8884 r0 *1 166.29,226.27
X$8884 VGND VIA_M1M2_PR
* cell instance $8885 r0 *1 162.61,197.37
X$8885 VGND VIA_M1M2_PR
* cell instance $8886 r0 *1 164.91,180.03
X$8886 VGND VIA_M1M2_PR
* cell instance $8887 r0 *1 164.45,143.65
X$8887 VGND VIA_M1M2_PR
* cell instance $8888 r0 *1 160.31,197.37
X$8888 VGND VIA_M1M2_PR
* cell instance $8889 r0 *1 162.15,180.03
X$8889 VGND VIA_M1M2_PR
* cell instance $8890 r0 *1 129.95,222.19
X$8890 VGND VIA_M1M2_PR
* cell instance $8891 r0 *1 125.81,213.69
X$8891 VGND VIA_M1M2_PR
* cell instance $8892 r0 *1 135.47,127.33
X$8892 VGND VIA_M1M2_PR
* cell instance $8893 r0 *1 129.95,155.55
X$8893 VGND VIA_M1M2_PR
* cell instance $8894 r0 *1 170.43,234.43
X$8894 VGND VIA_L1M1_PR_MR
* cell instance $8895 r0 *1 172.27,227.29
X$8895 VGND VIA_L1M1_PR_MR
* cell instance $8896 r0 *1 172.73,207.91
X$8896 VGND VIA_L1M1_PR_MR
* cell instance $8897 r0 *1 171.35,127.33
X$8897 VGND VIA_L1M1_PR_MR
* cell instance $8898 r0 *1 171.81,143.65
X$8898 VGND VIA_L1M1_PR_MR
* cell instance $8899 r0 *1 169.51,155.55
X$8899 VGND VIA_L1M1_PR_MR
* cell instance $8900 r0 *1 169.97,107.61
X$8900 VGND VIA_L1M1_PR_MR
* cell instance $8901 r0 *1 166.75,85.85
X$8901 VGND VIA_L1M1_PR_MR
* cell instance $8902 r0 *1 178.71,213.69
X$8902 VGND VIA_L1M1_PR_MR
* cell instance $8903 r0 *1 176.51,221.85
X$8903 VGND VIA_L1M1_PR_MR
* cell instance $8904 r0 *1 177.79,222.19
X$8904 VGND VIA_L1M1_PR_MR
* cell instance $8905 r0 *1 30.14,10.88
X$8905 VGND VIA_via3_4_2000_480_1_5_400_400
* cell instance $8906 r0 *1 30.14,10.88
X$8906 VGND VIA_via4_5_2000_480_1_5_400_400
* cell instance $8907 r0 *1 30.14,81.6
X$8907 VGND VIA_via4_5_2000_480_1_5_400_400
* cell instance $8908 r0 *1 30.14,87.04
X$8908 VGND VIA_via4_5_2000_480_1_5_400_400
* cell instance $8909 r0 *1 30.14,92.48
X$8909 VGND VIA_via4_5_2000_480_1_5_400_400
* cell instance $8910 r0 *1 150.14,152.32
X$8910 VGND VIA_via4_5_2000_480_1_5_400_400
* cell instance $8911 r0 *1 150.14,130.56
X$8911 VGND VIA_via4_5_2000_480_1_5_400_400
* cell instance $8912 r0 *1 180.14,114.24
X$8912 VGND VIA_via4_5_2000_480_1_5_400_400
* cell instance $8913 r0 *1 150.14,136
X$8913 VGND VIA_via4_5_2000_480_1_5_400_400
* cell instance $8914 r0 *1 60.14,250.24
X$8914 VGND VIA_via4_5_2000_480_1_5_400_400
* cell instance $8915 r0 *1 120.14,190.4
X$8915 VGND VIA_via4_5_2000_480_1_5_400_400
* cell instance $8916 r0 *1 30.14,97.92
X$8916 VGND VIA_via4_5_2000_480_1_5_400_400
* cell instance $8917 r0 *1 30.14,125.12
X$8917 VGND VIA_via4_5_2000_480_1_5_400_400
* cell instance $8918 r0 *1 120.14,261.12
X$8918 VGND VIA_via4_5_2000_480_1_5_400_400
* cell instance $8919 r0 *1 30.14,103.36
X$8919 VGND VIA_via4_5_2000_480_1_5_400_400
* cell instance $8920 r0 *1 150.14,119.68
X$8920 VGND VIA_via4_5_2000_480_1_5_400_400
* cell instance $8921 r0 *1 120.14,38.08
X$8921 VGND VIA_via4_5_2000_480_1_5_400_400
* cell instance $8922 r0 *1 150.14,141.44
X$8922 VGND VIA_via4_5_2000_480_1_5_400_400
* cell instance $8923 r0 *1 150.14,146.88
X$8923 VGND VIA_via4_5_2000_480_1_5_400_400
* cell instance $8924 r0 *1 120.14,184.96
X$8924 VGND VIA_via4_5_2000_480_1_5_400_400
* cell instance $8925 r0 *1 90.14,157.76
X$8925 VGND VIA_via4_5_2000_480_1_5_400_400
* cell instance $8926 r0 *1 150.14,125.12
X$8926 VGND VIA_via4_5_2000_480_1_5_400_400
* cell instance $8927 r0 *1 90.14,141.44
X$8927 VGND VIA_via4_5_2000_480_1_5_400_400
* cell instance $8928 r0 *1 120.14,195.84
X$8928 VGND VIA_via4_5_2000_480_1_5_400_400
* cell instance $8929 r0 *1 180.14,108.8
X$8929 VGND VIA_via4_5_2000_480_1_5_400_400
* cell instance $8930 r0 *1 120.14,16.32
X$8930 VGND VIA_via4_5_2000_480_1_5_400_400
* cell instance $8931 r0 *1 150.14,190.4
X$8931 VGND VIA_via4_5_2000_480_1_5_400_400
* cell instance $8932 r0 *1 60.14,261.12
X$8932 VGND VIA_via4_5_2000_480_1_5_400_400
* cell instance $8933 r0 *1 150.14,201.28
X$8933 VGND VIA_via4_5_2000_480_1_5_400_400
* cell instance $8934 r0 *1 150.14,195.84
X$8934 VGND VIA_via4_5_2000_480_1_5_400_400
* cell instance $8935 r0 *1 150.14,206.72
X$8935 VGND VIA_via4_5_2000_480_1_5_400_400
* cell instance $8936 r0 *1 30.14,48.96
X$8936 VGND VIA_via4_5_2000_480_1_5_400_400
* cell instance $8937 r0 *1 120.14,48.96
X$8937 VGND VIA_via4_5_2000_480_1_5_400_400
* cell instance $8938 r0 *1 30.14,70.72
X$8938 VGND VIA_via4_5_2000_480_1_5_400_400
* cell instance $8939 r0 *1 30.14,54.4
X$8939 VGND VIA_via4_5_2000_480_1_5_400_400
* cell instance $8940 r0 *1 90.14,163.2
X$8940 VGND VIA_via4_5_2000_480_1_5_400_400
* cell instance $8941 r0 *1 150.14,157.76
X$8941 VGND VIA_via4_5_2000_480_1_5_400_400
* cell instance $8942 r0 *1 150.14,163.2
X$8942 VGND VIA_via4_5_2000_480_1_5_400_400
* cell instance $8943 r0 *1 120.14,266.56
X$8943 VGND VIA_via4_5_2000_480_1_5_400_400
* cell instance $8944 r0 *1 30.14,76.16
X$8944 VGND VIA_via4_5_2000_480_1_5_400_400
* cell instance $8945 r0 *1 90.14,146.88
X$8945 VGND VIA_via4_5_2000_480_1_5_400_400
* cell instance $8946 r0 *1 150.14,168.64
X$8946 VGND VIA_via4_5_2000_480_1_5_400_400
* cell instance $8947 r0 *1 90.14,184.96
X$8947 VGND VIA_via4_5_2000_480_1_5_400_400
* cell instance $8948 r0 *1 120.14,201.28
X$8948 VGND VIA_via4_5_2000_480_1_5_400_400
* cell instance $8949 r0 *1 150.14,174.08
X$8949 VGND VIA_via4_5_2000_480_1_5_400_400
* cell instance $8950 r0 *1 150.14,179.52
X$8950 VGND VIA_via4_5_2000_480_1_5_400_400
* cell instance $8951 r0 *1 150.14,184.96
X$8951 VGND VIA_via4_5_2000_480_1_5_400_400
* cell instance $8952 r0 *1 180.14,65.28
X$8952 VGND VIA_via4_5_2000_480_1_5_400_400
* cell instance $8953 r0 *1 180.14,70.72
X$8953 VGND VIA_via4_5_2000_480_1_5_400_400
* cell instance $8954 r0 *1 30.14,141.44
X$8954 VGND VIA_via4_5_2000_480_1_5_400_400
* cell instance $8955 r0 *1 30.14,146.88
X$8955 VGND VIA_via4_5_2000_480_1_5_400_400
* cell instance $8956 r0 *1 180.14,21.76
X$8956 VGND VIA_via4_5_2000_480_1_5_400_400
* cell instance $8957 r0 *1 30.14,59.84
X$8957 VGND VIA_via4_5_2000_480_1_5_400_400
* cell instance $8958 r0 *1 180.14,16.32
X$8958 VGND VIA_via4_5_2000_480_1_5_400_400
* cell instance $8959 r0 *1 180.14,59.84
X$8959 VGND VIA_via4_5_2000_480_1_5_400_400
* cell instance $8960 r0 *1 180.14,54.4
X$8960 VGND VIA_via4_5_2000_480_1_5_400_400
* cell instance $8961 r0 *1 180.14,38.08
X$8961 VGND VIA_via4_5_2000_480_1_5_400_400
* cell instance $8962 r0 *1 180.14,48.96
X$8962 VGND VIA_via4_5_2000_480_1_5_400_400
* cell instance $8963 r0 *1 180.14,43.52
X$8963 VGND VIA_via4_5_2000_480_1_5_400_400
* cell instance $8964 r0 *1 180.14,179.52
X$8964 VGND VIA_via4_5_2000_480_1_5_400_400
* cell instance $8965 r0 *1 180.14,174.08
X$8965 VGND VIA_via4_5_2000_480_1_5_400_400
* cell instance $8966 r0 *1 180.14,146.88
X$8966 VGND VIA_via4_5_2000_480_1_5_400_400
* cell instance $8967 r0 *1 180.14,168.64
X$8967 VGND VIA_via4_5_2000_480_1_5_400_400
* cell instance $8968 r0 *1 30.14,152.32
X$8968 VGND VIA_via4_5_2000_480_1_5_400_400
* cell instance $8969 r0 *1 180.14,81.6
X$8969 VGND VIA_via4_5_2000_480_1_5_400_400
* cell instance $8970 r0 *1 30.14,157.76
X$8970 VGND VIA_via4_5_2000_480_1_5_400_400
* cell instance $8971 r0 *1 120.14,272
X$8971 VGND VIA_via4_5_2000_480_1_5_400_400
* cell instance $8972 r0 *1 180.14,87.04
X$8972 VGND VIA_via4_5_2000_480_1_5_400_400
* cell instance $8973 r0 *1 180.14,92.48
X$8973 VGND VIA_via4_5_2000_480_1_5_400_400
* cell instance $8974 r0 *1 180.14,163.2
X$8974 VGND VIA_via4_5_2000_480_1_5_400_400
* cell instance $8975 r0 *1 120.14,174.08
X$8975 VGND VIA_via4_5_2000_480_1_5_400_400
* cell instance $8976 r0 *1 120.14,179.52
X$8976 VGND VIA_via4_5_2000_480_1_5_400_400
* cell instance $8977 r0 *1 30.14,136
X$8977 VGND VIA_via4_5_2000_480_1_5_400_400
* cell instance $8978 r0 *1 180.14,97.92
X$8978 VGND VIA_via4_5_2000_480_1_5_400_400
* cell instance $8979 r0 *1 60.14,206.72
X$8979 VGND VIA_via4_5_2000_480_1_5_400_400
* cell instance $8980 r0 *1 120.14,65.28
X$8980 VGND VIA_via4_5_2000_480_1_5_400_400
* cell instance $8981 r0 *1 60.14,212.16
X$8981 VGND VIA_via4_5_2000_480_1_5_400_400
* cell instance $8982 r0 *1 120.14,223.04
X$8982 VGND VIA_via4_5_2000_480_1_5_400_400
* cell instance $8983 r0 *1 30.14,130.56
X$8983 VGND VIA_via4_5_2000_480_1_5_400_400
* cell instance $8984 r0 *1 30.14,119.68
X$8984 VGND VIA_via4_5_2000_480_1_5_400_400
* cell instance $8985 r0 *1 30.14,114.24
X$8985 VGND VIA_via4_5_2000_480_1_5_400_400
* cell instance $8986 r0 *1 30.14,108.8
X$8986 VGND VIA_via4_5_2000_480_1_5_400_400
* cell instance $8987 r0 *1 90.14,152.32
X$8987 VGND VIA_via4_5_2000_480_1_5_400_400
* cell instance $8988 r0 *1 120.14,163.2
X$8988 VGND VIA_via4_5_2000_480_1_5_400_400
* cell instance $8989 r0 *1 180.14,27.2
X$8989 VGND VIA_via4_5_2000_480_1_5_400_400
* cell instance $8990 r0 *1 120.14,217.6
X$8990 VGND VIA_via4_5_2000_480_1_5_400_400
* cell instance $8991 r0 *1 60.14,223.04
X$8991 VGND VIA_via4_5_2000_480_1_5_400_400
* cell instance $8992 r0 *1 120.14,70.72
X$8992 VGND VIA_via4_5_2000_480_1_5_400_400
* cell instance $8993 r0 *1 180.14,141.44
X$8993 VGND VIA_via4_5_2000_480_1_5_400_400
* cell instance $8994 r0 *1 180.14,76.16
X$8994 VGND VIA_via4_5_2000_480_1_5_400_400
* cell instance $8995 r0 *1 180.14,157.76
X$8995 VGND VIA_via4_5_2000_480_1_5_400_400
* cell instance $8996 r0 *1 120.14,168.64
X$8996 VGND VIA_via4_5_2000_480_1_5_400_400
* cell instance $8997 r0 *1 150.14,48.96
X$8997 VGND VIA_via4_5_2000_480_1_5_400_400
* cell instance $8998 r0 *1 150.14,43.52
X$8998 VGND VIA_via4_5_2000_480_1_5_400_400
* cell instance $8999 r0 *1 150.14,54.4
X$8999 VGND VIA_via4_5_2000_480_1_5_400_400
* cell instance $9000 r0 *1 150.14,65.28
X$9000 VGND VIA_via4_5_2000_480_1_5_400_400
* cell instance $9001 r0 *1 150.14,70.72
X$9001 VGND VIA_via4_5_2000_480_1_5_400_400
* cell instance $9002 r0 *1 150.14,59.84
X$9002 VGND VIA_via4_5_2000_480_1_5_400_400
* cell instance $9003 r0 *1 120.14,277.44
X$9003 VGND VIA_via4_5_2000_480_1_5_400_400
* cell instance $9004 r0 *1 120.14,21.76
X$9004 VGND VIA_via4_5_2000_480_1_5_400_400
* cell instance $9005 r0 *1 150.14,92.48
X$9005 VGND VIA_via4_5_2000_480_1_5_400_400
* cell instance $9006 r0 *1 150.14,76.16
X$9006 VGND VIA_via4_5_2000_480_1_5_400_400
* cell instance $9007 r0 *1 60.14,27.2
X$9007 VGND VIA_via4_5_2000_480_1_5_400_400
* cell instance $9008 r0 *1 60.14,21.76
X$9008 VGND VIA_via4_5_2000_480_1_5_400_400
* cell instance $9009 r0 *1 120.14,27.2
X$9009 VGND VIA_via4_5_2000_480_1_5_400_400
* cell instance $9010 r0 *1 120.14,54.4
X$9010 VGND VIA_via4_5_2000_480_1_5_400_400
* cell instance $9011 r0 *1 150.14,16.32
X$9011 VGND VIA_via4_5_2000_480_1_5_400_400
* cell instance $9012 r0 *1 150.14,21.76
X$9012 VGND VIA_via4_5_2000_480_1_5_400_400
* cell instance $9013 r0 *1 60.14,152.32
X$9013 VGND VIA_via4_5_2000_480_1_5_400_400
* cell instance $9014 r0 *1 60.14,288.32
X$9014 VGND VIA_via4_5_2000_480_1_5_400_400
* cell instance $9015 r0 *1 150.14,27.2
X$9015 VGND VIA_via4_5_2000_480_1_5_400_400
* cell instance $9016 r0 *1 120.14,244.8
X$9016 VGND VIA_via4_5_2000_480_1_5_400_400
* cell instance $9017 r0 *1 120.14,32.64
X$9017 VGND VIA_via4_5_2000_480_1_5_400_400
* cell instance $9018 r0 *1 60.14,255.68
X$9018 VGND VIA_via4_5_2000_480_1_5_400_400
* cell instance $9019 r0 *1 150.14,38.08
X$9019 VGND VIA_via4_5_2000_480_1_5_400_400
* cell instance $9020 r0 *1 180.14,32.64
X$9020 VGND VIA_via4_5_2000_480_1_5_400_400
* cell instance $9021 r0 *1 90.14,27.2
X$9021 VGND VIA_via4_5_2000_480_1_5_400_400
* cell instance $9022 r0 *1 60.14,141.44
X$9022 VGND VIA_via4_5_2000_480_1_5_400_400
* cell instance $9023 r0 *1 150.14,32.64
X$9023 VGND VIA_via4_5_2000_480_1_5_400_400
* cell instance $9024 r0 *1 120.14,59.84
X$9024 VGND VIA_via4_5_2000_480_1_5_400_400
* cell instance $9025 r0 *1 120.14,239.36
X$9025 VGND VIA_via4_5_2000_480_1_5_400_400
* cell instance $9026 r0 *1 60.14,179.52
X$9026 VGND VIA_via4_5_2000_480_1_5_400_400
* cell instance $9027 r0 *1 120.14,228.48
X$9027 VGND VIA_via4_5_2000_480_1_5_400_400
* cell instance $9028 r0 *1 60.14,184.96
X$9028 VGND VIA_via4_5_2000_480_1_5_400_400
* cell instance $9029 r0 *1 60.14,190.4
X$9029 VGND VIA_via4_5_2000_480_1_5_400_400
* cell instance $9030 r0 *1 60.14,201.28
X$9030 VGND VIA_via4_5_2000_480_1_5_400_400
* cell instance $9031 r0 *1 150.14,81.6
X$9031 VGND VIA_via4_5_2000_480_1_5_400_400
* cell instance $9032 r0 *1 120.14,233.92
X$9032 VGND VIA_via4_5_2000_480_1_5_400_400
* cell instance $9033 r0 *1 60.14,163.2
X$9033 VGND VIA_via4_5_2000_480_1_5_400_400
* cell instance $9034 r0 *1 90.14,250.24
X$9034 VGND VIA_via4_5_2000_480_1_5_400_400
* cell instance $9035 r0 *1 60.14,195.84
X$9035 VGND VIA_via4_5_2000_480_1_5_400_400
* cell instance $9036 r0 *1 150.14,87.04
X$9036 VGND VIA_via4_5_2000_480_1_5_400_400
* cell instance $9037 r0 *1 150.14,114.24
X$9037 VGND VIA_via4_5_2000_480_1_5_400_400
* cell instance $9038 r0 *1 150.14,97.92
X$9038 VGND VIA_via4_5_2000_480_1_5_400_400
* cell instance $9039 r0 *1 90.14,179.52
X$9039 VGND VIA_via4_5_2000_480_1_5_400_400
* cell instance $9040 r0 *1 150.14,108.8
X$9040 VGND VIA_via4_5_2000_480_1_5_400_400
* cell instance $9041 r0 *1 150.14,103.36
X$9041 VGND VIA_via4_5_2000_480_1_5_400_400
* cell instance $9042 r0 *1 60.14,168.64
X$9042 VGND VIA_via4_5_2000_480_1_5_400_400
* cell instance $9043 r0 *1 60.14,16.32
X$9043 VGND VIA_via4_5_2000_480_1_5_400_400
* cell instance $9044 r0 *1 60.14,10.88
X$9044 VGND VIA_via4_5_2000_480_1_5_400_400
* cell instance $9045 r0 *1 60.14,174.08
X$9045 VGND VIA_via4_5_2000_480_1_5_400_400
* cell instance $9046 r0 *1 120.14,255.68
X$9046 VGND VIA_via4_5_2000_480_1_5_400_400
* cell instance $9047 r0 *1 90.14,168.64
X$9047 VGND VIA_via4_5_2000_480_1_5_400_400
* cell instance $9048 r0 *1 180.14,152.32
X$9048 VGND VIA_via4_5_2000_480_1_5_400_400
* cell instance $9049 r0 *1 150.14,228.48
X$9049 VGND VIA_via4_5_2000_480_1_5_400_400
* cell instance $9050 r0 *1 150.14,244.8
X$9050 VGND VIA_via4_5_2000_480_1_5_400_400
* cell instance $9051 r0 *1 180.14,136
X$9051 VGND VIA_via4_5_2000_480_1_5_400_400
* cell instance $9052 r0 *1 150.14,233.92
X$9052 VGND VIA_via4_5_2000_480_1_5_400_400
* cell instance $9053 r0 *1 150.14,239.36
X$9053 VGND VIA_via4_5_2000_480_1_5_400_400
* cell instance $9054 r0 *1 150.14,255.68
X$9054 VGND VIA_via4_5_2000_480_1_5_400_400
* cell instance $9055 r0 *1 120.14,250.24
X$9055 VGND VIA_via4_5_2000_480_1_5_400_400
* cell instance $9056 r0 *1 90.14,190.4
X$9056 VGND VIA_via4_5_2000_480_1_5_400_400
* cell instance $9057 r0 *1 150.14,261.12
X$9057 VGND VIA_via4_5_2000_480_1_5_400_400
* cell instance $9058 r0 *1 90.14,195.84
X$9058 VGND VIA_via4_5_2000_480_1_5_400_400
* cell instance $9059 r0 *1 90.14,201.28
X$9059 VGND VIA_via4_5_2000_480_1_5_400_400
* cell instance $9060 r0 *1 60.14,130.56
X$9060 VGND VIA_via4_5_2000_480_1_5_400_400
* cell instance $9061 r0 *1 150.14,212.16
X$9061 VGND VIA_via4_5_2000_480_1_5_400_400
* cell instance $9062 r0 *1 180.14,103.36
X$9062 VGND VIA_via4_5_2000_480_1_5_400_400
* cell instance $9063 r0 *1 30.14,65.28
X$9063 VGND VIA_via4_5_2000_480_1_5_400_400
* cell instance $9064 r0 *1 180.14,119.68
X$9064 VGND VIA_via4_5_2000_480_1_5_400_400
* cell instance $9065 r0 *1 150.14,217.6
X$9065 VGND VIA_via4_5_2000_480_1_5_400_400
* cell instance $9066 r0 *1 120.14,206.72
X$9066 VGND VIA_via4_5_2000_480_1_5_400_400
* cell instance $9067 r0 *1 60.14,125.12
X$9067 VGND VIA_via4_5_2000_480_1_5_400_400
* cell instance $9068 r0 *1 120.14,212.16
X$9068 VGND VIA_via4_5_2000_480_1_5_400_400
* cell instance $9069 r0 *1 180.14,125.12
X$9069 VGND VIA_via4_5_2000_480_1_5_400_400
* cell instance $9070 r0 *1 30.14,38.08
X$9070 VGND VIA_via4_5_2000_480_1_5_400_400
* cell instance $9071 r0 *1 30.14,43.52
X$9071 VGND VIA_via4_5_2000_480_1_5_400_400
* cell instance $9072 r0 *1 60.14,119.68
X$9072 VGND VIA_via4_5_2000_480_1_5_400_400
* cell instance $9073 r0 *1 180.14,130.56
X$9073 VGND VIA_via4_5_2000_480_1_5_400_400
* cell instance $9074 r0 *1 150.14,223.04
X$9074 VGND VIA_via4_5_2000_480_1_5_400_400
* cell instance $9075 r0 *1 60.14,266.56
X$9075 VGND VIA_via4_5_2000_480_1_5_400_400
* cell instance $9076 r0 *1 90.14,266.56
X$9076 VGND VIA_via4_5_2000_480_1_5_400_400
* cell instance $9077 r0 *1 90.14,261.12
X$9077 VGND VIA_via4_5_2000_480_1_5_400_400
* cell instance $9078 r0 *1 90.14,255.68
X$9078 VGND VIA_via4_5_2000_480_1_5_400_400
* cell instance $9079 r0 *1 90.14,174.08
X$9079 VGND VIA_via4_5_2000_480_1_5_400_400
* cell instance $9080 r0 *1 90.14,288.32
X$9080 VGND VIA_via4_5_2000_480_1_5_400_400
* cell instance $9081 r0 *1 90.14,21.76
X$9081 VGND VIA_via4_5_2000_480_1_5_400_400
* cell instance $9082 r0 *1 60.14,157.76
X$9082 VGND VIA_via4_5_2000_480_1_5_400_400
* cell instance $9083 r0 *1 120.14,10.88
X$9083 VGND VIA_via4_5_2000_480_1_5_400_400
* cell instance $9084 r0 *1 90.14,16.32
X$9084 VGND VIA_via4_5_2000_480_1_5_400_400
* cell instance $9085 r0 *1 90.14,10.88
X$9085 VGND VIA_via4_5_2000_480_1_5_400_400
* cell instance $9086 r0 *1 150.14,10.88
X$9086 VGND VIA_via4_5_2000_480_1_5_400_400
* cell instance $9087 r0 *1 60.14,146.88
X$9087 VGND VIA_via4_5_2000_480_1_5_400_400
* cell instance $9088 r0 *1 120.14,43.52
X$9088 VGND VIA_via4_5_2000_480_1_5_400_400
* cell instance $9089 r0 *1 30.14,16.32
X$9089 VGND VIA_via4_5_2000_480_1_5_400_400
* cell instance $9090 r0 *1 150.14,266.56
X$9090 VGND VIA_via4_5_2000_480_1_5_400_400
* cell instance $9091 r0 *1 150.14,250.24
X$9091 VGND VIA_via4_5_2000_480_1_5_400_400
* cell instance $9092 r0 *1 30.14,21.76
X$9092 VGND VIA_via4_5_2000_480_1_5_400_400
* cell instance $9093 r0 *1 60.14,272
X$9093 VGND VIA_via4_5_2000_480_1_5_400_400
* cell instance $9094 r0 *1 90.14,272
X$9094 VGND VIA_via4_5_2000_480_1_5_400_400
* cell instance $9095 r0 *1 150.14,272
X$9095 VGND VIA_via4_5_2000_480_1_5_400_400
* cell instance $9096 r0 *1 60.14,277.44
X$9096 VGND VIA_via4_5_2000_480_1_5_400_400
* cell instance $9097 r0 *1 60.14,282.88
X$9097 VGND VIA_via4_5_2000_480_1_5_400_400
* cell instance $9098 r0 *1 90.14,282.88
X$9098 VGND VIA_via4_5_2000_480_1_5_400_400
* cell instance $9099 r0 *1 150.14,277.44
X$9099 VGND VIA_via4_5_2000_480_1_5_400_400
* cell instance $9100 r0 *1 150.14,282.88
X$9100 VGND VIA_via4_5_2000_480_1_5_400_400
* cell instance $9101 r0 *1 150.14,288.32
X$9101 VGND VIA_via4_5_2000_480_1_5_400_400
* cell instance $9102 r0 *1 90.14,277.44
X$9102 VGND VIA_via4_5_2000_480_1_5_400_400
* cell instance $9103 r0 *1 60.14,136
X$9103 VGND VIA_via4_5_2000_480_1_5_400_400
* cell instance $9104 r0 *1 30.14,27.2
X$9104 VGND VIA_via4_5_2000_480_1_5_400_400
* cell instance $9105 r0 *1 60.14,43.52
X$9105 VGND VIA_via4_5_2000_480_1_5_400_400
* cell instance $9106 r0 *1 90.14,32.64
X$9106 VGND VIA_via4_5_2000_480_1_5_400_400
* cell instance $9107 r0 *1 90.14,233.92
X$9107 VGND VIA_via4_5_2000_480_1_5_400_400
* cell instance $9108 r0 *1 120.14,125.12
X$9108 VGND VIA_via4_5_2000_480_1_5_400_400
* cell instance $9109 r0 *1 180.14,261.12
X$9109 VGND VIA_via4_5_2000_480_1_5_400_400
* cell instance $9110 r0 *1 60.14,32.64
X$9110 VGND VIA_via4_5_2000_480_1_5_400_400
* cell instance $9111 r0 *1 180.14,250.24
X$9111 VGND VIA_via4_5_2000_480_1_5_400_400
* cell instance $9112 r0 *1 90.14,244.8
X$9112 VGND VIA_via4_5_2000_480_1_5_400_400
* cell instance $9113 r0 *1 60.14,114.24
X$9113 VGND VIA_via4_5_2000_480_1_5_400_400
* cell instance $9114 r0 *1 30.14,195.84
X$9114 VGND VIA_via4_5_2000_480_1_5_400_400
* cell instance $9115 r0 *1 30.14,190.4
X$9115 VGND VIA_via4_5_2000_480_1_5_400_400
* cell instance $9116 r0 *1 60.14,38.08
X$9116 VGND VIA_via4_5_2000_480_1_5_400_400
* cell instance $9117 r0 *1 30.14,32.64
X$9117 VGND VIA_via4_5_2000_480_1_5_400_400
* cell instance $9118 r0 *1 120.14,119.68
X$9118 VGND VIA_via4_5_2000_480_1_5_400_400
* cell instance $9119 r0 *1 60.14,76.16
X$9119 VGND VIA_via4_5_2000_480_1_5_400_400
* cell instance $9120 r0 *1 60.14,48.96
X$9120 VGND VIA_via4_5_2000_480_1_5_400_400
* cell instance $9121 r0 *1 180.14,233.92
X$9121 VGND VIA_via4_5_2000_480_1_5_400_400
* cell instance $9122 r0 *1 180.14,277.44
X$9122 VGND VIA_via4_5_2000_480_1_5_400_400
* cell instance $9123 r0 *1 60.14,87.04
X$9123 VGND VIA_via4_5_2000_480_1_5_400_400
* cell instance $9124 r0 *1 90.14,59.84
X$9124 VGND VIA_via4_5_2000_480_1_5_400_400
* cell instance $9125 r0 *1 60.14,92.48
X$9125 VGND VIA_via4_5_2000_480_1_5_400_400
* cell instance $9126 r0 *1 90.14,54.4
X$9126 VGND VIA_via4_5_2000_480_1_5_400_400
* cell instance $9127 r0 *1 90.14,65.28
X$9127 VGND VIA_via4_5_2000_480_1_5_400_400
* cell instance $9128 r0 *1 120.14,282.88
X$9128 VGND VIA_via4_5_2000_480_1_5_400_400
* cell instance $9129 r0 *1 90.14,70.72
X$9129 VGND VIA_via4_5_2000_480_1_5_400_400
* cell instance $9130 r0 *1 120.14,136
X$9130 VGND VIA_via4_5_2000_480_1_5_400_400
* cell instance $9131 r0 *1 60.14,97.92
X$9131 VGND VIA_via4_5_2000_480_1_5_400_400
* cell instance $9132 r0 *1 90.14,136
X$9132 VGND VIA_via4_5_2000_480_1_5_400_400
* cell instance $9133 r0 *1 60.14,103.36
X$9133 VGND VIA_via4_5_2000_480_1_5_400_400
* cell instance $9134 r0 *1 180.14,282.88
X$9134 VGND VIA_via4_5_2000_480_1_5_400_400
* cell instance $9135 r0 *1 90.14,119.68
X$9135 VGND VIA_via4_5_2000_480_1_5_400_400
* cell instance $9136 r0 *1 90.14,130.56
X$9136 VGND VIA_via4_5_2000_480_1_5_400_400
* cell instance $9137 r0 *1 60.14,81.6
X$9137 VGND VIA_via4_5_2000_480_1_5_400_400
* cell instance $9138 r0 *1 90.14,125.12
X$9138 VGND VIA_via4_5_2000_480_1_5_400_400
* cell instance $9139 r0 *1 180.14,10.88
X$9139 VGND VIA_via4_5_2000_480_1_5_400_400
* cell instance $9140 r0 *1 180.14,272
X$9140 VGND VIA_via4_5_2000_480_1_5_400_400
* cell instance $9141 r0 *1 120.14,288.32
X$9141 VGND VIA_via4_5_2000_480_1_5_400_400
* cell instance $9142 r0 *1 90.14,239.36
X$9142 VGND VIA_via4_5_2000_480_1_5_400_400
* cell instance $9143 r0 *1 90.14,114.24
X$9143 VGND VIA_via4_5_2000_480_1_5_400_400
* cell instance $9144 r0 *1 180.14,255.68
X$9144 VGND VIA_via4_5_2000_480_1_5_400_400
* cell instance $9145 r0 *1 60.14,70.72
X$9145 VGND VIA_via4_5_2000_480_1_5_400_400
* cell instance $9146 r0 *1 90.14,108.8
X$9146 VGND VIA_via4_5_2000_480_1_5_400_400
* cell instance $9147 r0 *1 120.14,92.48
X$9147 VGND VIA_via4_5_2000_480_1_5_400_400
* cell instance $9148 r0 *1 180.14,239.36
X$9148 VGND VIA_via4_5_2000_480_1_5_400_400
* cell instance $9149 r0 *1 90.14,97.92
X$9149 VGND VIA_via4_5_2000_480_1_5_400_400
* cell instance $9150 r0 *1 90.14,103.36
X$9150 VGND VIA_via4_5_2000_480_1_5_400_400
* cell instance $9151 r0 *1 60.14,108.8
X$9151 VGND VIA_via4_5_2000_480_1_5_400_400
* cell instance $9152 r0 *1 30.14,223.04
X$9152 VGND VIA_via4_5_2000_480_1_5_400_400
* cell instance $9153 r0 *1 180.14,266.56
X$9153 VGND VIA_via4_5_2000_480_1_5_400_400
* cell instance $9154 r0 *1 120.14,108.8
X$9154 VGND VIA_via4_5_2000_480_1_5_400_400
* cell instance $9155 r0 *1 120.14,114.24
X$9155 VGND VIA_via4_5_2000_480_1_5_400_400
* cell instance $9156 r0 *1 60.14,54.4
X$9156 VGND VIA_via4_5_2000_480_1_5_400_400
* cell instance $9157 r0 *1 60.14,59.84
X$9157 VGND VIA_via4_5_2000_480_1_5_400_400
* cell instance $9158 r0 *1 120.14,87.04
X$9158 VGND VIA_via4_5_2000_480_1_5_400_400
* cell instance $9159 r0 *1 60.14,65.28
X$9159 VGND VIA_via4_5_2000_480_1_5_400_400
* cell instance $9160 r0 *1 180.14,288.32
X$9160 VGND VIA_via4_5_2000_480_1_5_400_400
* cell instance $9161 r0 *1 30.14,272
X$9161 VGND VIA_via4_5_2000_480_1_5_400_400
* cell instance $9162 r0 *1 180.14,184.96
X$9162 VGND VIA_via4_5_2000_480_1_5_400_400
* cell instance $9163 r0 *1 120.14,146.88
X$9163 VGND VIA_via4_5_2000_480_1_5_400_400
* cell instance $9164 r0 *1 120.14,81.6
X$9164 VGND VIA_via4_5_2000_480_1_5_400_400
* cell instance $9165 r0 *1 30.14,288.32
X$9165 VGND VIA_via4_5_2000_480_1_5_400_400
* cell instance $9166 r0 *1 90.14,228.48
X$9166 VGND VIA_via4_5_2000_480_1_5_400_400
* cell instance $9167 r0 *1 90.14,223.04
X$9167 VGND VIA_via4_5_2000_480_1_5_400_400
* cell instance $9168 r0 *1 120.14,152.32
X$9168 VGND VIA_via4_5_2000_480_1_5_400_400
* cell instance $9169 r0 *1 180.14,206.72
X$9169 VGND VIA_via4_5_2000_480_1_5_400_400
* cell instance $9170 r0 *1 90.14,43.52
X$9170 VGND VIA_via4_5_2000_480_1_5_400_400
* cell instance $9171 r0 *1 90.14,38.08
X$9171 VGND VIA_via4_5_2000_480_1_5_400_400
* cell instance $9172 r0 *1 180.14,212.16
X$9172 VGND VIA_via4_5_2000_480_1_5_400_400
* cell instance $9173 r0 *1 60.14,239.36
X$9173 VGND VIA_via4_5_2000_480_1_5_400_400
* cell instance $9174 r0 *1 30.14,174.08
X$9174 VGND VIA_via4_5_2000_480_1_5_400_400
* cell instance $9175 r0 *1 180.14,244.8
X$9175 VGND VIA_via4_5_2000_480_1_5_400_400
* cell instance $9176 r0 *1 30.14,228.48
X$9176 VGND VIA_via4_5_2000_480_1_5_400_400
* cell instance $9177 r0 *1 120.14,141.44
X$9177 VGND VIA_via4_5_2000_480_1_5_400_400
* cell instance $9178 r0 *1 30.14,168.64
X$9178 VGND VIA_via4_5_2000_480_1_5_400_400
* cell instance $9179 r0 *1 60.14,244.8
X$9179 VGND VIA_via4_5_2000_480_1_5_400_400
* cell instance $9180 r0 *1 180.14,201.28
X$9180 VGND VIA_via4_5_2000_480_1_5_400_400
* cell instance $9181 r0 *1 60.14,233.92
X$9181 VGND VIA_via4_5_2000_480_1_5_400_400
* cell instance $9182 r0 *1 30.14,179.52
X$9182 VGND VIA_via4_5_2000_480_1_5_400_400
* cell instance $9183 r0 *1 30.14,184.96
X$9183 VGND VIA_via4_5_2000_480_1_5_400_400
* cell instance $9184 r0 *1 60.14,217.6
X$9184 VGND VIA_via4_5_2000_480_1_5_400_400
* cell instance $9185 r0 *1 180.14,195.84
X$9185 VGND VIA_via4_5_2000_480_1_5_400_400
* cell instance $9186 r0 *1 120.14,157.76
X$9186 VGND VIA_via4_5_2000_480_1_5_400_400
* cell instance $9187 r0 *1 120.14,76.16
X$9187 VGND VIA_via4_5_2000_480_1_5_400_400
* cell instance $9188 r0 *1 180.14,190.4
X$9188 VGND VIA_via4_5_2000_480_1_5_400_400
* cell instance $9189 r0 *1 180.14,228.48
X$9189 VGND VIA_via4_5_2000_480_1_5_400_400
* cell instance $9190 r0 *1 30.14,239.36
X$9190 VGND VIA_via4_5_2000_480_1_5_400_400
* cell instance $9191 r0 *1 60.14,228.48
X$9191 VGND VIA_via4_5_2000_480_1_5_400_400
* cell instance $9192 r0 *1 90.14,217.6
X$9192 VGND VIA_via4_5_2000_480_1_5_400_400
* cell instance $9193 r0 *1 90.14,212.16
X$9193 VGND VIA_via4_5_2000_480_1_5_400_400
* cell instance $9194 r0 *1 180.14,223.04
X$9194 VGND VIA_via4_5_2000_480_1_5_400_400
* cell instance $9195 r0 *1 90.14,206.72
X$9195 VGND VIA_via4_5_2000_480_1_5_400_400
* cell instance $9196 r0 *1 30.14,233.92
X$9196 VGND VIA_via4_5_2000_480_1_5_400_400
* cell instance $9197 r0 *1 30.14,212.16
X$9197 VGND VIA_via4_5_2000_480_1_5_400_400
* cell instance $9198 r0 *1 30.14,277.44
X$9198 VGND VIA_via4_5_2000_480_1_5_400_400
* cell instance $9199 r0 *1 30.14,201.28
X$9199 VGND VIA_via4_5_2000_480_1_5_400_400
* cell instance $9200 r0 *1 120.14,103.36
X$9200 VGND VIA_via4_5_2000_480_1_5_400_400
* cell instance $9201 r0 *1 30.14,217.6
X$9201 VGND VIA_via4_5_2000_480_1_5_400_400
* cell instance $9202 r0 *1 90.14,92.48
X$9202 VGND VIA_via4_5_2000_480_1_5_400_400
* cell instance $9203 r0 *1 120.14,130.56
X$9203 VGND VIA_via4_5_2000_480_1_5_400_400
* cell instance $9204 r0 *1 30.14,282.88
X$9204 VGND VIA_via4_5_2000_480_1_5_400_400
* cell instance $9205 r0 *1 180.14,217.6
X$9205 VGND VIA_via4_5_2000_480_1_5_400_400
* cell instance $9206 r0 *1 90.14,76.16
X$9206 VGND VIA_via4_5_2000_480_1_5_400_400
* cell instance $9207 r0 *1 90.14,48.96
X$9207 VGND VIA_via4_5_2000_480_1_5_400_400
* cell instance $9208 r0 *1 90.14,87.04
X$9208 VGND VIA_via4_5_2000_480_1_5_400_400
* cell instance $9209 r0 *1 30.14,261.12
X$9209 VGND VIA_via4_5_2000_480_1_5_400_400
* cell instance $9210 r0 *1 30.14,266.56
X$9210 VGND VIA_via4_5_2000_480_1_5_400_400
* cell instance $9211 r0 *1 30.14,163.2
X$9211 VGND VIA_via4_5_2000_480_1_5_400_400
* cell instance $9212 r0 *1 90.14,81.6
X$9212 VGND VIA_via4_5_2000_480_1_5_400_400
* cell instance $9213 r0 *1 30.14,250.24
X$9213 VGND VIA_via4_5_2000_480_1_5_400_400
* cell instance $9214 r0 *1 120.14,97.92
X$9214 VGND VIA_via4_5_2000_480_1_5_400_400
* cell instance $9215 r0 *1 30.14,255.68
X$9215 VGND VIA_via4_5_2000_480_1_5_400_400
* cell instance $9216 r0 *1 30.14,206.72
X$9216 VGND VIA_via4_5_2000_480_1_5_400_400
* cell instance $9217 r0 *1 30.14,244.8
X$9217 VGND VIA_via4_5_2000_480_1_5_400_400
* cell instance $9218 r0 *1 120.14,288.32
X$9218 VGND VIA_via3_4_2000_480_1_5_400_400
* cell instance $9219 r0 *1 90.14,59.84
X$9219 VGND VIA_via3_4_2000_480_1_5_400_400
* cell instance $9220 r0 *1 90.14,54.4
X$9220 VGND VIA_via3_4_2000_480_1_5_400_400
* cell instance $9221 r0 *1 120.14,130.56
X$9221 VGND VIA_via3_4_2000_480_1_5_400_400
* cell instance $9222 r0 *1 90.14,65.28
X$9222 VGND VIA_via3_4_2000_480_1_5_400_400
* cell instance $9223 r0 *1 120.14,282.88
X$9223 VGND VIA_via3_4_2000_480_1_5_400_400
* cell instance $9224 r0 *1 180.14,76.16
X$9224 VGND VIA_via3_4_2000_480_1_5_400_400
* cell instance $9225 r0 *1 90.14,70.72
X$9225 VGND VIA_via3_4_2000_480_1_5_400_400
* cell instance $9226 r0 *1 60.14,43.52
X$9226 VGND VIA_via3_4_2000_480_1_5_400_400
* cell instance $9227 r0 *1 90.14,217.6
X$9227 VGND VIA_via3_4_2000_480_1_5_400_400
* cell instance $9228 r0 *1 120.14,136
X$9228 VGND VIA_via3_4_2000_480_1_5_400_400
* cell instance $9229 r0 *1 90.14,228.48
X$9229 VGND VIA_via3_4_2000_480_1_5_400_400
* cell instance $9230 r0 *1 90.14,233.92
X$9230 VGND VIA_via3_4_2000_480_1_5_400_400
* cell instance $9231 r0 *1 90.14,239.36
X$9231 VGND VIA_via3_4_2000_480_1_5_400_400
* cell instance $9232 r0 *1 90.14,244.8
X$9232 VGND VIA_via3_4_2000_480_1_5_400_400
* cell instance $9233 r0 *1 120.14,217.6
X$9233 VGND VIA_via3_4_2000_480_1_5_400_400
* cell instance $9234 r0 *1 120.14,157.76
X$9234 VGND VIA_via3_4_2000_480_1_5_400_400
* cell instance $9235 r0 *1 60.14,233.92
X$9235 VGND VIA_via3_4_2000_480_1_5_400_400
* cell instance $9236 r0 *1 90.14,43.52
X$9236 VGND VIA_via3_4_2000_480_1_5_400_400
* cell instance $9237 r0 *1 120.14,152.32
X$9237 VGND VIA_via3_4_2000_480_1_5_400_400
* cell instance $9238 r0 *1 90.14,48.96
X$9238 VGND VIA_via3_4_2000_480_1_5_400_400
* cell instance $9239 r0 *1 60.14,228.48
X$9239 VGND VIA_via3_4_2000_480_1_5_400_400
* cell instance $9240 r0 *1 180.14,48.96
X$9240 VGND VIA_via3_4_2000_480_1_5_400_400
* cell instance $9241 r0 *1 60.14,223.04
X$9241 VGND VIA_via3_4_2000_480_1_5_400_400
* cell instance $9242 r0 *1 180.14,43.52
X$9242 VGND VIA_via3_4_2000_480_1_5_400_400
* cell instance $9243 r0 *1 180.14,288.32
X$9243 VGND VIA_via3_4_2000_480_1_5_400_400
* cell instance $9244 r0 *1 180.14,38.08
X$9244 VGND VIA_via3_4_2000_480_1_5_400_400
* cell instance $9245 r0 *1 180.14,146.88
X$9245 VGND VIA_via3_4_2000_480_1_5_400_400
* cell instance $9246 r0 *1 120.14,277.44
X$9246 VGND VIA_via3_4_2000_480_1_5_400_400
* cell instance $9247 r0 *1 180.14,141.44
X$9247 VGND VIA_via3_4_2000_480_1_5_400_400
* cell instance $9248 r0 *1 90.14,38.08
X$9248 VGND VIA_via3_4_2000_480_1_5_400_400
* cell instance $9249 r0 *1 90.14,206.72
X$9249 VGND VIA_via3_4_2000_480_1_5_400_400
* cell instance $9250 r0 *1 90.14,212.16
X$9250 VGND VIA_via3_4_2000_480_1_5_400_400
* cell instance $9251 r0 *1 180.14,272
X$9251 VGND VIA_via3_4_2000_480_1_5_400_400
* cell instance $9252 r0 *1 180.14,277.44
X$9252 VGND VIA_via3_4_2000_480_1_5_400_400
* cell instance $9253 r0 *1 180.14,282.88
X$9253 VGND VIA_via3_4_2000_480_1_5_400_400
* cell instance $9254 r0 *1 90.14,223.04
X$9254 VGND VIA_via3_4_2000_480_1_5_400_400
* cell instance $9255 r0 *1 120.14,146.88
X$9255 VGND VIA_via3_4_2000_480_1_5_400_400
* cell instance $9256 r0 *1 120.14,141.44
X$9256 VGND VIA_via3_4_2000_480_1_5_400_400
* cell instance $9257 r0 *1 60.14,38.08
X$9257 VGND VIA_via3_4_2000_480_1_5_400_400
* cell instance $9258 r0 *1 90.14,92.48
X$9258 VGND VIA_via3_4_2000_480_1_5_400_400
* cell instance $9259 r0 *1 90.14,81.6
X$9259 VGND VIA_via3_4_2000_480_1_5_400_400
* cell instance $9260 r0 *1 90.14,76.16
X$9260 VGND VIA_via3_4_2000_480_1_5_400_400
* cell instance $9261 r0 *1 60.14,108.8
X$9261 VGND VIA_via3_4_2000_480_1_5_400_400
* cell instance $9262 r0 *1 60.14,81.6
X$9262 VGND VIA_via3_4_2000_480_1_5_400_400
* cell instance $9263 r0 *1 60.14,87.04
X$9263 VGND VIA_via3_4_2000_480_1_5_400_400
* cell instance $9264 r0 *1 60.14,92.48
X$9264 VGND VIA_via3_4_2000_480_1_5_400_400
* cell instance $9265 r0 *1 180.14,10.88
X$9265 VGND VIA_via3_4_2000_480_1_5_400_400
* cell instance $9266 r0 *1 60.14,114.24
X$9266 VGND VIA_via3_4_2000_480_1_5_400_400
* cell instance $9267 r0 *1 120.14,108.8
X$9267 VGND VIA_via3_4_2000_480_1_5_400_400
* cell instance $9268 r0 *1 30.14,250.24
X$9268 VGND VIA_via3_4_2000_480_1_5_400_400
* cell instance $9269 r0 *1 60.14,76.16
X$9269 VGND VIA_via3_4_2000_480_1_5_400_400
* cell instance $9270 r0 *1 120.14,114.24
X$9270 VGND VIA_via3_4_2000_480_1_5_400_400
* cell instance $9271 r0 *1 180.14,266.56
X$9271 VGND VIA_via3_4_2000_480_1_5_400_400
* cell instance $9272 r0 *1 180.14,92.48
X$9272 VGND VIA_via3_4_2000_480_1_5_400_400
* cell instance $9273 r0 *1 30.14,212.16
X$9273 VGND VIA_via3_4_2000_480_1_5_400_400
* cell instance $9274 r0 *1 30.14,217.6
X$9274 VGND VIA_via3_4_2000_480_1_5_400_400
* cell instance $9275 r0 *1 120.14,97.92
X$9275 VGND VIA_via3_4_2000_480_1_5_400_400
* cell instance $9276 r0 *1 30.14,228.48
X$9276 VGND VIA_via3_4_2000_480_1_5_400_400
* cell instance $9277 r0 *1 30.14,233.92
X$9277 VGND VIA_via3_4_2000_480_1_5_400_400
* cell instance $9278 r0 *1 30.14,223.04
X$9278 VGND VIA_via3_4_2000_480_1_5_400_400
* cell instance $9279 r0 *1 30.14,244.8
X$9279 VGND VIA_via3_4_2000_480_1_5_400_400
* cell instance $9280 r0 *1 30.14,206.72
X$9280 VGND VIA_via3_4_2000_480_1_5_400_400
* cell instance $9281 r0 *1 30.14,272
X$9281 VGND VIA_via3_4_2000_480_1_5_400_400
* cell instance $9282 r0 *1 90.14,87.04
X$9282 VGND VIA_via3_4_2000_480_1_5_400_400
* cell instance $9283 r0 *1 180.14,87.04
X$9283 VGND VIA_via3_4_2000_480_1_5_400_400
* cell instance $9284 r0 *1 180.14,81.6
X$9284 VGND VIA_via3_4_2000_480_1_5_400_400
* cell instance $9285 r0 *1 30.14,261.12
X$9285 VGND VIA_via3_4_2000_480_1_5_400_400
* cell instance $9286 r0 *1 30.14,255.68
X$9286 VGND VIA_via3_4_2000_480_1_5_400_400
* cell instance $9287 r0 *1 30.14,277.44
X$9287 VGND VIA_via3_4_2000_480_1_5_400_400
* cell instance $9288 r0 *1 120.14,103.36
X$9288 VGND VIA_via3_4_2000_480_1_5_400_400
* cell instance $9289 r0 *1 30.14,288.32
X$9289 VGND VIA_via3_4_2000_480_1_5_400_400
* cell instance $9290 r0 *1 30.14,282.88
X$9290 VGND VIA_via3_4_2000_480_1_5_400_400
* cell instance $9291 r0 *1 30.14,266.56
X$9291 VGND VIA_via3_4_2000_480_1_5_400_400
* cell instance $9292 r0 *1 60.14,65.28
X$9292 VGND VIA_via3_4_2000_480_1_5_400_400
* cell instance $9293 r0 *1 60.14,70.72
X$9293 VGND VIA_via3_4_2000_480_1_5_400_400
* cell instance $9294 r0 *1 120.14,119.68
X$9294 VGND VIA_via3_4_2000_480_1_5_400_400
* cell instance $9295 r0 *1 120.14,125.12
X$9295 VGND VIA_via3_4_2000_480_1_5_400_400
* cell instance $9296 r0 *1 180.14,255.68
X$9296 VGND VIA_via3_4_2000_480_1_5_400_400
* cell instance $9297 r0 *1 180.14,261.12
X$9297 VGND VIA_via3_4_2000_480_1_5_400_400
* cell instance $9298 r0 *1 60.14,59.84
X$9298 VGND VIA_via3_4_2000_480_1_5_400_400
* cell instance $9299 r0 *1 60.14,48.96
X$9299 VGND VIA_via3_4_2000_480_1_5_400_400
* cell instance $9300 r0 *1 180.14,250.24
X$9300 VGND VIA_via3_4_2000_480_1_5_400_400
* cell instance $9301 r0 *1 60.14,103.36
X$9301 VGND VIA_via3_4_2000_480_1_5_400_400
* cell instance $9302 r0 *1 60.14,54.4
X$9302 VGND VIA_via3_4_2000_480_1_5_400_400
* cell instance $9303 r0 *1 60.14,97.92
X$9303 VGND VIA_via3_4_2000_480_1_5_400_400
* cell instance $9304 r0 *1 150.14,244.8
X$9304 VGND VIA_via3_4_2000_480_1_5_400_400
* cell instance $9305 r0 *1 150.14,233.92
X$9305 VGND VIA_via3_4_2000_480_1_5_400_400
* cell instance $9306 r0 *1 150.14,239.36
X$9306 VGND VIA_via3_4_2000_480_1_5_400_400
* cell instance $9307 r0 *1 150.14,250.24
X$9307 VGND VIA_via3_4_2000_480_1_5_400_400
* cell instance $9308 r0 *1 150.14,255.68
X$9308 VGND VIA_via3_4_2000_480_1_5_400_400
* cell instance $9309 r0 *1 150.14,261.12
X$9309 VGND VIA_via3_4_2000_480_1_5_400_400
* cell instance $9310 r0 *1 150.14,266.56
X$9310 VGND VIA_via3_4_2000_480_1_5_400_400
* cell instance $9311 r0 *1 150.14,277.44
X$9311 VGND VIA_via3_4_2000_480_1_5_400_400
* cell instance $9312 r0 *1 150.14,272
X$9312 VGND VIA_via3_4_2000_480_1_5_400_400
* cell instance $9313 r0 *1 150.14,288.32
X$9313 VGND VIA_via3_4_2000_480_1_5_400_400
* cell instance $9314 r0 *1 60.14,10.88
X$9314 VGND VIA_via3_4_2000_480_1_5_400_400
* cell instance $9315 r0 *1 150.14,282.88
X$9315 VGND VIA_via3_4_2000_480_1_5_400_400
* cell instance $9316 r0 *1 60.14,21.76
X$9316 VGND VIA_via3_4_2000_480_1_5_400_400
* cell instance $9317 r0 *1 90.14,21.76
X$9317 VGND VIA_via3_4_2000_480_1_5_400_400
* cell instance $9318 r0 *1 150.14,168.64
X$9318 VGND VIA_via3_4_2000_480_1_5_400_400
* cell instance $9319 r0 *1 150.14,174.08
X$9319 VGND VIA_via3_4_2000_480_1_5_400_400
* cell instance $9320 r0 *1 120.14,239.36
X$9320 VGND VIA_via3_4_2000_480_1_5_400_400
* cell instance $9321 r0 *1 90.14,27.2
X$9321 VGND VIA_via3_4_2000_480_1_5_400_400
* cell instance $9322 r0 *1 150.14,163.2
X$9322 VGND VIA_via3_4_2000_480_1_5_400_400
* cell instance $9323 r0 *1 150.14,179.52
X$9323 VGND VIA_via3_4_2000_480_1_5_400_400
* cell instance $9324 r0 *1 150.14,190.4
X$9324 VGND VIA_via3_4_2000_480_1_5_400_400
* cell instance $9325 r0 *1 150.14,184.96
X$9325 VGND VIA_via3_4_2000_480_1_5_400_400
* cell instance $9326 r0 *1 150.14,201.28
X$9326 VGND VIA_via3_4_2000_480_1_5_400_400
* cell instance $9327 r0 *1 150.14,195.84
X$9327 VGND VIA_via3_4_2000_480_1_5_400_400
* cell instance $9328 r0 *1 60.14,16.32
X$9328 VGND VIA_via3_4_2000_480_1_5_400_400
* cell instance $9329 r0 *1 150.14,223.04
X$9329 VGND VIA_via3_4_2000_480_1_5_400_400
* cell instance $9330 r0 *1 150.14,212.16
X$9330 VGND VIA_via3_4_2000_480_1_5_400_400
* cell instance $9331 r0 *1 150.14,206.72
X$9331 VGND VIA_via3_4_2000_480_1_5_400_400
* cell instance $9332 r0 *1 150.14,217.6
X$9332 VGND VIA_via3_4_2000_480_1_5_400_400
* cell instance $9333 r0 *1 150.14,228.48
X$9333 VGND VIA_via3_4_2000_480_1_5_400_400
* cell instance $9334 r0 *1 60.14,27.2
X$9334 VGND VIA_via3_4_2000_480_1_5_400_400
* cell instance $9335 r0 *1 180.14,125.12
X$9335 VGND VIA_via3_4_2000_480_1_5_400_400
* cell instance $9336 r0 *1 180.14,119.68
X$9336 VGND VIA_via3_4_2000_480_1_5_400_400
* cell instance $9337 r0 *1 90.14,266.56
X$9337 VGND VIA_via3_4_2000_480_1_5_400_400
* cell instance $9338 r0 *1 90.14,272
X$9338 VGND VIA_via3_4_2000_480_1_5_400_400
* cell instance $9339 r0 *1 90.14,277.44
X$9339 VGND VIA_via3_4_2000_480_1_5_400_400
* cell instance $9340 r0 *1 90.14,282.88
X$9340 VGND VIA_via3_4_2000_480_1_5_400_400
* cell instance $9341 r0 *1 90.14,288.32
X$9341 VGND VIA_via3_4_2000_480_1_5_400_400
* cell instance $9342 r0 *1 90.14,255.68
X$9342 VGND VIA_via3_4_2000_480_1_5_400_400
* cell instance $9343 r0 *1 90.14,261.12
X$9343 VGND VIA_via3_4_2000_480_1_5_400_400
* cell instance $9344 r0 *1 120.14,206.72
X$9344 VGND VIA_via3_4_2000_480_1_5_400_400
* cell instance $9345 r0 *1 120.14,212.16
X$9345 VGND VIA_via3_4_2000_480_1_5_400_400
* cell instance $9346 r0 *1 180.14,108.8
X$9346 VGND VIA_via3_4_2000_480_1_5_400_400
* cell instance $9347 r0 *1 180.14,103.36
X$9347 VGND VIA_via3_4_2000_480_1_5_400_400
* cell instance $9348 r0 *1 180.14,97.92
X$9348 VGND VIA_via3_4_2000_480_1_5_400_400
* cell instance $9349 r0 *1 180.14,114.24
X$9349 VGND VIA_via3_4_2000_480_1_5_400_400
* cell instance $9350 r0 *1 180.14,136
X$9350 VGND VIA_via3_4_2000_480_1_5_400_400
* cell instance $9351 r0 *1 120.14,233.92
X$9351 VGND VIA_via3_4_2000_480_1_5_400_400
* cell instance $9352 r0 *1 90.14,250.24
X$9352 VGND VIA_via3_4_2000_480_1_5_400_400
* cell instance $9353 r0 *1 120.14,228.48
X$9353 VGND VIA_via3_4_2000_480_1_5_400_400
* cell instance $9354 r0 *1 180.14,130.56
X$9354 VGND VIA_via3_4_2000_480_1_5_400_400
* cell instance $9355 r0 *1 150.14,97.92
X$9355 VGND VIA_via3_4_2000_480_1_5_400_400
* cell instance $9356 r0 *1 150.14,114.24
X$9356 VGND VIA_via3_4_2000_480_1_5_400_400
* cell instance $9357 r0 *1 150.14,103.36
X$9357 VGND VIA_via3_4_2000_480_1_5_400_400
* cell instance $9358 r0 *1 150.14,108.8
X$9358 VGND VIA_via3_4_2000_480_1_5_400_400
* cell instance $9359 r0 *1 150.14,87.04
X$9359 VGND VIA_via3_4_2000_480_1_5_400_400
* cell instance $9360 r0 *1 150.14,76.16
X$9360 VGND VIA_via3_4_2000_480_1_5_400_400
* cell instance $9361 r0 *1 150.14,10.88
X$9361 VGND VIA_via3_4_2000_480_1_5_400_400
* cell instance $9362 r0 *1 150.14,81.6
X$9362 VGND VIA_via3_4_2000_480_1_5_400_400
* cell instance $9363 r0 *1 150.14,65.28
X$9363 VGND VIA_via3_4_2000_480_1_5_400_400
* cell instance $9364 r0 *1 150.14,59.84
X$9364 VGND VIA_via3_4_2000_480_1_5_400_400
* cell instance $9365 r0 *1 150.14,70.72
X$9365 VGND VIA_via3_4_2000_480_1_5_400_400
* cell instance $9366 r0 *1 150.14,54.4
X$9366 VGND VIA_via3_4_2000_480_1_5_400_400
* cell instance $9367 r0 *1 150.14,48.96
X$9367 VGND VIA_via3_4_2000_480_1_5_400_400
* cell instance $9368 r0 *1 150.14,43.52
X$9368 VGND VIA_via3_4_2000_480_1_5_400_400
* cell instance $9369 r0 *1 150.14,38.08
X$9369 VGND VIA_via3_4_2000_480_1_5_400_400
* cell instance $9370 r0 *1 150.14,32.64
X$9370 VGND VIA_via3_4_2000_480_1_5_400_400
* cell instance $9371 r0 *1 180.14,32.64
X$9371 VGND VIA_via3_4_2000_480_1_5_400_400
* cell instance $9372 r0 *1 120.14,32.64
X$9372 VGND VIA_via3_4_2000_480_1_5_400_400
* cell instance $9373 r0 *1 150.14,27.2
X$9373 VGND VIA_via3_4_2000_480_1_5_400_400
* cell instance $9374 r0 *1 150.14,16.32
X$9374 VGND VIA_via3_4_2000_480_1_5_400_400
* cell instance $9375 r0 *1 150.14,21.76
X$9375 VGND VIA_via3_4_2000_480_1_5_400_400
* cell instance $9376 r0 *1 150.14,92.48
X$9376 VGND VIA_via3_4_2000_480_1_5_400_400
* cell instance $9377 r0 *1 120.14,163.2
X$9377 VGND VIA_via3_4_2000_480_1_5_400_400
* cell instance $9378 r0 *1 120.14,168.64
X$9378 VGND VIA_via3_4_2000_480_1_5_400_400
* cell instance $9379 r0 *1 120.14,179.52
X$9379 VGND VIA_via3_4_2000_480_1_5_400_400
* cell instance $9380 r0 *1 30.14,108.8
X$9380 VGND VIA_via3_4_2000_480_1_5_400_400
* cell instance $9381 r0 *1 30.14,114.24
X$9381 VGND VIA_via3_4_2000_480_1_5_400_400
* cell instance $9382 r0 *1 30.14,103.36
X$9382 VGND VIA_via3_4_2000_480_1_5_400_400
* cell instance $9383 r0 *1 120.14,184.96
X$9383 VGND VIA_via3_4_2000_480_1_5_400_400
* cell instance $9384 r0 *1 120.14,261.12
X$9384 VGND VIA_via3_4_2000_480_1_5_400_400
* cell instance $9385 r0 *1 120.14,190.4
X$9385 VGND VIA_via3_4_2000_480_1_5_400_400
* cell instance $9386 r0 *1 30.14,92.48
X$9386 VGND VIA_via3_4_2000_480_1_5_400_400
* cell instance $9387 r0 *1 30.14,81.6
X$9387 VGND VIA_via3_4_2000_480_1_5_400_400
* cell instance $9388 r0 *1 30.14,76.16
X$9388 VGND VIA_via3_4_2000_480_1_5_400_400
* cell instance $9389 r0 *1 120.14,266.56
X$9389 VGND VIA_via3_4_2000_480_1_5_400_400
* cell instance $9390 r0 *1 30.14,87.04
X$9390 VGND VIA_via3_4_2000_480_1_5_400_400
* cell instance $9391 r0 *1 30.14,97.92
X$9391 VGND VIA_via3_4_2000_480_1_5_400_400
* cell instance $9392 r0 *1 180.14,54.4
X$9392 VGND VIA_via3_4_2000_480_1_5_400_400
* cell instance $9393 r0 *1 180.14,59.84
X$9393 VGND VIA_via3_4_2000_480_1_5_400_400
* cell instance $9394 r0 *1 180.14,65.28
X$9394 VGND VIA_via3_4_2000_480_1_5_400_400
* cell instance $9395 r0 *1 180.14,70.72
X$9395 VGND VIA_via3_4_2000_480_1_5_400_400
* cell instance $9396 r0 *1 120.14,174.08
X$9396 VGND VIA_via3_4_2000_480_1_5_400_400
* cell instance $9397 r0 *1 120.14,272
X$9397 VGND VIA_via3_4_2000_480_1_5_400_400
* cell instance $9398 r0 *1 60.14,244.8
X$9398 VGND VIA_via3_4_2000_480_1_5_400_400
* cell instance $9399 r0 *1 60.14,239.36
X$9399 VGND VIA_via3_4_2000_480_1_5_400_400
* cell instance $9400 r0 *1 60.14,212.16
X$9400 VGND VIA_via3_4_2000_480_1_5_400_400
* cell instance $9401 r0 *1 60.14,206.72
X$9401 VGND VIA_via3_4_2000_480_1_5_400_400
* cell instance $9402 r0 *1 60.14,217.6
X$9402 VGND VIA_via3_4_2000_480_1_5_400_400
* cell instance $9403 r0 *1 120.14,250.24
X$9403 VGND VIA_via3_4_2000_480_1_5_400_400
* cell instance $9404 r0 *1 60.14,261.12
X$9404 VGND VIA_via3_4_2000_480_1_5_400_400
* cell instance $9405 r0 *1 30.14,21.76
X$9405 VGND VIA_via3_4_2000_480_1_5_400_400
* cell instance $9406 r0 *1 60.14,255.68
X$9406 VGND VIA_via3_4_2000_480_1_5_400_400
* cell instance $9407 r0 *1 150.14,119.68
X$9407 VGND VIA_via3_4_2000_480_1_5_400_400
* cell instance $9408 r0 *1 150.14,136
X$9408 VGND VIA_via3_4_2000_480_1_5_400_400
* cell instance $9409 r0 *1 150.14,125.12
X$9409 VGND VIA_via3_4_2000_480_1_5_400_400
* cell instance $9410 r0 *1 150.14,130.56
X$9410 VGND VIA_via3_4_2000_480_1_5_400_400
* cell instance $9411 r0 *1 150.14,157.76
X$9411 VGND VIA_via3_4_2000_480_1_5_400_400
* cell instance $9412 r0 *1 90.14,16.32
X$9412 VGND VIA_via3_4_2000_480_1_5_400_400
* cell instance $9413 r0 *1 60.14,288.32
X$9413 VGND VIA_via3_4_2000_480_1_5_400_400
* cell instance $9414 r0 *1 60.14,282.88
X$9414 VGND VIA_via3_4_2000_480_1_5_400_400
* cell instance $9415 r0 *1 60.14,277.44
X$9415 VGND VIA_via3_4_2000_480_1_5_400_400
* cell instance $9416 r0 *1 150.14,146.88
X$9416 VGND VIA_via3_4_2000_480_1_5_400_400
* cell instance $9417 r0 *1 150.14,152.32
X$9417 VGND VIA_via3_4_2000_480_1_5_400_400
* cell instance $9418 r0 *1 60.14,272
X$9418 VGND VIA_via3_4_2000_480_1_5_400_400
* cell instance $9419 r0 *1 120.14,244.8
X$9419 VGND VIA_via3_4_2000_480_1_5_400_400
* cell instance $9420 r0 *1 90.14,10.88
X$9420 VGND VIA_via3_4_2000_480_1_5_400_400
* cell instance $9421 r0 *1 150.14,141.44
X$9421 VGND VIA_via3_4_2000_480_1_5_400_400
* cell instance $9422 r0 *1 30.14,27.2
X$9422 VGND VIA_via3_4_2000_480_1_5_400_400
* cell instance $9423 r0 *1 180.14,157.76
X$9423 VGND VIA_via3_4_2000_480_1_5_400_400
* cell instance $9424 r0 *1 120.14,201.28
X$9424 VGND VIA_via3_4_2000_480_1_5_400_400
* cell instance $9425 r0 *1 120.14,195.84
X$9425 VGND VIA_via3_4_2000_480_1_5_400_400
* cell instance $9426 r0 *1 60.14,250.24
X$9426 VGND VIA_via3_4_2000_480_1_5_400_400
* cell instance $9427 r0 *1 60.14,266.56
X$9427 VGND VIA_via3_4_2000_480_1_5_400_400
* cell instance $9428 r0 *1 30.14,38.08
X$9428 VGND VIA_via3_4_2000_480_1_5_400_400
* cell instance $9429 r0 *1 120.14,223.04
X$9429 VGND VIA_via3_4_2000_480_1_5_400_400
* cell instance $9430 r0 *1 30.14,16.32
X$9430 VGND VIA_via3_4_2000_480_1_5_400_400
* cell instance $9431 r0 *1 30.14,54.4
X$9431 VGND VIA_via3_4_2000_480_1_5_400_400
* cell instance $9432 r0 *1 30.14,48.96
X$9432 VGND VIA_via3_4_2000_480_1_5_400_400
* cell instance $9433 r0 *1 120.14,255.68
X$9433 VGND VIA_via3_4_2000_480_1_5_400_400
* cell instance $9434 r0 *1 30.14,59.84
X$9434 VGND VIA_via3_4_2000_480_1_5_400_400
* cell instance $9435 r0 *1 30.14,65.28
X$9435 VGND VIA_via3_4_2000_480_1_5_400_400
* cell instance $9436 r0 *1 30.14,43.52
X$9436 VGND VIA_via3_4_2000_480_1_5_400_400
* cell instance $9437 r0 *1 180.14,152.32
X$9437 VGND VIA_via3_4_2000_480_1_5_400_400
* cell instance $9438 r0 *1 30.14,70.72
X$9438 VGND VIA_via3_4_2000_480_1_5_400_400
* cell instance $9439 r0 *1 90.14,103.36
X$9439 VGND VIA_via3_4_2000_480_1_5_400_400
* cell instance $9440 r0 *1 90.14,114.24
X$9440 VGND VIA_via3_4_2000_480_1_5_400_400
* cell instance $9441 r0 *1 60.14,152.32
X$9441 VGND VIA_via3_4_2000_480_1_5_400_400
* cell instance $9442 r0 *1 90.14,108.8
X$9442 VGND VIA_via3_4_2000_480_1_5_400_400
* cell instance $9443 r0 *1 90.14,168.64
X$9443 VGND VIA_via3_4_2000_480_1_5_400_400
* cell instance $9444 r0 *1 30.14,174.08
X$9444 VGND VIA_via3_4_2000_480_1_5_400_400
* cell instance $9445 r0 *1 60.14,136
X$9445 VGND VIA_via3_4_2000_480_1_5_400_400
* cell instance $9446 r0 *1 60.14,125.12
X$9446 VGND VIA_via3_4_2000_480_1_5_400_400
* cell instance $9447 r0 *1 60.14,119.68
X$9447 VGND VIA_via3_4_2000_480_1_5_400_400
* cell instance $9448 r0 *1 60.14,157.76
X$9448 VGND VIA_via3_4_2000_480_1_5_400_400
* cell instance $9449 r0 *1 60.14,141.44
X$9449 VGND VIA_via3_4_2000_480_1_5_400_400
* cell instance $9450 r0 *1 120.14,87.04
X$9450 VGND VIA_via3_4_2000_480_1_5_400_400
* cell instance $9451 r0 *1 60.14,146.88
X$9451 VGND VIA_via3_4_2000_480_1_5_400_400
* cell instance $9452 r0 *1 90.14,163.2
X$9452 VGND VIA_via3_4_2000_480_1_5_400_400
* cell instance $9453 r0 *1 180.14,223.04
X$9453 VGND VIA_via3_4_2000_480_1_5_400_400
* cell instance $9454 r0 *1 180.14,217.6
X$9454 VGND VIA_via3_4_2000_480_1_5_400_400
* cell instance $9455 r0 *1 90.14,97.92
X$9455 VGND VIA_via3_4_2000_480_1_5_400_400
* cell instance $9456 r0 *1 180.14,206.72
X$9456 VGND VIA_via3_4_2000_480_1_5_400_400
* cell instance $9457 r0 *1 90.14,190.4
X$9457 VGND VIA_via3_4_2000_480_1_5_400_400
* cell instance $9458 r0 *1 90.14,184.96
X$9458 VGND VIA_via3_4_2000_480_1_5_400_400
* cell instance $9459 r0 *1 60.14,163.2
X$9459 VGND VIA_via3_4_2000_480_1_5_400_400
* cell instance $9460 r0 *1 60.14,174.08
X$9460 VGND VIA_via3_4_2000_480_1_5_400_400
* cell instance $9461 r0 *1 60.14,168.64
X$9461 VGND VIA_via3_4_2000_480_1_5_400_400
* cell instance $9462 r0 *1 180.14,212.16
X$9462 VGND VIA_via3_4_2000_480_1_5_400_400
* cell instance $9463 r0 *1 120.14,59.84
X$9463 VGND VIA_via3_4_2000_480_1_5_400_400
* cell instance $9464 r0 *1 120.14,92.48
X$9464 VGND VIA_via3_4_2000_480_1_5_400_400
* cell instance $9465 r0 *1 90.14,174.08
X$9465 VGND VIA_via3_4_2000_480_1_5_400_400
* cell instance $9466 r0 *1 120.14,54.4
X$9466 VGND VIA_via3_4_2000_480_1_5_400_400
* cell instance $9467 r0 *1 180.14,21.76
X$9467 VGND VIA_via3_4_2000_480_1_5_400_400
* cell instance $9468 r0 *1 120.14,76.16
X$9468 VGND VIA_via3_4_2000_480_1_5_400_400
* cell instance $9469 r0 *1 180.14,16.32
X$9469 VGND VIA_via3_4_2000_480_1_5_400_400
* cell instance $9470 r0 *1 180.14,27.2
X$9470 VGND VIA_via3_4_2000_480_1_5_400_400
* cell instance $9471 r0 *1 120.14,65.28
X$9471 VGND VIA_via3_4_2000_480_1_5_400_400
* cell instance $9472 r0 *1 30.14,125.12
X$9472 VGND VIA_via3_4_2000_480_1_5_400_400
* cell instance $9473 r0 *1 30.14,119.68
X$9473 VGND VIA_via3_4_2000_480_1_5_400_400
* cell instance $9474 r0 *1 90.14,141.44
X$9474 VGND VIA_via3_4_2000_480_1_5_400_400
* cell instance $9475 r0 *1 90.14,146.88
X$9475 VGND VIA_via3_4_2000_480_1_5_400_400
* cell instance $9476 r0 *1 120.14,70.72
X$9476 VGND VIA_via3_4_2000_480_1_5_400_400
* cell instance $9477 r0 *1 90.14,152.32
X$9477 VGND VIA_via3_4_2000_480_1_5_400_400
* cell instance $9478 r0 *1 30.14,130.56
X$9478 VGND VIA_via3_4_2000_480_1_5_400_400
* cell instance $9479 r0 *1 30.14,136
X$9479 VGND VIA_via3_4_2000_480_1_5_400_400
* cell instance $9480 r0 *1 30.14,168.64
X$9480 VGND VIA_via3_4_2000_480_1_5_400_400
* cell instance $9481 r0 *1 30.14,201.28
X$9481 VGND VIA_via3_4_2000_480_1_5_400_400
* cell instance $9482 r0 *1 180.14,163.2
X$9482 VGND VIA_via3_4_2000_480_1_5_400_400
* cell instance $9483 r0 *1 180.14,179.52
X$9483 VGND VIA_via3_4_2000_480_1_5_400_400
* cell instance $9484 r0 *1 30.14,179.52
X$9484 VGND VIA_via3_4_2000_480_1_5_400_400
* cell instance $9485 r0 *1 180.14,174.08
X$9485 VGND VIA_via3_4_2000_480_1_5_400_400
* cell instance $9486 r0 *1 180.14,168.64
X$9486 VGND VIA_via3_4_2000_480_1_5_400_400
* cell instance $9487 r0 *1 30.14,157.76
X$9487 VGND VIA_via3_4_2000_480_1_5_400_400
* cell instance $9488 r0 *1 30.14,146.88
X$9488 VGND VIA_via3_4_2000_480_1_5_400_400
* cell instance $9489 r0 *1 120.14,81.6
X$9489 VGND VIA_via3_4_2000_480_1_5_400_400
* cell instance $9490 r0 *1 30.14,141.44
X$9490 VGND VIA_via3_4_2000_480_1_5_400_400
* cell instance $9491 r0 *1 30.14,163.2
X$9491 VGND VIA_via3_4_2000_480_1_5_400_400
* cell instance $9492 r0 *1 30.14,152.32
X$9492 VGND VIA_via3_4_2000_480_1_5_400_400
* cell instance $9493 r0 *1 30.14,195.84
X$9493 VGND VIA_via3_4_2000_480_1_5_400_400
* cell instance $9494 r0 *1 30.14,190.4
X$9494 VGND VIA_via3_4_2000_480_1_5_400_400
* cell instance $9495 r0 *1 30.14,184.96
X$9495 VGND VIA_via3_4_2000_480_1_5_400_400
* cell instance $9496 r0 *1 180.14,244.8
X$9496 VGND VIA_via3_4_2000_480_1_5_400_400
* cell instance $9497 r0 *1 60.14,32.64
X$9497 VGND VIA_via3_4_2000_480_1_5_400_400
* cell instance $9498 r0 *1 180.14,233.92
X$9498 VGND VIA_via3_4_2000_480_1_5_400_400
* cell instance $9499 r0 *1 90.14,32.64
X$9499 VGND VIA_via3_4_2000_480_1_5_400_400
* cell instance $9500 r0 *1 90.14,157.76
X$9500 VGND VIA_via3_4_2000_480_1_5_400_400
* cell instance $9501 r0 *1 90.14,179.52
X$9501 VGND VIA_via3_4_2000_480_1_5_400_400
* cell instance $9502 r0 *1 180.14,239.36
X$9502 VGND VIA_via3_4_2000_480_1_5_400_400
* cell instance $9503 r0 *1 60.14,130.56
X$9503 VGND VIA_via3_4_2000_480_1_5_400_400
* cell instance $9504 r0 *1 120.14,27.2
X$9504 VGND VIA_via3_4_2000_480_1_5_400_400
* cell instance $9505 r0 *1 30.14,32.64
X$9505 VGND VIA_via3_4_2000_480_1_5_400_400
* cell instance $9506 r0 *1 180.14,228.48
X$9506 VGND VIA_via3_4_2000_480_1_5_400_400
* cell instance $9507 r0 *1 120.14,21.76
X$9507 VGND VIA_via3_4_2000_480_1_5_400_400
* cell instance $9508 r0 *1 90.14,125.12
X$9508 VGND VIA_via3_4_2000_480_1_5_400_400
* cell instance $9509 r0 *1 90.14,130.56
X$9509 VGND VIA_via3_4_2000_480_1_5_400_400
* cell instance $9510 r0 *1 90.14,136
X$9510 VGND VIA_via3_4_2000_480_1_5_400_400
* cell instance $9511 r0 *1 120.14,16.32
X$9511 VGND VIA_via3_4_2000_480_1_5_400_400
* cell instance $9512 r0 *1 90.14,119.68
X$9512 VGND VIA_via3_4_2000_480_1_5_400_400
* cell instance $9513 r0 *1 120.14,10.88
X$9513 VGND VIA_via3_4_2000_480_1_5_400_400
* cell instance $9514 r0 *1 120.14,38.08
X$9514 VGND VIA_via3_4_2000_480_1_5_400_400
* cell instance $9515 r0 *1 60.14,184.96
X$9515 VGND VIA_via3_4_2000_480_1_5_400_400
* cell instance $9516 r0 *1 60.14,201.28
X$9516 VGND VIA_via3_4_2000_480_1_5_400_400
* cell instance $9517 r0 *1 90.14,195.84
X$9517 VGND VIA_via3_4_2000_480_1_5_400_400
* cell instance $9518 r0 *1 120.14,43.52
X$9518 VGND VIA_via3_4_2000_480_1_5_400_400
* cell instance $9519 r0 *1 30.14,239.36
X$9519 VGND VIA_via3_4_2000_480_1_5_400_400
* cell instance $9520 r0 *1 120.14,48.96
X$9520 VGND VIA_via3_4_2000_480_1_5_400_400
* cell instance $9521 r0 *1 60.14,190.4
X$9521 VGND VIA_via3_4_2000_480_1_5_400_400
* cell instance $9522 r0 *1 60.14,195.84
X$9522 VGND VIA_via3_4_2000_480_1_5_400_400
* cell instance $9523 r0 *1 60.14,179.52
X$9523 VGND VIA_via3_4_2000_480_1_5_400_400
* cell instance $9524 r0 *1 180.14,190.4
X$9524 VGND VIA_via3_4_2000_480_1_5_400_400
* cell instance $9525 r0 *1 90.14,201.28
X$9525 VGND VIA_via3_4_2000_480_1_5_400_400
* cell instance $9526 r0 *1 180.14,184.96
X$9526 VGND VIA_via3_4_2000_480_1_5_400_400
* cell instance $9527 r0 *1 180.14,195.84
X$9527 VGND VIA_via3_4_2000_480_1_5_400_400
* cell instance $9528 r0 *1 180.14,201.28
X$9528 VGND VIA_via3_4_2000_480_1_5_400_400
* cell instance $9529 r0 *1 180.14,130.56
X$9529 VGND VIA_via2_3_2000_480_1_6_320_320
* cell instance $9530 r0 *1 90.14,195.84
X$9530 VGND VIA_via2_3_2000_480_1_6_320_320
* cell instance $9531 r0 *1 180.14,108.8
X$9531 VGND VIA_via2_3_2000_480_1_6_320_320
* cell instance $9532 r0 *1 30.14,239.36
X$9532 VGND VIA_via2_3_2000_480_1_6_320_320
* cell instance $9533 r0 *1 180.14,97.92
X$9533 VGND VIA_via2_3_2000_480_1_6_320_320
* cell instance $9534 r0 *1 30.14,255.68
X$9534 VGND VIA_via2_3_2000_480_1_6_320_320
* cell instance $9535 r0 *1 90.14,114.24
X$9535 VGND VIA_via2_3_2000_480_1_6_320_320
* cell instance $9536 r0 *1 180.14,76.16
X$9536 VGND VIA_via2_3_2000_480_1_6_320_320
* cell instance $9537 r0 *1 30.14,223.04
X$9537 VGND VIA_via2_3_2000_480_1_6_320_320
* cell instance $9538 r0 *1 30.14,244.8
X$9538 VGND VIA_via2_3_2000_480_1_6_320_320
* cell instance $9539 r0 *1 60.14,16.32
X$9539 VGND VIA_via2_3_2000_480_1_6_320_320
* cell instance $9540 r0 *1 30.14,217.6
X$9540 VGND VIA_via2_3_2000_480_1_6_320_320
* cell instance $9541 r0 *1 180.14,136
X$9541 VGND VIA_via2_3_2000_480_1_6_320_320
* cell instance $9542 r0 *1 30.14,212.16
X$9542 VGND VIA_via2_3_2000_480_1_6_320_320
* cell instance $9543 r0 *1 30.14,228.48
X$9543 VGND VIA_via2_3_2000_480_1_6_320_320
* cell instance $9544 r0 *1 30.14,206.72
X$9544 VGND VIA_via2_3_2000_480_1_6_320_320
* cell instance $9545 r0 *1 30.14,233.92
X$9545 VGND VIA_via2_3_2000_480_1_6_320_320
* cell instance $9546 r0 *1 60.14,190.4
X$9546 VGND VIA_via2_3_2000_480_1_6_320_320
* cell instance $9547 r0 *1 60.14,184.96
X$9547 VGND VIA_via2_3_2000_480_1_6_320_320
* cell instance $9548 r0 *1 90.14,190.4
X$9548 VGND VIA_via2_3_2000_480_1_6_320_320
* cell instance $9549 r0 *1 120.14,206.72
X$9549 VGND VIA_via2_3_2000_480_1_6_320_320
* cell instance $9550 r0 *1 120.14,212.16
X$9550 VGND VIA_via2_3_2000_480_1_6_320_320
* cell instance $9551 r0 *1 30.14,261.12
X$9551 VGND VIA_via2_3_2000_480_1_6_320_320
* cell instance $9552 r0 *1 60.14,87.04
X$9552 VGND VIA_via2_3_2000_480_1_6_320_320
* cell instance $9553 r0 *1 60.14,92.48
X$9553 VGND VIA_via2_3_2000_480_1_6_320_320
* cell instance $9554 r0 *1 60.14,81.6
X$9554 VGND VIA_via2_3_2000_480_1_6_320_320
* cell instance $9555 r0 *1 180.14,114.24
X$9555 VGND VIA_via2_3_2000_480_1_6_320_320
* cell instance $9556 r0 *1 60.14,201.28
X$9556 VGND VIA_via2_3_2000_480_1_6_320_320
* cell instance $9557 r0 *1 60.14,195.84
X$9557 VGND VIA_via2_3_2000_480_1_6_320_320
* cell instance $9558 r0 *1 180.14,103.36
X$9558 VGND VIA_via2_3_2000_480_1_6_320_320
* cell instance $9559 r0 *1 60.14,179.52
X$9559 VGND VIA_via2_3_2000_480_1_6_320_320
* cell instance $9560 r0 *1 60.14,114.24
X$9560 VGND VIA_via2_3_2000_480_1_6_320_320
* cell instance $9561 r0 *1 180.14,195.84
X$9561 VGND VIA_via2_3_2000_480_1_6_320_320
* cell instance $9562 r0 *1 180.14,201.28
X$9562 VGND VIA_via2_3_2000_480_1_6_320_320
* cell instance $9563 r0 *1 90.14,92.48
X$9563 VGND VIA_via2_3_2000_480_1_6_320_320
* cell instance $9564 r0 *1 90.14,184.96
X$9564 VGND VIA_via2_3_2000_480_1_6_320_320
* cell instance $9565 r0 *1 180.14,184.96
X$9565 VGND VIA_via2_3_2000_480_1_6_320_320
* cell instance $9566 r0 *1 90.14,81.6
X$9566 VGND VIA_via2_3_2000_480_1_6_320_320
* cell instance $9567 r0 *1 180.14,190.4
X$9567 VGND VIA_via2_3_2000_480_1_6_320_320
* cell instance $9568 r0 *1 30.14,266.56
X$9568 VGND VIA_via2_3_2000_480_1_6_320_320
* cell instance $9569 r0 *1 90.14,76.16
X$9569 VGND VIA_via2_3_2000_480_1_6_320_320
* cell instance $9570 r0 *1 60.14,103.36
X$9570 VGND VIA_via2_3_2000_480_1_6_320_320
* cell instance $9571 r0 *1 90.14,250.24
X$9571 VGND VIA_via2_3_2000_480_1_6_320_320
* cell instance $9572 r0 *1 30.14,272
X$9572 VGND VIA_via2_3_2000_480_1_6_320_320
* cell instance $9573 r0 *1 90.14,201.28
X$9573 VGND VIA_via2_3_2000_480_1_6_320_320
* cell instance $9574 r0 *1 90.14,87.04
X$9574 VGND VIA_via2_3_2000_480_1_6_320_320
* cell instance $9575 r0 *1 90.14,277.44
X$9575 VGND VIA_via2_3_2000_480_1_6_320_320
* cell instance $9576 r0 *1 90.14,255.68
X$9576 VGND VIA_via2_3_2000_480_1_6_320_320
* cell instance $9577 r0 *1 180.14,125.12
X$9577 VGND VIA_via2_3_2000_480_1_6_320_320
* cell instance $9578 r0 *1 150.14,54.4
X$9578 VGND VIA_via2_3_2000_480_1_6_320_320
* cell instance $9579 r0 *1 30.14,250.24
X$9579 VGND VIA_via2_3_2000_480_1_6_320_320
* cell instance $9580 r0 *1 150.14,65.28
X$9580 VGND VIA_via2_3_2000_480_1_6_320_320
* cell instance $9581 r0 *1 150.14,59.84
X$9581 VGND VIA_via2_3_2000_480_1_6_320_320
* cell instance $9582 r0 *1 150.14,70.72
X$9582 VGND VIA_via2_3_2000_480_1_6_320_320
* cell instance $9583 r0 *1 150.14,92.48
X$9583 VGND VIA_via2_3_2000_480_1_6_320_320
* cell instance $9584 r0 *1 150.14,87.04
X$9584 VGND VIA_via2_3_2000_480_1_6_320_320
* cell instance $9585 r0 *1 150.14,76.16
X$9585 VGND VIA_via2_3_2000_480_1_6_320_320
* cell instance $9586 r0 *1 150.14,81.6
X$9586 VGND VIA_via2_3_2000_480_1_6_320_320
* cell instance $9587 r0 *1 150.14,103.36
X$9587 VGND VIA_via2_3_2000_480_1_6_320_320
* cell instance $9588 r0 *1 90.14,288.32
X$9588 VGND VIA_via2_3_2000_480_1_6_320_320
* cell instance $9589 r0 *1 150.14,114.24
X$9589 VGND VIA_via2_3_2000_480_1_6_320_320
* cell instance $9590 r0 *1 60.14,174.08
X$9590 VGND VIA_via2_3_2000_480_1_6_320_320
* cell instance $9591 r0 *1 90.14,282.88
X$9591 VGND VIA_via2_3_2000_480_1_6_320_320
* cell instance $9592 r0 *1 60.14,168.64
X$9592 VGND VIA_via2_3_2000_480_1_6_320_320
* cell instance $9593 r0 *1 150.14,97.92
X$9593 VGND VIA_via2_3_2000_480_1_6_320_320
* cell instance $9594 r0 *1 90.14,272
X$9594 VGND VIA_via2_3_2000_480_1_6_320_320
* cell instance $9595 r0 *1 90.14,266.56
X$9595 VGND VIA_via2_3_2000_480_1_6_320_320
* cell instance $9596 r0 *1 90.14,261.12
X$9596 VGND VIA_via2_3_2000_480_1_6_320_320
* cell instance $9597 r0 *1 180.14,119.68
X$9597 VGND VIA_via2_3_2000_480_1_6_320_320
* cell instance $9598 r0 *1 60.14,163.2
X$9598 VGND VIA_via2_3_2000_480_1_6_320_320
* cell instance $9599 r0 *1 150.14,108.8
X$9599 VGND VIA_via2_3_2000_480_1_6_320_320
* cell instance $9600 r0 *1 30.14,288.32
X$9600 VGND VIA_via2_3_2000_480_1_6_320_320
* cell instance $9601 r0 *1 30.14,282.88
X$9601 VGND VIA_via2_3_2000_480_1_6_320_320
* cell instance $9602 r0 *1 150.14,10.88
X$9602 VGND VIA_via2_3_2000_480_1_6_320_320
* cell instance $9603 r0 *1 150.14,21.76
X$9603 VGND VIA_via2_3_2000_480_1_6_320_320
* cell instance $9604 r0 *1 150.14,43.52
X$9604 VGND VIA_via2_3_2000_480_1_6_320_320
* cell instance $9605 r0 *1 150.14,16.32
X$9605 VGND VIA_via2_3_2000_480_1_6_320_320
* cell instance $9606 r0 *1 60.14,76.16
X$9606 VGND VIA_via2_3_2000_480_1_6_320_320
* cell instance $9607 r0 *1 150.14,27.2
X$9607 VGND VIA_via2_3_2000_480_1_6_320_320
* cell instance $9608 r0 *1 120.14,32.64
X$9608 VGND VIA_via2_3_2000_480_1_6_320_320
* cell instance $9609 r0 *1 180.14,32.64
X$9609 VGND VIA_via2_3_2000_480_1_6_320_320
* cell instance $9610 r0 *1 150.14,32.64
X$9610 VGND VIA_via2_3_2000_480_1_6_320_320
* cell instance $9611 r0 *1 150.14,38.08
X$9611 VGND VIA_via2_3_2000_480_1_6_320_320
* cell instance $9612 r0 *1 150.14,48.96
X$9612 VGND VIA_via2_3_2000_480_1_6_320_320
* cell instance $9613 r0 *1 30.14,277.44
X$9613 VGND VIA_via2_3_2000_480_1_6_320_320
* cell instance $9614 r0 *1 120.14,174.08
X$9614 VGND VIA_via2_3_2000_480_1_6_320_320
* cell instance $9615 r0 *1 120.14,168.64
X$9615 VGND VIA_via2_3_2000_480_1_6_320_320
* cell instance $9616 r0 *1 30.14,130.56
X$9616 VGND VIA_via2_3_2000_480_1_6_320_320
* cell instance $9617 r0 *1 90.14,233.92
X$9617 VGND VIA_via2_3_2000_480_1_6_320_320
* cell instance $9618 r0 *1 90.14,223.04
X$9618 VGND VIA_via2_3_2000_480_1_6_320_320
* cell instance $9619 r0 *1 90.14,228.48
X$9619 VGND VIA_via2_3_2000_480_1_6_320_320
* cell instance $9620 r0 *1 30.14,174.08
X$9620 VGND VIA_via2_3_2000_480_1_6_320_320
* cell instance $9621 r0 *1 30.14,108.8
X$9621 VGND VIA_via2_3_2000_480_1_6_320_320
* cell instance $9622 r0 *1 90.14,157.76
X$9622 VGND VIA_via2_3_2000_480_1_6_320_320
* cell instance $9623 r0 *1 90.14,244.8
X$9623 VGND VIA_via2_3_2000_480_1_6_320_320
* cell instance $9624 r0 *1 90.14,212.16
X$9624 VGND VIA_via2_3_2000_480_1_6_320_320
* cell instance $9625 r0 *1 30.14,114.24
X$9625 VGND VIA_via2_3_2000_480_1_6_320_320
* cell instance $9626 r0 *1 120.14,179.52
X$9626 VGND VIA_via2_3_2000_480_1_6_320_320
* cell instance $9627 r0 *1 90.14,141.44
X$9627 VGND VIA_via2_3_2000_480_1_6_320_320
* cell instance $9628 r0 *1 120.14,163.2
X$9628 VGND VIA_via2_3_2000_480_1_6_320_320
* cell instance $9629 r0 *1 90.14,146.88
X$9629 VGND VIA_via2_3_2000_480_1_6_320_320
* cell instance $9630 r0 *1 60.14,206.72
X$9630 VGND VIA_via2_3_2000_480_1_6_320_320
* cell instance $9631 r0 *1 30.14,119.68
X$9631 VGND VIA_via2_3_2000_480_1_6_320_320
* cell instance $9632 r0 *1 30.14,125.12
X$9632 VGND VIA_via2_3_2000_480_1_6_320_320
* cell instance $9633 r0 *1 90.14,119.68
X$9633 VGND VIA_via2_3_2000_480_1_6_320_320
* cell instance $9634 r0 *1 90.14,125.12
X$9634 VGND VIA_via2_3_2000_480_1_6_320_320
* cell instance $9635 r0 *1 30.14,179.52
X$9635 VGND VIA_via2_3_2000_480_1_6_320_320
* cell instance $9636 r0 *1 90.14,136
X$9636 VGND VIA_via2_3_2000_480_1_6_320_320
* cell instance $9637 r0 *1 90.14,65.28
X$9637 VGND VIA_via2_3_2000_480_1_6_320_320
* cell instance $9638 r0 *1 30.14,76.16
X$9638 VGND VIA_via2_3_2000_480_1_6_320_320
* cell instance $9639 r0 *1 30.14,81.6
X$9639 VGND VIA_via2_3_2000_480_1_6_320_320
* cell instance $9640 r0 *1 90.14,70.72
X$9640 VGND VIA_via2_3_2000_480_1_6_320_320
* cell instance $9641 r0 *1 90.14,59.84
X$9641 VGND VIA_via2_3_2000_480_1_6_320_320
* cell instance $9642 r0 *1 90.14,206.72
X$9642 VGND VIA_via2_3_2000_480_1_6_320_320
* cell instance $9643 r0 *1 90.14,54.4
X$9643 VGND VIA_via2_3_2000_480_1_6_320_320
* cell instance $9644 r0 *1 30.14,87.04
X$9644 VGND VIA_via2_3_2000_480_1_6_320_320
* cell instance $9645 r0 *1 120.14,136
X$9645 VGND VIA_via2_3_2000_480_1_6_320_320
* cell instance $9646 r0 *1 90.14,152.32
X$9646 VGND VIA_via2_3_2000_480_1_6_320_320
* cell instance $9647 r0 *1 30.14,92.48
X$9647 VGND VIA_via2_3_2000_480_1_6_320_320
* cell instance $9648 r0 *1 60.14,250.24
X$9648 VGND VIA_via2_3_2000_480_1_6_320_320
* cell instance $9649 r0 *1 90.14,217.6
X$9649 VGND VIA_via2_3_2000_480_1_6_320_320
* cell instance $9650 r0 *1 120.14,190.4
X$9650 VGND VIA_via2_3_2000_480_1_6_320_320
* cell instance $9651 r0 *1 30.14,103.36
X$9651 VGND VIA_via2_3_2000_480_1_6_320_320
* cell instance $9652 r0 *1 30.14,97.92
X$9652 VGND VIA_via2_3_2000_480_1_6_320_320
* cell instance $9653 r0 *1 120.14,184.96
X$9653 VGND VIA_via2_3_2000_480_1_6_320_320
* cell instance $9654 r0 *1 120.14,130.56
X$9654 VGND VIA_via2_3_2000_480_1_6_320_320
* cell instance $9655 r0 *1 120.14,152.32
X$9655 VGND VIA_via2_3_2000_480_1_6_320_320
* cell instance $9656 r0 *1 30.14,201.28
X$9656 VGND VIA_via2_3_2000_480_1_6_320_320
* cell instance $9657 r0 *1 120.14,157.76
X$9657 VGND VIA_via2_3_2000_480_1_6_320_320
* cell instance $9658 r0 *1 30.14,141.44
X$9658 VGND VIA_via2_3_2000_480_1_6_320_320
* cell instance $9659 r0 *1 30.14,163.2
X$9659 VGND VIA_via2_3_2000_480_1_6_320_320
* cell instance $9660 r0 *1 30.14,146.88
X$9660 VGND VIA_via2_3_2000_480_1_6_320_320
* cell instance $9661 r0 *1 30.14,152.32
X$9661 VGND VIA_via2_3_2000_480_1_6_320_320
* cell instance $9662 r0 *1 30.14,157.76
X$9662 VGND VIA_via2_3_2000_480_1_6_320_320
* cell instance $9663 r0 *1 180.14,174.08
X$9663 VGND VIA_via2_3_2000_480_1_6_320_320
* cell instance $9664 r0 *1 30.14,184.96
X$9664 VGND VIA_via2_3_2000_480_1_6_320_320
* cell instance $9665 r0 *1 180.14,179.52
X$9665 VGND VIA_via2_3_2000_480_1_6_320_320
* cell instance $9666 r0 *1 60.14,228.48
X$9666 VGND VIA_via2_3_2000_480_1_6_320_320
* cell instance $9667 r0 *1 90.14,43.52
X$9667 VGND VIA_via2_3_2000_480_1_6_320_320
* cell instance $9668 r0 *1 60.14,233.92
X$9668 VGND VIA_via2_3_2000_480_1_6_320_320
* cell instance $9669 r0 *1 90.14,38.08
X$9669 VGND VIA_via2_3_2000_480_1_6_320_320
* cell instance $9670 r0 *1 60.14,223.04
X$9670 VGND VIA_via2_3_2000_480_1_6_320_320
* cell instance $9671 r0 *1 30.14,168.64
X$9671 VGND VIA_via2_3_2000_480_1_6_320_320
* cell instance $9672 r0 *1 30.14,136
X$9672 VGND VIA_via2_3_2000_480_1_6_320_320
* cell instance $9673 r0 *1 120.14,141.44
X$9673 VGND VIA_via2_3_2000_480_1_6_320_320
* cell instance $9674 r0 *1 180.14,141.44
X$9674 VGND VIA_via2_3_2000_480_1_6_320_320
* cell instance $9675 r0 *1 120.14,146.88
X$9675 VGND VIA_via2_3_2000_480_1_6_320_320
* cell instance $9676 r0 *1 60.14,212.16
X$9676 VGND VIA_via2_3_2000_480_1_6_320_320
* cell instance $9677 r0 *1 60.14,217.6
X$9677 VGND VIA_via2_3_2000_480_1_6_320_320
* cell instance $9678 r0 *1 180.14,146.88
X$9678 VGND VIA_via2_3_2000_480_1_6_320_320
* cell instance $9679 r0 *1 180.14,168.64
X$9679 VGND VIA_via2_3_2000_480_1_6_320_320
* cell instance $9680 r0 *1 90.14,48.96
X$9680 VGND VIA_via2_3_2000_480_1_6_320_320
* cell instance $9681 r0 *1 180.14,163.2
X$9681 VGND VIA_via2_3_2000_480_1_6_320_320
* cell instance $9682 r0 *1 60.14,244.8
X$9682 VGND VIA_via2_3_2000_480_1_6_320_320
* cell instance $9683 r0 *1 60.14,239.36
X$9683 VGND VIA_via2_3_2000_480_1_6_320_320
* cell instance $9684 r0 *1 90.14,16.32
X$9684 VGND VIA_via2_3_2000_480_1_6_320_320
* cell instance $9685 r0 *1 90.14,10.88
X$9685 VGND VIA_via2_3_2000_480_1_6_320_320
* cell instance $9686 r0 *1 90.14,21.76
X$9686 VGND VIA_via2_3_2000_480_1_6_320_320
* cell instance $9687 r0 *1 60.14,157.76
X$9687 VGND VIA_via2_3_2000_480_1_6_320_320
* cell instance $9688 r0 *1 60.14,266.56
X$9688 VGND VIA_via2_3_2000_480_1_6_320_320
* cell instance $9689 r0 *1 60.14,65.28
X$9689 VGND VIA_via2_3_2000_480_1_6_320_320
* cell instance $9690 r0 *1 60.14,261.12
X$9690 VGND VIA_via2_3_2000_480_1_6_320_320
* cell instance $9691 r0 *1 60.14,255.68
X$9691 VGND VIA_via2_3_2000_480_1_6_320_320
* cell instance $9692 r0 *1 60.14,272
X$9692 VGND VIA_via2_3_2000_480_1_6_320_320
* cell instance $9693 r0 *1 120.14,195.84
X$9693 VGND VIA_via2_3_2000_480_1_6_320_320
* cell instance $9694 r0 *1 30.14,10.88
X$9694 VGND VIA_via2_3_2000_480_1_6_320_320
* cell instance $9695 r0 *1 60.14,136
X$9695 VGND VIA_via2_3_2000_480_1_6_320_320
* cell instance $9696 r0 *1 60.14,70.72
X$9696 VGND VIA_via2_3_2000_480_1_6_320_320
* cell instance $9697 r0 *1 60.14,288.32
X$9697 VGND VIA_via2_3_2000_480_1_6_320_320
* cell instance $9698 r0 *1 60.14,282.88
X$9698 VGND VIA_via2_3_2000_480_1_6_320_320
* cell instance $9699 r0 *1 60.14,277.44
X$9699 VGND VIA_via2_3_2000_480_1_6_320_320
* cell instance $9700 r0 *1 60.14,32.64
X$9700 VGND VIA_via2_3_2000_480_1_6_320_320
* cell instance $9701 r0 *1 60.14,27.2
X$9701 VGND VIA_via2_3_2000_480_1_6_320_320
* cell instance $9702 r0 *1 60.14,108.8
X$9702 VGND VIA_via2_3_2000_480_1_6_320_320
* cell instance $9703 r0 *1 60.14,97.92
X$9703 VGND VIA_via2_3_2000_480_1_6_320_320
* cell instance $9704 r0 *1 90.14,163.2
X$9704 VGND VIA_via2_3_2000_480_1_6_320_320
* cell instance $9705 r0 *1 90.14,168.64
X$9705 VGND VIA_via2_3_2000_480_1_6_320_320
* cell instance $9706 r0 *1 60.14,10.88
X$9706 VGND VIA_via2_3_2000_480_1_6_320_320
* cell instance $9707 r0 *1 60.14,21.76
X$9707 VGND VIA_via2_3_2000_480_1_6_320_320
* cell instance $9708 r0 *1 90.14,27.2
X$9708 VGND VIA_via2_3_2000_480_1_6_320_320
* cell instance $9709 r0 *1 60.14,146.88
X$9709 VGND VIA_via2_3_2000_480_1_6_320_320
* cell instance $9710 r0 *1 60.14,54.4
X$9710 VGND VIA_via2_3_2000_480_1_6_320_320
* cell instance $9711 r0 *1 90.14,108.8
X$9711 VGND VIA_via2_3_2000_480_1_6_320_320
* cell instance $9712 r0 *1 90.14,97.92
X$9712 VGND VIA_via2_3_2000_480_1_6_320_320
* cell instance $9713 r0 *1 60.14,152.32
X$9713 VGND VIA_via2_3_2000_480_1_6_320_320
* cell instance $9714 r0 *1 90.14,103.36
X$9714 VGND VIA_via2_3_2000_480_1_6_320_320
* cell instance $9715 r0 *1 60.14,141.44
X$9715 VGND VIA_via2_3_2000_480_1_6_320_320
* cell instance $9716 r0 *1 90.14,174.08
X$9716 VGND VIA_via2_3_2000_480_1_6_320_320
* cell instance $9717 r0 *1 30.14,43.52
X$9717 VGND VIA_via2_3_2000_480_1_6_320_320
* cell instance $9718 r0 *1 120.14,125.12
X$9718 VGND VIA_via2_3_2000_480_1_6_320_320
* cell instance $9719 r0 *1 180.14,152.32
X$9719 VGND VIA_via2_3_2000_480_1_6_320_320
* cell instance $9720 r0 *1 30.14,54.4
X$9720 VGND VIA_via2_3_2000_480_1_6_320_320
* cell instance $9721 r0 *1 30.14,65.28
X$9721 VGND VIA_via2_3_2000_480_1_6_320_320
* cell instance $9722 r0 *1 30.14,190.4
X$9722 VGND VIA_via2_3_2000_480_1_6_320_320
* cell instance $9723 r0 *1 30.14,70.72
X$9723 VGND VIA_via2_3_2000_480_1_6_320_320
* cell instance $9724 r0 *1 90.14,239.36
X$9724 VGND VIA_via2_3_2000_480_1_6_320_320
* cell instance $9725 r0 *1 60.14,59.84
X$9725 VGND VIA_via2_3_2000_480_1_6_320_320
* cell instance $9726 r0 *1 90.14,32.64
X$9726 VGND VIA_via2_3_2000_480_1_6_320_320
* cell instance $9727 r0 *1 60.14,130.56
X$9727 VGND VIA_via2_3_2000_480_1_6_320_320
* cell instance $9728 r0 *1 30.14,38.08
X$9728 VGND VIA_via2_3_2000_480_1_6_320_320
* cell instance $9729 r0 *1 30.14,59.84
X$9729 VGND VIA_via2_3_2000_480_1_6_320_320
* cell instance $9730 r0 *1 30.14,48.96
X$9730 VGND VIA_via2_3_2000_480_1_6_320_320
* cell instance $9731 r0 *1 180.14,157.76
X$9731 VGND VIA_via2_3_2000_480_1_6_320_320
* cell instance $9732 r0 *1 90.14,130.56
X$9732 VGND VIA_via2_3_2000_480_1_6_320_320
* cell instance $9733 r0 *1 120.14,201.28
X$9733 VGND VIA_via2_3_2000_480_1_6_320_320
* cell instance $9734 r0 *1 30.14,32.64
X$9734 VGND VIA_via2_3_2000_480_1_6_320_320
* cell instance $9735 r0 *1 30.14,16.32
X$9735 VGND VIA_via2_3_2000_480_1_6_320_320
* cell instance $9736 r0 *1 60.14,119.68
X$9736 VGND VIA_via2_3_2000_480_1_6_320_320
* cell instance $9737 r0 *1 30.14,195.84
X$9737 VGND VIA_via2_3_2000_480_1_6_320_320
* cell instance $9738 r0 *1 30.14,27.2
X$9738 VGND VIA_via2_3_2000_480_1_6_320_320
* cell instance $9739 r0 *1 60.14,38.08
X$9739 VGND VIA_via2_3_2000_480_1_6_320_320
* cell instance $9740 r0 *1 60.14,43.52
X$9740 VGND VIA_via2_3_2000_480_1_6_320_320
* cell instance $9741 r0 *1 60.14,125.12
X$9741 VGND VIA_via2_3_2000_480_1_6_320_320
* cell instance $9742 r0 *1 60.14,48.96
X$9742 VGND VIA_via2_3_2000_480_1_6_320_320
* cell instance $9743 r0 *1 90.14,179.52
X$9743 VGND VIA_via2_3_2000_480_1_6_320_320
* cell instance $9744 r0 *1 120.14,119.68
X$9744 VGND VIA_via2_3_2000_480_1_6_320_320
* cell instance $9745 r0 *1 30.14,21.76
X$9745 VGND VIA_via2_3_2000_480_1_6_320_320
* cell instance $9746 r0 *1 120.14,70.72
X$9746 VGND VIA_via2_3_2000_480_1_6_320_320
* cell instance $9747 r0 *1 120.14,228.48
X$9747 VGND VIA_via2_3_2000_480_1_6_320_320
* cell instance $9748 r0 *1 180.14,288.32
X$9748 VGND VIA_via2_3_2000_480_1_6_320_320
* cell instance $9749 r0 *1 180.14,282.88
X$9749 VGND VIA_via2_3_2000_480_1_6_320_320
* cell instance $9750 r0 *1 120.14,97.92
X$9750 VGND VIA_via2_3_2000_480_1_6_320_320
* cell instance $9751 r0 *1 120.14,103.36
X$9751 VGND VIA_via2_3_2000_480_1_6_320_320
* cell instance $9752 r0 *1 120.14,233.92
X$9752 VGND VIA_via2_3_2000_480_1_6_320_320
* cell instance $9753 r0 *1 180.14,272
X$9753 VGND VIA_via2_3_2000_480_1_6_320_320
* cell instance $9754 r0 *1 120.14,48.96
X$9754 VGND VIA_via2_3_2000_480_1_6_320_320
* cell instance $9755 r0 *1 180.14,277.44
X$9755 VGND VIA_via2_3_2000_480_1_6_320_320
* cell instance $9756 r0 *1 120.14,43.52
X$9756 VGND VIA_via2_3_2000_480_1_6_320_320
* cell instance $9757 r0 *1 120.14,38.08
X$9757 VGND VIA_via2_3_2000_480_1_6_320_320
* cell instance $9758 r0 *1 180.14,38.08
X$9758 VGND VIA_via2_3_2000_480_1_6_320_320
* cell instance $9759 r0 *1 180.14,43.52
X$9759 VGND VIA_via2_3_2000_480_1_6_320_320
* cell instance $9760 r0 *1 180.14,48.96
X$9760 VGND VIA_via2_3_2000_480_1_6_320_320
* cell instance $9761 r0 *1 180.14,54.4
X$9761 VGND VIA_via2_3_2000_480_1_6_320_320
* cell instance $9762 r0 *1 180.14,70.72
X$9762 VGND VIA_via2_3_2000_480_1_6_320_320
* cell instance $9763 r0 *1 120.14,81.6
X$9763 VGND VIA_via2_3_2000_480_1_6_320_320
* cell instance $9764 r0 *1 180.14,65.28
X$9764 VGND VIA_via2_3_2000_480_1_6_320_320
* cell instance $9765 r0 *1 120.14,277.44
X$9765 VGND VIA_via2_3_2000_480_1_6_320_320
* cell instance $9766 r0 *1 120.14,272
X$9766 VGND VIA_via2_3_2000_480_1_6_320_320
* cell instance $9767 r0 *1 180.14,59.84
X$9767 VGND VIA_via2_3_2000_480_1_6_320_320
* cell instance $9768 r0 *1 120.14,76.16
X$9768 VGND VIA_via2_3_2000_480_1_6_320_320
* cell instance $9769 r0 *1 120.14,10.88
X$9769 VGND VIA_via2_3_2000_480_1_6_320_320
* cell instance $9770 r0 *1 120.14,16.32
X$9770 VGND VIA_via2_3_2000_480_1_6_320_320
* cell instance $9771 r0 *1 120.14,27.2
X$9771 VGND VIA_via2_3_2000_480_1_6_320_320
* cell instance $9772 r0 *1 120.14,108.8
X$9772 VGND VIA_via2_3_2000_480_1_6_320_320
* cell instance $9773 r0 *1 120.14,261.12
X$9773 VGND VIA_via2_3_2000_480_1_6_320_320
* cell instance $9774 r0 *1 120.14,250.24
X$9774 VGND VIA_via2_3_2000_480_1_6_320_320
* cell instance $9775 r0 *1 120.14,266.56
X$9775 VGND VIA_via2_3_2000_480_1_6_320_320
* cell instance $9776 r0 *1 120.14,255.68
X$9776 VGND VIA_via2_3_2000_480_1_6_320_320
* cell instance $9777 r0 *1 120.14,54.4
X$9777 VGND VIA_via2_3_2000_480_1_6_320_320
* cell instance $9778 r0 *1 120.14,65.28
X$9778 VGND VIA_via2_3_2000_480_1_6_320_320
* cell instance $9779 r0 *1 120.14,282.88
X$9779 VGND VIA_via2_3_2000_480_1_6_320_320
* cell instance $9780 r0 *1 120.14,288.32
X$9780 VGND VIA_via2_3_2000_480_1_6_320_320
* cell instance $9781 r0 *1 120.14,244.8
X$9781 VGND VIA_via2_3_2000_480_1_6_320_320
* cell instance $9782 r0 *1 120.14,239.36
X$9782 VGND VIA_via2_3_2000_480_1_6_320_320
* cell instance $9783 r0 *1 180.14,266.56
X$9783 VGND VIA_via2_3_2000_480_1_6_320_320
* cell instance $9784 r0 *1 180.14,255.68
X$9784 VGND VIA_via2_3_2000_480_1_6_320_320
* cell instance $9785 r0 *1 180.14,261.12
X$9785 VGND VIA_via2_3_2000_480_1_6_320_320
* cell instance $9786 r0 *1 120.14,114.24
X$9786 VGND VIA_via2_3_2000_480_1_6_320_320
* cell instance $9787 r0 *1 180.14,250.24
X$9787 VGND VIA_via2_3_2000_480_1_6_320_320
* cell instance $9788 r0 *1 150.14,179.52
X$9788 VGND VIA_via2_3_2000_480_1_6_320_320
* cell instance $9789 r0 *1 180.14,27.2
X$9789 VGND VIA_via2_3_2000_480_1_6_320_320
* cell instance $9790 r0 *1 150.14,168.64
X$9790 VGND VIA_via2_3_2000_480_1_6_320_320
* cell instance $9791 r0 *1 120.14,92.48
X$9791 VGND VIA_via2_3_2000_480_1_6_320_320
* cell instance $9792 r0 *1 150.14,174.08
X$9792 VGND VIA_via2_3_2000_480_1_6_320_320
* cell instance $9793 r0 *1 150.14,157.76
X$9793 VGND VIA_via2_3_2000_480_1_6_320_320
* cell instance $9794 r0 *1 150.14,141.44
X$9794 VGND VIA_via2_3_2000_480_1_6_320_320
* cell instance $9795 r0 *1 150.14,146.88
X$9795 VGND VIA_via2_3_2000_480_1_6_320_320
* cell instance $9796 r0 *1 150.14,152.32
X$9796 VGND VIA_via2_3_2000_480_1_6_320_320
* cell instance $9797 r0 *1 180.14,16.32
X$9797 VGND VIA_via2_3_2000_480_1_6_320_320
* cell instance $9798 r0 *1 150.14,136
X$9798 VGND VIA_via2_3_2000_480_1_6_320_320
* cell instance $9799 r0 *1 180.14,244.8
X$9799 VGND VIA_via2_3_2000_480_1_6_320_320
* cell instance $9800 r0 *1 150.14,277.44
X$9800 VGND VIA_via2_3_2000_480_1_6_320_320
* cell instance $9801 r0 *1 150.14,282.88
X$9801 VGND VIA_via2_3_2000_480_1_6_320_320
* cell instance $9802 r0 *1 150.14,130.56
X$9802 VGND VIA_via2_3_2000_480_1_6_320_320
* cell instance $9803 r0 *1 150.14,288.32
X$9803 VGND VIA_via2_3_2000_480_1_6_320_320
* cell instance $9804 r0 *1 180.14,239.36
X$9804 VGND VIA_via2_3_2000_480_1_6_320_320
* cell instance $9805 r0 *1 150.14,125.12
X$9805 VGND VIA_via2_3_2000_480_1_6_320_320
* cell instance $9806 r0 *1 150.14,119.68
X$9806 VGND VIA_via2_3_2000_480_1_6_320_320
* cell instance $9807 r0 *1 180.14,81.6
X$9807 VGND VIA_via2_3_2000_480_1_6_320_320
* cell instance $9808 r0 *1 180.14,233.92
X$9808 VGND VIA_via2_3_2000_480_1_6_320_320
* cell instance $9809 r0 *1 150.14,272
X$9809 VGND VIA_via2_3_2000_480_1_6_320_320
* cell instance $9810 r0 *1 120.14,223.04
X$9810 VGND VIA_via2_3_2000_480_1_6_320_320
* cell instance $9811 r0 *1 150.14,239.36
X$9811 VGND VIA_via2_3_2000_480_1_6_320_320
* cell instance $9812 r0 *1 150.14,223.04
X$9812 VGND VIA_via2_3_2000_480_1_6_320_320
* cell instance $9813 r0 *1 150.14,233.92
X$9813 VGND VIA_via2_3_2000_480_1_6_320_320
* cell instance $9814 r0 *1 150.14,228.48
X$9814 VGND VIA_via2_3_2000_480_1_6_320_320
* cell instance $9815 r0 *1 150.14,206.72
X$9815 VGND VIA_via2_3_2000_480_1_6_320_320
* cell instance $9816 r0 *1 150.14,212.16
X$9816 VGND VIA_via2_3_2000_480_1_6_320_320
* cell instance $9817 r0 *1 150.14,217.6
X$9817 VGND VIA_via2_3_2000_480_1_6_320_320
* cell instance $9818 r0 *1 150.14,244.8
X$9818 VGND VIA_via2_3_2000_480_1_6_320_320
* cell instance $9819 r0 *1 150.14,261.12
X$9819 VGND VIA_via2_3_2000_480_1_6_320_320
* cell instance $9820 r0 *1 150.14,163.2
X$9820 VGND VIA_via2_3_2000_480_1_6_320_320
* cell instance $9821 r0 *1 120.14,87.04
X$9821 VGND VIA_via2_3_2000_480_1_6_320_320
* cell instance $9822 r0 *1 150.14,201.28
X$9822 VGND VIA_via2_3_2000_480_1_6_320_320
* cell instance $9823 r0 *1 120.14,217.6
X$9823 VGND VIA_via2_3_2000_480_1_6_320_320
* cell instance $9824 r0 *1 150.14,195.84
X$9824 VGND VIA_via2_3_2000_480_1_6_320_320
* cell instance $9825 r0 *1 150.14,255.68
X$9825 VGND VIA_via2_3_2000_480_1_6_320_320
* cell instance $9826 r0 *1 150.14,266.56
X$9826 VGND VIA_via2_3_2000_480_1_6_320_320
* cell instance $9827 r0 *1 150.14,184.96
X$9827 VGND VIA_via2_3_2000_480_1_6_320_320
* cell instance $9828 r0 *1 180.14,228.48
X$9828 VGND VIA_via2_3_2000_480_1_6_320_320
* cell instance $9829 r0 *1 150.14,190.4
X$9829 VGND VIA_via2_3_2000_480_1_6_320_320
* cell instance $9830 r0 *1 150.14,250.24
X$9830 VGND VIA_via2_3_2000_480_1_6_320_320
* cell instance $9831 r0 *1 180.14,217.6
X$9831 VGND VIA_via2_3_2000_480_1_6_320_320
* cell instance $9832 r0 *1 180.14,223.04
X$9832 VGND VIA_via2_3_2000_480_1_6_320_320
* cell instance $9833 r0 *1 180.14,206.72
X$9833 VGND VIA_via2_3_2000_480_1_6_320_320
* cell instance $9834 r0 *1 180.14,212.16
X$9834 VGND VIA_via2_3_2000_480_1_6_320_320
* cell instance $9835 r0 *1 120.14,59.84
X$9835 VGND VIA_via2_3_2000_480_1_6_320_320
* cell instance $9836 r0 *1 180.14,87.04
X$9836 VGND VIA_via2_3_2000_480_1_6_320_320
* cell instance $9837 r0 *1 180.14,92.48
X$9837 VGND VIA_via2_3_2000_480_1_6_320_320
* cell instance $9838 r0 *1 120.14,21.76
X$9838 VGND VIA_via2_3_2000_480_1_6_320_320
* cell instance $9839 r0 *1 180.14,21.76
X$9839 VGND VIA_via2_3_2000_480_1_6_320_320
* device instance $1 r0 *1 112.74,208.415 sky130_fd_pr__pfet_01v8_hvt
XM$1 \$I13771 \$I13782 \$I13703 VPWR sky130_fd_pr__pfet_01v8_hvt L=150000
+ W=420000 AS=109200000000 AD=69300000000 PS=1360000 PD=750000
* device instance $2 r0 *1 113.22,208.415 sky130_fd_pr__pfet_01v8_hvt
XM$2 \$I13703 \$425 \$I13719 VPWR sky130_fd_pr__pfet_01v8_hvt L=150000 W=420000
+ AS=69300000000 AD=44100000000 PS=750000 PD=630000
* device instance $3 r0 *1 113.58,208.415 sky130_fd_pr__pfet_01v8_hvt
XM$3 \$I13719 \$864 \$I13741 VPWR sky130_fd_pr__pfet_01v8_hvt L=150000 W=420000
+ AS=44100000000 AD=69300000000 PS=630000 PD=750000
* device instance $4 r0 *1 114.06,208.415 sky130_fd_pr__pfet_01v8_hvt
XM$4 \$I13741 \$340 VPWR VPWR sky130_fd_pr__pfet_01v8_hvt L=150000 W=420000
+ AS=69300000000 AD=168350000000 PS=750000 PD=1495000
* device instance $5 r0 *1 115.45,208.415 sky130_fd_pr__pfet_01v8_hvt
XM$5 VPWR \$27 \$I13782 VPWR sky130_fd_pr__pfet_01v8_hvt L=150000 W=420000
+ AS=169300000000 AD=109200000000 PS=1500000 PD=1360000
* device instance $6 r0 *1 114.545,208.705 sky130_fd_pr__pfet_01v8_hvt
XM$6 VPWR \$I13771 \$3292 VPWR sky130_fd_pr__pfet_01v8_hvt L=150000 W=1000000
+ AS=168350000000 AD=135000000000 PS=1495000 PD=1270000
* device instance $7 r0 *1 114.965,208.705 sky130_fd_pr__pfet_01v8_hvt
XM$7 \$3292 \$I13771 VPWR VPWR sky130_fd_pr__pfet_01v8_hvt L=150000 W=1000000
+ AS=135000000000 AD=169300000000 PS=1270000 PD=1500000
* device instance $8 r0 *1 121.02,143.135 sky130_fd_pr__pfet_01v8_hvt
XM$8 \$I13773 \$I13781 \$I13704 VPWR sky130_fd_pr__pfet_01v8_hvt L=150000
+ W=420000 AS=109200000000 AD=69300000000 PS=1360000 PD=750000
* device instance $9 r0 *1 121.5,143.135 sky130_fd_pr__pfet_01v8_hvt
XM$9 \$I13704 \$984 \$I13720 VPWR sky130_fd_pr__pfet_01v8_hvt L=150000 W=420000
+ AS=69300000000 AD=44100000000 PS=750000 PD=630000
* device instance $10 r0 *1 121.86,143.135 sky130_fd_pr__pfet_01v8_hvt
XM$10 \$I13720 \$760 \$I13743 VPWR sky130_fd_pr__pfet_01v8_hvt L=150000
+ W=420000 AS=44100000000 AD=69300000000 PS=630000 PD=750000
* device instance $11 r0 *1 122.34,143.135 sky130_fd_pr__pfet_01v8_hvt
XM$11 \$I13743 \$899 VPWR VPWR sky130_fd_pr__pfet_01v8_hvt L=150000 W=420000
+ AS=69300000000 AD=168350000000 PS=750000 PD=1495000
* device instance $12 r0 *1 123.73,143.135 sky130_fd_pr__pfet_01v8_hvt
XM$12 VPWR \$1050 \$I13781 VPWR sky130_fd_pr__pfet_01v8_hvt L=150000 W=420000
+ AS=169300000000 AD=109200000000 PS=1500000 PD=1360000
* device instance $13 r0 *1 122.825,143.425 sky130_fd_pr__pfet_01v8_hvt
XM$13 VPWR \$I13773 \$2068 VPWR sky130_fd_pr__pfet_01v8_hvt L=150000 W=1000000
+ AS=168350000000 AD=135000000000 PS=1495000 PD=1270000
* device instance $14 r0 *1 123.245,143.425 sky130_fd_pr__pfet_01v8_hvt
XM$14 \$2068 \$I13773 VPWR VPWR sky130_fd_pr__pfet_01v8_hvt L=150000 W=1000000
+ AS=135000000000 AD=169300000000 PS=1270000 PD=1500000
* device instance $15 r0 *1 114.09,270.305 sky130_fd_pr__pfet_01v8_hvt
XM$15 VPWR \$864 \$I14176 VPWR sky130_fd_pr__pfet_01v8_hvt L=150000 W=420000
+ AS=169300000000 AD=109200000000 PS=1500000 PD=1360000
* device instance $16 r0 *1 114.575,270.015 sky130_fd_pr__pfet_01v8_hvt
XM$16 VPWR \$I14185 \$4142 VPWR sky130_fd_pr__pfet_01v8_hvt L=150000 W=1000000
+ AS=169300000000 AD=135000000000 PS=1500000 PD=1270000
* device instance $17 r0 *1 114.995,270.015 sky130_fd_pr__pfet_01v8_hvt
XM$17 VPWR \$I14185 \$4142 VPWR sky130_fd_pr__pfet_01v8_hvt L=150000 W=1000000
+ AS=168350000000 AD=135000000000 PS=1495000 PD=1270000
* device instance $18 r0 *1 115.48,270.305 sky130_fd_pr__pfet_01v8_hvt
XM$18 VPWR \$27 \$I14188 VPWR sky130_fd_pr__pfet_01v8_hvt L=150000 W=420000
+ AS=168350000000 AD=69300000000 PS=1495000 PD=750000
* device instance $19 r0 *1 115.96,270.305 sky130_fd_pr__pfet_01v8_hvt
XM$19 \$I14188 \$340 \$I13718 VPWR sky130_fd_pr__pfet_01v8_hvt L=150000
+ W=420000 AS=69300000000 AD=44100000000 PS=750000 PD=630000
* device instance $20 r0 *1 116.32,270.305 sky130_fd_pr__pfet_01v8_hvt
XM$20 \$I13718 \$425 \$I13844 VPWR sky130_fd_pr__pfet_01v8_hvt L=150000
+ W=420000 AS=44100000000 AD=69300000000 PS=630000 PD=750000
* device instance $21 r0 *1 116.8,270.305 sky130_fd_pr__pfet_01v8_hvt
XM$21 \$I13844 \$I14176 \$I14185 VPWR sky130_fd_pr__pfet_01v8_hvt L=150000
+ W=420000 AS=69300000000 AD=109200000000 PS=750000 PD=1360000
* device instance $22 r0 *1 117.34,226.785 sky130_fd_pr__pfet_01v8_hvt
XM$22 \$I13981 \$I13984 \$I13699 VPWR sky130_fd_pr__pfet_01v8_hvt L=150000
+ W=420000 AS=109200000000 AD=69300000000 PS=1360000 PD=750000
* device instance $23 r0 *1 117.82,226.785 sky130_fd_pr__pfet_01v8_hvt
XM$23 \$I13699 \$864 \$I13715 VPWR sky130_fd_pr__pfet_01v8_hvt L=150000
+ W=420000 AS=69300000000 AD=44100000000 PS=750000 PD=630000
* device instance $24 r0 *1 118.18,226.785 sky130_fd_pr__pfet_01v8_hvt
XM$24 \$I13715 \$340 \$I13972 VPWR sky130_fd_pr__pfet_01v8_hvt L=150000
+ W=420000 AS=44100000000 AD=69300000000 PS=630000 PD=750000
* device instance $25 r0 *1 118.66,226.785 sky130_fd_pr__pfet_01v8_hvt
XM$25 VPWR \$27 \$I13972 VPWR sky130_fd_pr__pfet_01v8_hvt L=150000 W=420000
+ AS=168350000000 AD=69300000000 PS=1495000 PD=750000
* device instance $26 r0 *1 119.145,226.495 sky130_fd_pr__pfet_01v8_hvt
XM$26 VPWR \$I13981 \$3706 VPWR sky130_fd_pr__pfet_01v8_hvt L=150000 W=1000000
+ AS=168350000000 AD=135000000000 PS=1495000 PD=1270000
* device instance $27 r0 *1 119.565,226.495 sky130_fd_pr__pfet_01v8_hvt
XM$27 VPWR \$I13981 \$3706 VPWR sky130_fd_pr__pfet_01v8_hvt L=150000 W=1000000
+ AS=169300000000 AD=135000000000 PS=1500000 PD=1270000
* device instance $28 r0 *1 120.05,226.785 sky130_fd_pr__pfet_01v8_hvt
XM$28 VPWR \$425 \$I13984 VPWR sky130_fd_pr__pfet_01v8_hvt L=150000 W=420000
+ AS=169300000000 AD=109200000000 PS=1500000 PD=1360000
* device instance $29 r0 *1 164.72,251.935 sky130_fd_pr__pfet_01v8_hvt
XM$29 \$I13772 \$I13780 \$I13705 VPWR sky130_fd_pr__pfet_01v8_hvt L=150000
+ W=420000 AS=109200000000 AD=69300000000 PS=1360000 PD=750000
* device instance $30 r0 *1 165.2,251.935 sky130_fd_pr__pfet_01v8_hvt
XM$30 \$I13705 \$1103 \$I13721 VPWR sky130_fd_pr__pfet_01v8_hvt L=150000
+ W=420000 AS=69300000000 AD=44100000000 PS=750000 PD=630000
* device instance $31 r0 *1 165.56,251.935 sky130_fd_pr__pfet_01v8_hvt
XM$31 \$I13721 success \$I13742 VPWR sky130_fd_pr__pfet_01v8_hvt L=150000
+ W=420000 AS=44100000000 AD=69300000000 PS=630000 PD=750000
* device instance $32 r0 *1 166.04,251.935 sky130_fd_pr__pfet_01v8_hvt
XM$32 \$I13742 \$737 VPWR VPWR sky130_fd_pr__pfet_01v8_hvt L=150000 W=420000
+ AS=69300000000 AD=168350000000 PS=750000 PD=1495000
* device instance $33 r0 *1 167.43,251.935 sky130_fd_pr__pfet_01v8_hvt
XM$33 VPWR \$3981 \$I13780 VPWR sky130_fd_pr__pfet_01v8_hvt L=150000 W=420000
+ AS=169300000000 AD=109200000000 PS=1500000 PD=1360000
* device instance $34 r0 *1 166.525,252.225 sky130_fd_pr__pfet_01v8_hvt
XM$34 VPWR \$I13772 \$3913 VPWR sky130_fd_pr__pfet_01v8_hvt L=150000 W=1000000
+ AS=168350000000 AD=135000000000 PS=1495000 PD=1270000
* device instance $35 r0 *1 166.945,252.225 sky130_fd_pr__pfet_01v8_hvt
XM$35 \$3913 \$I13772 VPWR VPWR sky130_fd_pr__pfet_01v8_hvt L=150000 W=1000000
+ AS=135000000000 AD=169300000000 PS=1270000 PD=1500000
* device instance $36 r0 *1 118.72,61.535 sky130_fd_pr__pfet_01v8_hvt
XM$36 \$I87 \$I93 \$I43 VPWR sky130_fd_pr__pfet_01v8_hvt L=150000 W=420000
+ AS=109200000000 AD=69300000000 PS=1360000 PD=750000
* device instance $37 r0 *1 119.2,61.535 sky130_fd_pr__pfet_01v8_hvt
XM$37 \$I43 \$984 \$I52 VPWR sky130_fd_pr__pfet_01v8_hvt L=150000 W=420000
+ AS=69300000000 AD=44100000000 PS=750000 PD=630000
* device instance $38 r0 *1 119.56,61.535 sky130_fd_pr__pfet_01v8_hvt
XM$38 \$I52 \$1050 \$I18 VPWR sky130_fd_pr__pfet_01v8_hvt L=150000 W=420000
+ AS=44100000000 AD=69300000000 PS=630000 PD=750000
* device instance $39 r0 *1 120.04,61.535 sky130_fd_pr__pfet_01v8_hvt
XM$39 \$I18 \$899 VPWR VPWR sky130_fd_pr__pfet_01v8_hvt L=150000 W=420000
+ AS=69300000000 AD=168350000000 PS=750000 PD=1495000
* device instance $40 r0 *1 121.43,61.535 sky130_fd_pr__pfet_01v8_hvt
XM$40 VPWR \$760 \$I93 VPWR sky130_fd_pr__pfet_01v8_hvt L=150000 W=420000
+ AS=169300000000 AD=109200000000 PS=1500000 PD=1360000
* device instance $41 r0 *1 120.525,61.825 sky130_fd_pr__pfet_01v8_hvt
XM$41 VPWR \$I87 \$1143 VPWR sky130_fd_pr__pfet_01v8_hvt L=150000 W=1000000
+ AS=168350000000 AD=135000000000 PS=1495000 PD=1270000
* device instance $42 r0 *1 120.945,61.825 sky130_fd_pr__pfet_01v8_hvt
XM$42 \$1143 \$I87 VPWR VPWR sky130_fd_pr__pfet_01v8_hvt L=150000 W=1000000
+ AS=135000000000 AD=169300000000 PS=1270000 PD=1500000
* device instance $43 r0 *1 114.09,199.585 sky130_fd_pr__pfet_01v8_hvt
XM$43 VPWR \$340 \$I13849 VPWR sky130_fd_pr__pfet_01v8_hvt L=150000 W=420000
+ AS=169300000000 AD=109200000000 PS=1500000 PD=1360000
* device instance $44 r0 *1 114.575,199.295 sky130_fd_pr__pfet_01v8_hvt
XM$44 VPWR \$I13847 \$3175 VPWR sky130_fd_pr__pfet_01v8_hvt L=150000 W=1000000
+ AS=169300000000 AD=135000000000 PS=1500000 PD=1270000
* device instance $45 r0 *1 114.995,199.295 sky130_fd_pr__pfet_01v8_hvt
XM$45 VPWR \$I13847 \$3175 VPWR sky130_fd_pr__pfet_01v8_hvt L=150000 W=1000000
+ AS=168350000000 AD=135000000000 PS=1495000 PD=1270000
* device instance $46 r0 *1 115.48,199.585 sky130_fd_pr__pfet_01v8_hvt
XM$46 VPWR \$27 \$I13725 VPWR sky130_fd_pr__pfet_01v8_hvt L=150000 W=420000
+ AS=168350000000 AD=69300000000 PS=1495000 PD=750000
* device instance $47 r0 *1 115.96,199.585 sky130_fd_pr__pfet_01v8_hvt
XM$47 \$I13725 \$864 \$I13717 VPWR sky130_fd_pr__pfet_01v8_hvt L=150000
+ W=420000 AS=69300000000 AD=44100000000 PS=750000 PD=630000
* device instance $48 r0 *1 116.32,199.585 sky130_fd_pr__pfet_01v8_hvt
XM$48 \$I13717 \$425 \$I13845 VPWR sky130_fd_pr__pfet_01v8_hvt L=150000
+ W=420000 AS=44100000000 AD=69300000000 PS=630000 PD=750000
* device instance $49 r0 *1 116.8,199.585 sky130_fd_pr__pfet_01v8_hvt
XM$49 \$I13845 \$I13849 \$I13847 VPWR sky130_fd_pr__pfet_01v8_hvt L=150000
+ W=420000 AS=69300000000 AD=109200000000 PS=750000 PD=1360000
* device instance $50 r0 *1 111.79,72.415 sky130_fd_pr__pfet_01v8_hvt
XM$50 \$I13706 \$899 VPWR VPWR sky130_fd_pr__pfet_01v8_hvt L=150000 W=420000
+ AS=109200000000 AD=169300000000 PS=1360000 PD=1500000
* device instance $51 r0 *1 113.18,72.415 sky130_fd_pr__pfet_01v8_hvt
XM$51 VPWR \$760 \$I13722 VPWR sky130_fd_pr__pfet_01v8_hvt L=150000 W=420000
+ AS=168350000000 AD=69300000000 PS=1495000 PD=750000
* device instance $52 r0 *1 113.66,72.415 sky130_fd_pr__pfet_01v8_hvt
XM$52 \$I13722 \$1050 \$I13714 VPWR sky130_fd_pr__pfet_01v8_hvt L=150000
+ W=420000 AS=69300000000 AD=44100000000 PS=750000 PD=630000
* device instance $53 r0 *1 114.02,72.415 sky130_fd_pr__pfet_01v8_hvt
XM$53 \$I13714 \$984 \$I13698 VPWR sky130_fd_pr__pfet_01v8_hvt L=150000
+ W=420000 AS=44100000000 AD=69300000000 PS=630000 PD=750000
* device instance $54 r0 *1 114.5,72.415 sky130_fd_pr__pfet_01v8_hvt
XM$54 \$I13698 \$I13706 \$I13690 VPWR sky130_fd_pr__pfet_01v8_hvt L=150000
+ W=420000 AS=69300000000 AD=109200000000 PS=750000 PD=1360000
* device instance $55 r0 *1 112.275,72.705 sky130_fd_pr__pfet_01v8_hvt
XM$55 VPWR \$I13690 \$1273 VPWR sky130_fd_pr__pfet_01v8_hvt L=150000 W=1000000
+ AS=169300000000 AD=135000000000 PS=1500000 PD=1270000
* device instance $56 r0 *1 112.695,72.705 sky130_fd_pr__pfet_01v8_hvt
XM$56 \$1273 \$I13690 VPWR VPWR sky130_fd_pr__pfet_01v8_hvt L=150000 W=1000000
+ AS=135000000000 AD=168350000000 PS=1270000 PD=1495000
* device instance $57 r0 *1 115.5,85.345 sky130_fd_pr__pfet_01v8_hvt
XM$57 \$I13692 \$I13708 \$I13700 VPWR sky130_fd_pr__pfet_01v8_hvt L=150000
+ W=420000 AS=109200000000 AD=69300000000 PS=1360000 PD=750000
* device instance $58 r0 *1 115.98,85.345 sky130_fd_pr__pfet_01v8_hvt
XM$58 \$I13700 \$1050 \$I13716 VPWR sky130_fd_pr__pfet_01v8_hvt L=150000
+ W=420000 AS=69300000000 AD=44100000000 PS=750000 PD=630000
* device instance $59 r0 *1 116.34,85.345 sky130_fd_pr__pfet_01v8_hvt
XM$59 \$I13716 \$760 \$I13724 VPWR sky130_fd_pr__pfet_01v8_hvt L=150000
+ W=420000 AS=44100000000 AD=69300000000 PS=630000 PD=750000
* device instance $60 r0 *1 116.82,85.345 sky130_fd_pr__pfet_01v8_hvt
XM$60 VPWR \$899 \$I13724 VPWR sky130_fd_pr__pfet_01v8_hvt L=150000 W=420000
+ AS=168350000000 AD=69300000000 PS=1495000 PD=750000
* device instance $61 r0 *1 117.305,85.055 sky130_fd_pr__pfet_01v8_hvt
XM$61 VPWR \$I13692 \$1404 VPWR sky130_fd_pr__pfet_01v8_hvt L=150000 W=1000000
+ AS=168350000000 AD=135000000000 PS=1495000 PD=1270000
* device instance $62 r0 *1 117.725,85.055 sky130_fd_pr__pfet_01v8_hvt
XM$62 VPWR \$I13692 \$1404 VPWR sky130_fd_pr__pfet_01v8_hvt L=150000 W=1000000
+ AS=169300000000 AD=135000000000 PS=1500000 PD=1270000
* device instance $63 r0 *1 118.21,85.345 sky130_fd_pr__pfet_01v8_hvt
XM$63 VPWR \$984 \$I13708 VPWR sky130_fd_pr__pfet_01v8_hvt L=150000 W=420000
+ AS=169300000000 AD=109200000000 PS=1500000 PD=1360000
.ENDS puzzle

* cell sky130_fd_sc_hd__o31ai_2
* pin VGND
* pin A1
* pin A2
* pin A3
* pin Y
* pin B1
* pin VPWR
* pin VPB
* pin sky130_gnd
.SUBCKT sky130_fd_sc_hd__o31ai_2 VGND A1 A2 A3 Y B1 VPWR VPB sky130_gnd
* device instance $1 r0 *1 2.71,1.985 sky130_fd_pr__pfet_01v8_hvt
XM$1 Y A3 \$12 VPB sky130_fd_pr__pfet_01v8_hvt L=150000 W=1000000
+ AS=280000000000 AD=135000000000 PS=2560000 PD=1270000
* device instance $2 r0 *1 3.13,1.985 sky130_fd_pr__pfet_01v8_hvt
XM$2 \$12 A3 Y VPB sky130_fd_pr__pfet_01v8_hvt L=150000 W=1000000
+ AS=135000000000 AD=135000000000 PS=1270000 PD=1270000
* device instance $3 r0 *1 3.55,1.985 sky130_fd_pr__pfet_01v8_hvt
XM$3 Y B1 VPWR VPB sky130_fd_pr__pfet_01v8_hvt L=150000 W=1000000
+ AS=135000000000 AD=195000000000 PS=1270000 PD=1390000
* device instance $4 r0 *1 4.09,1.985 sky130_fd_pr__pfet_01v8_hvt
XM$4 VPWR B1 Y VPB sky130_fd_pr__pfet_01v8_hvt L=150000 W=1000000
+ AS=195000000000 AD=260000000000 PS=1390000 PD=2520000
* device instance $5 r0 *1 0.49,1.985 sky130_fd_pr__pfet_01v8_hvt
XM$5 \$9 A1 VPWR VPB sky130_fd_pr__pfet_01v8_hvt L=150000 W=1000000
+ AS=280000000000 AD=135000000000 PS=2560000 PD=1270000
* device instance $6 r0 *1 0.91,1.985 sky130_fd_pr__pfet_01v8_hvt
XM$6 VPWR A1 \$9 VPB sky130_fd_pr__pfet_01v8_hvt L=150000 W=1000000
+ AS=135000000000 AD=135000000000 PS=1270000 PD=1270000
* device instance $7 r0 *1 1.33,1.985 sky130_fd_pr__pfet_01v8_hvt
XM$7 \$9 A2 \$12 VPB sky130_fd_pr__pfet_01v8_hvt L=150000 W=1000000
+ AS=135000000000 AD=135000000000 PS=1270000 PD=1270000
* device instance $8 r0 *1 1.75,1.985 sky130_fd_pr__pfet_01v8_hvt
XM$8 \$12 A2 \$9 VPB sky130_fd_pr__pfet_01v8_hvt L=150000 W=1000000
+ AS=135000000000 AD=260000000000 PS=1270000 PD=2520000
* device instance $9 r0 *1 0.49,0.56 sky130_fd_pr__nfet_01v8
XM$9 \$3 A1 VGND sky130_gnd sky130_fd_pr__nfet_01v8 L=150000 W=650000
+ AS=182000000000 AD=87750000000 PS=1860000 PD=920000
* device instance $10 r0 *1 0.91,0.56 sky130_fd_pr__nfet_01v8
XM$10 VGND A1 \$3 sky130_gnd sky130_fd_pr__nfet_01v8 L=150000 W=650000
+ AS=87750000000 AD=87750000000 PS=920000 PD=920000
* device instance $11 r0 *1 1.33,0.56 sky130_fd_pr__nfet_01v8
XM$11 \$3 A2 VGND sky130_gnd sky130_fd_pr__nfet_01v8 L=150000 W=650000
+ AS=87750000000 AD=198250000000 PS=920000 PD=1260000
* device instance $12 r0 *1 2.09,0.56 sky130_fd_pr__nfet_01v8
XM$12 VGND A2 \$3 sky130_gnd sky130_fd_pr__nfet_01v8 L=150000 W=650000
+ AS=198250000000 AD=126750000000 PS=1260000 PD=1040000
* device instance $13 r0 *1 2.63,0.56 sky130_fd_pr__nfet_01v8
XM$13 \$3 A3 VGND sky130_gnd sky130_fd_pr__nfet_01v8 L=150000 W=650000
+ AS=126750000000 AD=113750000000 PS=1040000 PD=1000000
* device instance $14 r0 *1 3.13,0.56 sky130_fd_pr__nfet_01v8
XM$14 VGND A3 \$3 sky130_gnd sky130_fd_pr__nfet_01v8 L=150000 W=650000
+ AS=113750000000 AD=87750000000 PS=1000000 PD=920000
* device instance $15 r0 *1 3.55,0.56 sky130_fd_pr__nfet_01v8
XM$15 \$3 B1 Y sky130_gnd sky130_fd_pr__nfet_01v8 L=150000 W=650000
+ AS=87750000000 AD=126750000000 PS=920000 PD=1040000
* device instance $16 r0 *1 4.09,0.56 sky130_fd_pr__nfet_01v8
XM$16 Y B1 \$3 sky130_gnd sky130_fd_pr__nfet_01v8 L=150000 W=650000
+ AS=126750000000 AD=169000000000 PS=1040000 PD=1820000
.ENDS sky130_fd_sc_hd__o31ai_2

* cell sky130_fd_sc_hd__a21bo_2
* pin VPB
* pin VPWR
* pin VGND
* pin X
* pin B1_N
* pin A1
* pin A2
* pin sky130_gnd
.SUBCKT sky130_fd_sc_hd__a21bo_2 VPB VPWR VGND X B1_N A1 A2 sky130_gnd
* device instance $1 r0 *1 2.35,1.985 sky130_fd_pr__pfet_01v8_hvt
XM$1 \$8 \$7 \$2 VPB sky130_fd_pr__pfet_01v8_hvt L=150000 W=1000000
+ AS=260000000000 AD=135000000000 PS=2520000 PD=1270000
* device instance $2 r0 *1 2.77,1.985 sky130_fd_pr__pfet_01v8_hvt
XM$2 \$2 A1 VPWR VPB sky130_fd_pr__pfet_01v8_hvt L=150000 W=1000000
+ AS=135000000000 AD=135000000000 PS=1270000 PD=1270000
* device instance $3 r0 *1 3.19,1.985 sky130_fd_pr__pfet_01v8_hvt
XM$3 VPWR A2 \$2 VPB sky130_fd_pr__pfet_01v8_hvt L=150000 W=1000000
+ AS=135000000000 AD=260000000000 PS=1270000 PD=2520000
* device instance $4 r0 *1 1.41,1.695 sky130_fd_pr__pfet_01v8_hvt
XM$4 VPWR B1_N \$7 VPB sky130_fd_pr__pfet_01v8_hvt L=150000 W=420000
+ AS=181500000000 AD=109200000000 PS=1510000 PD=1360000
* device instance $5 r0 *1 0.47,1.985 sky130_fd_pr__pfet_01v8_hvt
XM$5 VPWR \$8 X VPB sky130_fd_pr__pfet_01v8_hvt L=150000 W=1000000
+ AS=260000000000 AD=140000000000 PS=2520000 PD=1280000
* device instance $6 r0 *1 0.9,1.985 sky130_fd_pr__pfet_01v8_hvt
XM$6 X \$8 VPWR VPB sky130_fd_pr__pfet_01v8_hvt L=150000 W=1000000
+ AS=140000000000 AD=181500000000 PS=1280000 PD=1510000
* device instance $7 r0 *1 2.35,0.56 sky130_fd_pr__nfet_01v8
XM$7 VGND \$7 \$8 sky130_gnd sky130_fd_pr__nfet_01v8 L=150000 W=650000
+ AS=169000000000 AD=107250000000 PS=1820000 PD=980000
* device instance $8 r0 *1 2.83,0.56 sky130_fd_pr__nfet_01v8
XM$8 \$8 A1 \$12 sky130_gnd sky130_fd_pr__nfet_01v8 L=150000 W=650000
+ AS=107250000000 AD=68250000000 PS=980000 PD=860000
* device instance $9 r0 *1 3.19,0.56 sky130_fd_pr__nfet_01v8
XM$9 \$12 A2 VGND sky130_gnd sky130_fd_pr__nfet_01v8 L=150000 W=650000
+ AS=68250000000 AD=169000000000 PS=860000 PD=1820000
* device instance $10 r0 *1 0.47,0.56 sky130_fd_pr__nfet_01v8
XM$10 VGND \$8 X sky130_gnd sky130_fd_pr__nfet_01v8 L=150000 W=650000
+ AS=169000000000 AD=91000000000 PS=1820000 PD=930000
* device instance $11 r0 *1 0.9,0.56 sky130_fd_pr__nfet_01v8
XM$11 X \$8 VGND sky130_gnd sky130_fd_pr__nfet_01v8 L=150000 W=650000
+ AS=91000000000 AD=108375000000 PS=930000 PD=1010000
* device instance $12 r0 *1 1.41,0.675 sky130_fd_pr__nfet_01v8
XM$12 VGND B1_N \$7 sky130_gnd sky130_fd_pr__nfet_01v8 L=150000 W=420000
+ AS=108375000000 AD=109200000000 PS=1010000 PD=1360000
.ENDS sky130_fd_sc_hd__a21bo_2

* cell sky130_fd_sc_hd__o211ai_2
* pin VGND
* pin Y
* pin A1
* pin C1
* pin B1
* pin A2
* pin VPWR
* pin VPB
* pin sky130_gnd
.SUBCKT sky130_fd_sc_hd__o211ai_2 VGND Y A1 C1 B1 A2 VPWR VPB sky130_gnd
* device instance $1 r0 *1 2.775,1.985 sky130_fd_pr__pfet_01v8_hvt
XM$1 \$10 A2 Y VPB sky130_fd_pr__pfet_01v8_hvt L=150000 W=1000000
+ AS=265000000000 AD=140000000000 PS=2530000 PD=1280000
* device instance $2 r0 *1 3.205,1.985 sky130_fd_pr__pfet_01v8_hvt
XM$2 Y A2 \$10 VPB sky130_fd_pr__pfet_01v8_hvt L=150000 W=1000000
+ AS=140000000000 AD=140000000000 PS=1280000 PD=1280000
* device instance $3 r0 *1 3.635,1.985 sky130_fd_pr__pfet_01v8_hvt
XM$3 \$10 A1 VPWR VPB sky130_fd_pr__pfet_01v8_hvt L=150000 W=1000000
+ AS=140000000000 AD=140000000000 PS=1280000 PD=1280000
* device instance $4 r0 *1 4.065,1.985 sky130_fd_pr__pfet_01v8_hvt
XM$4 VPWR A1 \$10 VPB sky130_fd_pr__pfet_01v8_hvt L=150000 W=1000000
+ AS=140000000000 AD=265000000000 PS=1280000 PD=2530000
* device instance $5 r0 *1 0.495,1.985 sky130_fd_pr__pfet_01v8_hvt
XM$5 VPWR C1 Y VPB sky130_fd_pr__pfet_01v8_hvt L=150000 W=1000000
+ AS=265000000000 AD=140000000000 PS=2530000 PD=1280000
* device instance $6 r0 *1 0.925,1.985 sky130_fd_pr__pfet_01v8_hvt
XM$6 Y C1 VPWR VPB sky130_fd_pr__pfet_01v8_hvt L=150000 W=1000000
+ AS=140000000000 AD=140000000000 PS=1280000 PD=1280000
* device instance $7 r0 *1 1.355,1.985 sky130_fd_pr__pfet_01v8_hvt
XM$7 VPWR B1 Y VPB sky130_fd_pr__pfet_01v8_hvt L=150000 W=1000000
+ AS=140000000000 AD=140000000000 PS=1280000 PD=1280000
* device instance $8 r0 *1 1.785,1.985 sky130_fd_pr__pfet_01v8_hvt
XM$8 Y B1 VPWR VPB sky130_fd_pr__pfet_01v8_hvt L=150000 W=1000000
+ AS=140000000000 AD=265000000000 PS=1280000 PD=2530000
* device instance $9 r0 *1 2.775,0.56 sky130_fd_pr__nfet_01v8
XM$9 VGND A2 \$5 sky130_gnd sky130_fd_pr__nfet_01v8 L=150000 W=650000
+ AS=185250000000 AD=91000000000 PS=1870000 PD=930000
* device instance $10 r0 *1 3.205,0.56 sky130_fd_pr__nfet_01v8
XM$10 \$5 A2 VGND sky130_gnd sky130_fd_pr__nfet_01v8 L=150000 W=650000
+ AS=91000000000 AD=91000000000 PS=930000 PD=930000
* device instance $11 r0 *1 3.635,0.56 sky130_fd_pr__nfet_01v8
XM$11 VGND A1 \$5 sky130_gnd sky130_fd_pr__nfet_01v8 L=150000 W=650000
+ AS=91000000000 AD=91000000000 PS=930000 PD=930000
* device instance $12 r0 *1 4.065,0.56 sky130_fd_pr__nfet_01v8
XM$12 \$5 A1 VGND sky130_gnd sky130_fd_pr__nfet_01v8 L=150000 W=650000
+ AS=91000000000 AD=185250000000 PS=930000 PD=1870000
* device instance $13 r0 *1 0.495,0.56 sky130_fd_pr__nfet_01v8
XM$13 \$3 C1 Y sky130_gnd sky130_fd_pr__nfet_01v8 L=150000 W=650000
+ AS=185250000000 AD=91000000000 PS=1870000 PD=930000
* device instance $14 r0 *1 0.925,0.56 sky130_fd_pr__nfet_01v8
XM$14 Y C1 \$3 sky130_gnd sky130_fd_pr__nfet_01v8 L=150000 W=650000
+ AS=91000000000 AD=91000000000 PS=930000 PD=930000
* device instance $15 r0 *1 1.355,0.56 sky130_fd_pr__nfet_01v8
XM$15 \$3 B1 \$5 sky130_gnd sky130_fd_pr__nfet_01v8 L=150000 W=650000
+ AS=91000000000 AD=91000000000 PS=930000 PD=930000
* device instance $16 r0 *1 1.785,0.56 sky130_fd_pr__nfet_01v8
XM$16 \$5 B1 \$3 sky130_gnd sky130_fd_pr__nfet_01v8 L=150000 W=650000
+ AS=91000000000 AD=185250000000 PS=930000 PD=1870000
.ENDS sky130_fd_sc_hd__o211ai_2

* cell sky130_fd_sc_hd__o21bai_2
* pin VGND
* pin B1_N
* pin Y
* pin A2
* pin A1
* pin VPWR
* pin VPB
* pin sky130_gnd
.SUBCKT sky130_fd_sc_hd__o21bai_2 VGND B1_N Y A2 A1 VPWR VPB sky130_gnd
* device instance $1 r0 *1 0.475,1.695 sky130_fd_pr__pfet_01v8_hvt
XM$1 \$3 B1_N VPWR VPB sky130_fd_pr__pfet_01v8_hvt L=150000 W=420000
+ AS=109200000000 AD=145750000000 PS=1360000 PD=1335000
* device instance $2 r0 *1 0.96,1.985 sky130_fd_pr__pfet_01v8_hvt
XM$2 VPWR \$3 Y VPB sky130_fd_pr__pfet_01v8_hvt L=150000 W=1000000
+ AS=145750000000 AD=135000000000 PS=1335000 PD=1270000
* device instance $3 r0 *1 1.38,1.985 sky130_fd_pr__pfet_01v8_hvt
XM$3 Y \$3 VPWR VPB sky130_fd_pr__pfet_01v8_hvt L=150000 W=1000000
+ AS=135000000000 AD=260000000000 PS=1270000 PD=2520000
* device instance $4 r0 *1 2.32,1.985 sky130_fd_pr__pfet_01v8_hvt
XM$4 \$9 A2 Y VPB sky130_fd_pr__pfet_01v8_hvt L=150000 W=1000000
+ AS=260000000000 AD=135000000000 PS=2520000 PD=1270000
* device instance $5 r0 *1 2.74,1.985 sky130_fd_pr__pfet_01v8_hvt
XM$5 Y A2 \$9 VPB sky130_fd_pr__pfet_01v8_hvt L=150000 W=1000000
+ AS=135000000000 AD=135000000000 PS=1270000 PD=1270000
* device instance $6 r0 *1 3.16,1.985 sky130_fd_pr__pfet_01v8_hvt
XM$6 \$9 A1 VPWR VPB sky130_fd_pr__pfet_01v8_hvt L=150000 W=1000000
+ AS=135000000000 AD=135000000000 PS=1270000 PD=1270000
* device instance $7 r0 *1 3.58,1.985 sky130_fd_pr__pfet_01v8_hvt
XM$7 VPWR A1 \$9 VPB sky130_fd_pr__pfet_01v8_hvt L=150000 W=1000000
+ AS=135000000000 AD=280000000000 PS=1270000 PD=2560000
* device instance $8 r0 *1 1.48,0.56 sky130_fd_pr__nfet_01v8
XM$8 \$4 \$3 Y sky130_gnd sky130_fd_pr__nfet_01v8 L=150000 W=650000
+ AS=169000000000 AD=87750000000 PS=1820000 PD=920000
* device instance $9 r0 *1 1.9,0.56 sky130_fd_pr__nfet_01v8
XM$9 Y \$3 \$4 sky130_gnd sky130_fd_pr__nfet_01v8 L=150000 W=650000
+ AS=87750000000 AD=87750000000 PS=920000 PD=920000
* device instance $10 r0 *1 2.32,0.56 sky130_fd_pr__nfet_01v8
XM$10 \$4 A2 VGND sky130_gnd sky130_fd_pr__nfet_01v8 L=150000 W=650000
+ AS=87750000000 AD=87750000000 PS=920000 PD=920000
* device instance $11 r0 *1 2.74,0.56 sky130_fd_pr__nfet_01v8
XM$11 VGND A2 \$4 sky130_gnd sky130_fd_pr__nfet_01v8 L=150000 W=650000
+ AS=87750000000 AD=87750000000 PS=920000 PD=920000
* device instance $12 r0 *1 3.16,0.56 sky130_fd_pr__nfet_01v8
XM$12 \$4 A1 VGND sky130_gnd sky130_fd_pr__nfet_01v8 L=150000 W=650000
+ AS=87750000000 AD=87750000000 PS=920000 PD=920000
* device instance $13 r0 *1 3.58,0.56 sky130_fd_pr__nfet_01v8
XM$13 VGND A1 \$4 sky130_gnd sky130_fd_pr__nfet_01v8 L=150000 W=650000
+ AS=87750000000 AD=182000000000 PS=920000 PD=1860000
* device instance $14 r0 *1 0.475,0.675 sky130_fd_pr__nfet_01v8
XM$14 VGND B1_N \$3 sky130_gnd sky130_fd_pr__nfet_01v8 L=150000 W=420000
+ AS=109200000000 AD=109200000000 PS=1360000 PD=1360000
.ENDS sky130_fd_sc_hd__o21bai_2

* cell sky130_fd_sc_hd__a311o_2
* pin VGND
* pin X
* pin A3
* pin A2
* pin A1
* pin B1
* pin C1
* pin VPWR
* pin VPB
* pin sky130_gnd
.SUBCKT sky130_fd_sc_hd__a311o_2 VGND X A3 A2 A1 B1 C1 VPWR VPB sky130_gnd
* device instance $1 r0 *1 0.47,1.985 sky130_fd_pr__pfet_01v8_hvt
XM$1 VPWR \$4 X VPB sky130_fd_pr__pfet_01v8_hvt L=150000 W=1000000
+ AS=260000000000 AD=135000000000 PS=2520000 PD=1270000
* device instance $2 r0 *1 0.89,1.985 sky130_fd_pr__pfet_01v8_hvt
XM$2 X \$4 VPWR VPB sky130_fd_pr__pfet_01v8_hvt L=150000 W=1000000
+ AS=135000000000 AD=240000000000 PS=1270000 PD=1480000
* device instance $3 r0 *1 1.52,1.985 sky130_fd_pr__pfet_01v8_hvt
XM$3 VPWR A3 \$13 VPB sky130_fd_pr__pfet_01v8_hvt L=150000 W=1000000
+ AS=240000000000 AD=170000000000 PS=1480000 PD=1340000
* device instance $4 r0 *1 2.01,1.985 sky130_fd_pr__pfet_01v8_hvt
XM$4 \$13 A2 VPWR VPB sky130_fd_pr__pfet_01v8_hvt L=150000 W=1000000
+ AS=170000000000 AD=185000000000 PS=1340000 PD=1370000
* device instance $5 r0 *1 2.53,1.985 sky130_fd_pr__pfet_01v8_hvt
XM$5 VPWR A1 \$13 VPB sky130_fd_pr__pfet_01v8_hvt L=150000 W=1000000
+ AS=185000000000 AD=210000000000 PS=1370000 PD=1420000
* device instance $6 r0 *1 3.1,1.985 sky130_fd_pr__pfet_01v8_hvt
XM$6 \$13 B1 \$15 VPB sky130_fd_pr__pfet_01v8_hvt L=150000 W=1000000
+ AS=210000000000 AD=210000000000 PS=1420000 PD=1420000
* device instance $7 r0 *1 3.67,1.985 sky130_fd_pr__pfet_01v8_hvt
XM$7 \$15 C1 \$4 VPB sky130_fd_pr__pfet_01v8_hvt L=150000 W=1000000
+ AS=210000000000 AD=260000000000 PS=1420000 PD=2520000
* device instance $8 r0 *1 0.47,0.56 sky130_fd_pr__nfet_01v8
XM$8 VGND \$4 X sky130_gnd sky130_fd_pr__nfet_01v8 L=150000 W=650000
+ AS=169000000000 AD=87750000000 PS=1820000 PD=920000
* device instance $9 r0 *1 0.89,0.56 sky130_fd_pr__nfet_01v8
XM$9 X \$4 VGND sky130_gnd sky130_fd_pr__nfet_01v8 L=150000 W=650000
+ AS=87750000000 AD=156000000000 PS=920000 PD=1130000
* device instance $10 r0 *1 1.52,0.56 sky130_fd_pr__nfet_01v8
XM$10 VGND A3 \$6 sky130_gnd sky130_fd_pr__nfet_01v8 L=150000 W=650000
+ AS=156000000000 AD=110500000000 PS=1130000 PD=990000
* device instance $11 r0 *1 2.01,0.56 sky130_fd_pr__nfet_01v8
XM$11 \$6 A2 \$5 sky130_gnd sky130_fd_pr__nfet_01v8 L=150000 W=650000
+ AS=110500000000 AD=120250000000 PS=990000 PD=1020000
* device instance $12 r0 *1 2.53,0.56 sky130_fd_pr__nfet_01v8
XM$12 \$5 A1 \$4 sky130_gnd sky130_fd_pr__nfet_01v8 L=150000 W=650000
+ AS=120250000000 AD=133250000000 PS=1020000 PD=1060000
* device instance $13 r0 *1 3.09,0.56 sky130_fd_pr__nfet_01v8
XM$13 \$4 B1 VGND sky130_gnd sky130_fd_pr__nfet_01v8 L=150000 W=650000
+ AS=133250000000 AD=139750000000 PS=1060000 PD=1080000
* device instance $14 r0 *1 3.67,0.56 sky130_fd_pr__nfet_01v8
XM$14 VGND C1 \$4 sky130_gnd sky130_fd_pr__nfet_01v8 L=150000 W=650000
+ AS=139750000000 AD=169000000000 PS=1080000 PD=1820000
.ENDS sky130_fd_sc_hd__a311o_2

* cell sky130_fd_sc_hd__o32ai_2
* pin VGND
* pin A3
* pin Y
* pin B2
* pin B1
* pin A2
* pin A1
* pin VPWR
* pin VPB
* pin sky130_gnd
.SUBCKT sky130_fd_sc_hd__o32ai_2 VGND A3 Y B2 B1 A2 A1 VPWR VPB sky130_gnd
* device instance $1 r0 *1 4.95,1.985 sky130_fd_pr__pfet_01v8_hvt
XM$1 VPWR A1 \$12 VPB sky130_fd_pr__pfet_01v8_hvt L=150000 W=1000000
+ AS=260000000000 AD=135000000000 PS=2520000 PD=1270000
* device instance $2 r0 *1 5.37,1.985 sky130_fd_pr__pfet_01v8_hvt
XM$2 \$12 A1 VPWR VPB sky130_fd_pr__pfet_01v8_hvt L=150000 W=1000000
+ AS=135000000000 AD=280000000000 PS=1270000 PD=2560000
* device instance $3 r0 *1 2.73,1.985 sky130_fd_pr__pfet_01v8_hvt
XM$3 \$11 A3 Y VPB sky130_fd_pr__pfet_01v8_hvt L=150000 W=1000000
+ AS=280000000000 AD=135000000000 PS=2560000 PD=1270000
* device instance $4 r0 *1 3.15,1.985 sky130_fd_pr__pfet_01v8_hvt
XM$4 Y A3 \$11 VPB sky130_fd_pr__pfet_01v8_hvt L=150000 W=1000000
+ AS=135000000000 AD=135000000000 PS=1270000 PD=1270000
* device instance $5 r0 *1 3.57,1.985 sky130_fd_pr__pfet_01v8_hvt
XM$5 \$11 A2 \$12 VPB sky130_fd_pr__pfet_01v8_hvt L=150000 W=1000000
+ AS=135000000000 AD=135000000000 PS=1270000 PD=1270000
* device instance $6 r0 *1 3.99,1.985 sky130_fd_pr__pfet_01v8_hvt
XM$6 \$12 A2 \$11 VPB sky130_fd_pr__pfet_01v8_hvt L=150000 W=1000000
+ AS=135000000000 AD=280000000000 PS=1270000 PD=2560000
* device instance $7 r0 *1 0.47,1.985 sky130_fd_pr__pfet_01v8_hvt
XM$7 \$10 B2 Y VPB sky130_fd_pr__pfet_01v8_hvt L=150000 W=1000000
+ AS=260000000000 AD=135000000000 PS=2520000 PD=1270000
* device instance $8 r0 *1 0.89,1.985 sky130_fd_pr__pfet_01v8_hvt
XM$8 Y B2 \$10 VPB sky130_fd_pr__pfet_01v8_hvt L=150000 W=1000000
+ AS=135000000000 AD=135000000000 PS=1270000 PD=1270000
* device instance $9 r0 *1 1.31,1.985 sky130_fd_pr__pfet_01v8_hvt
XM$9 \$10 B1 VPWR VPB sky130_fd_pr__pfet_01v8_hvt L=150000 W=1000000
+ AS=135000000000 AD=135000000000 PS=1270000 PD=1270000
* device instance $10 r0 *1 1.73,1.985 sky130_fd_pr__pfet_01v8_hvt
XM$10 VPWR B1 \$10 VPB sky130_fd_pr__pfet_01v8_hvt L=150000 W=1000000
+ AS=135000000000 AD=260000000000 PS=1270000 PD=2520000
* device instance $11 r0 *1 0.47,0.56 sky130_fd_pr__nfet_01v8
XM$11 \$4 B2 Y sky130_gnd sky130_fd_pr__nfet_01v8 L=150000 W=650000
+ AS=169000000000 AD=87750000000 PS=1820000 PD=920000
* device instance $12 r0 *1 0.89,0.56 sky130_fd_pr__nfet_01v8
XM$12 Y B2 \$4 sky130_gnd sky130_fd_pr__nfet_01v8 L=150000 W=650000
+ AS=87750000000 AD=87750000000 PS=920000 PD=920000
* device instance $13 r0 *1 1.31,0.56 sky130_fd_pr__nfet_01v8
XM$13 \$4 B1 Y sky130_gnd sky130_fd_pr__nfet_01v8 L=150000 W=650000
+ AS=87750000000 AD=87750000000 PS=920000 PD=920000
* device instance $14 r0 *1 1.73,0.56 sky130_fd_pr__nfet_01v8
XM$14 Y B1 \$4 sky130_gnd sky130_fd_pr__nfet_01v8 L=150000 W=650000
+ AS=87750000000 AD=87750000000 PS=920000 PD=920000
* device instance $15 r0 *1 2.15,0.56 sky130_fd_pr__nfet_01v8
XM$15 \$4 A3 VGND sky130_gnd sky130_fd_pr__nfet_01v8 L=150000 W=650000
+ AS=87750000000 AD=256750000000 PS=920000 PD=1440000
* device instance $16 r0 *1 3.09,0.56 sky130_fd_pr__nfet_01v8
XM$16 VGND A3 \$4 sky130_gnd sky130_fd_pr__nfet_01v8 L=150000 W=650000
+ AS=256750000000 AD=87750000000 PS=1440000 PD=920000
* device instance $17 r0 *1 3.51,0.56 sky130_fd_pr__nfet_01v8
XM$17 \$4 A2 VGND sky130_gnd sky130_fd_pr__nfet_01v8 L=150000 W=650000
+ AS=87750000000 AD=87750000000 PS=920000 PD=920000
* device instance $18 r0 *1 3.93,0.56 sky130_fd_pr__nfet_01v8
XM$18 VGND A2 \$4 sky130_gnd sky130_fd_pr__nfet_01v8 L=150000 W=650000
+ AS=87750000000 AD=256750000000 PS=920000 PD=1440000
* device instance $19 r0 *1 4.87,0.56 sky130_fd_pr__nfet_01v8
XM$19 \$4 A1 VGND sky130_gnd sky130_fd_pr__nfet_01v8 L=150000 W=650000
+ AS=256750000000 AD=87750000000 PS=1440000 PD=920000
* device instance $20 r0 *1 5.29,0.56 sky130_fd_pr__nfet_01v8
XM$20 VGND A1 \$4 sky130_gnd sky130_fd_pr__nfet_01v8 L=150000 W=650000
+ AS=87750000000 AD=227500000000 PS=920000 PD=2000000
.ENDS sky130_fd_sc_hd__o32ai_2

* cell sky130_fd_sc_hd__a31oi_2
* pin VGND
* pin Y
* pin A3
* pin A2
* pin A1
* pin B1
* pin VPWR
* pin VPB
* pin sky130_gnd
.SUBCKT sky130_fd_sc_hd__a31oi_2 VGND Y A3 A2 A1 B1 VPWR VPB sky130_gnd
* device instance $1 r0 *1 0.47,1.985 sky130_fd_pr__pfet_01v8_hvt
XM$1 \$11 A3 VPWR VPB sky130_fd_pr__pfet_01v8_hvt L=150000 W=1000000
+ AS=260000000000 AD=135000000000 PS=2520000 PD=1270000
* device instance $2 r0 *1 0.89,1.985 sky130_fd_pr__pfet_01v8_hvt
XM$2 VPWR A3 \$11 VPB sky130_fd_pr__pfet_01v8_hvt L=150000 W=1000000
+ AS=135000000000 AD=135000000000 PS=1270000 PD=1270000
* device instance $3 r0 *1 1.31,1.985 sky130_fd_pr__pfet_01v8_hvt
XM$3 \$11 A2 VPWR VPB sky130_fd_pr__pfet_01v8_hvt L=150000 W=1000000
+ AS=135000000000 AD=135000000000 PS=1270000 PD=1270000
* device instance $4 r0 *1 1.73,1.985 sky130_fd_pr__pfet_01v8_hvt
XM$4 VPWR A2 \$11 VPB sky130_fd_pr__pfet_01v8_hvt L=150000 W=1000000
+ AS=135000000000 AD=135000000000 PS=1270000 PD=1270000
* device instance $5 r0 *1 2.15,1.985 sky130_fd_pr__pfet_01v8_hvt
XM$5 \$11 A1 VPWR VPB sky130_fd_pr__pfet_01v8_hvt L=150000 W=1000000
+ AS=135000000000 AD=410000000000 PS=1270000 PD=1820000
* device instance $6 r0 *1 3.12,1.985 sky130_fd_pr__pfet_01v8_hvt
XM$6 VPWR A1 \$11 VPB sky130_fd_pr__pfet_01v8_hvt L=150000 W=1000000
+ AS=410000000000 AD=180000000000 PS=1820000 PD=1360000
* device instance $7 r0 *1 3.63,1.985 sky130_fd_pr__pfet_01v8_hvt
XM$7 \$11 B1 Y VPB sky130_fd_pr__pfet_01v8_hvt L=150000 W=1000000
+ AS=180000000000 AD=175000000000 PS=1360000 PD=1350000
* device instance $8 r0 *1 4.13,1.985 sky130_fd_pr__pfet_01v8_hvt
XM$8 Y B1 \$11 VPB sky130_fd_pr__pfet_01v8_hvt L=150000 W=1000000
+ AS=175000000000 AD=260000000000 PS=1350000 PD=2520000
* device instance $9 r0 *1 2.67,0.56 sky130_fd_pr__nfet_01v8
XM$9 Y A1 \$4 sky130_gnd sky130_fd_pr__nfet_01v8 L=150000 W=650000
+ AS=169000000000 AD=97500000000 PS=1820000 PD=950000
* device instance $10 r0 *1 3.12,0.56 sky130_fd_pr__nfet_01v8
XM$10 \$4 A1 Y sky130_gnd sky130_fd_pr__nfet_01v8 L=150000 W=650000
+ AS=97500000000 AD=117000000000 PS=950000 PD=1010000
* device instance $11 r0 *1 3.63,0.56 sky130_fd_pr__nfet_01v8
XM$11 Y B1 VGND sky130_gnd sky130_fd_pr__nfet_01v8 L=150000 W=650000
+ AS=117000000000 AD=113750000000 PS=1010000 PD=1000000
* device instance $12 r0 *1 4.13,0.56 sky130_fd_pr__nfet_01v8
XM$12 VGND B1 Y sky130_gnd sky130_fd_pr__nfet_01v8 L=150000 W=650000
+ AS=113750000000 AD=169000000000 PS=1000000 PD=1820000
* device instance $13 r0 *1 0.47,0.56 sky130_fd_pr__nfet_01v8
XM$13 \$3 A3 VGND sky130_gnd sky130_fd_pr__nfet_01v8 L=150000 W=650000
+ AS=169000000000 AD=87750000000 PS=1820000 PD=920000
* device instance $14 r0 *1 0.89,0.56 sky130_fd_pr__nfet_01v8
XM$14 VGND A3 \$3 sky130_gnd sky130_fd_pr__nfet_01v8 L=150000 W=650000
+ AS=87750000000 AD=87750000000 PS=920000 PD=920000
* device instance $15 r0 *1 1.31,0.56 sky130_fd_pr__nfet_01v8
XM$15 \$3 A2 \$4 sky130_gnd sky130_fd_pr__nfet_01v8 L=150000 W=650000
+ AS=87750000000 AD=87750000000 PS=920000 PD=920000
* device instance $16 r0 *1 1.73,0.56 sky130_fd_pr__nfet_01v8
XM$16 \$4 A2 \$3 sky130_gnd sky130_fd_pr__nfet_01v8 L=150000 W=650000
+ AS=87750000000 AD=169000000000 PS=920000 PD=1820000
.ENDS sky130_fd_sc_hd__a31oi_2

* cell sky130_fd_sc_hd__o22ai_2
* pin VGND
* pin Y
* pin B1
* pin B2
* pin A2
* pin A1
* pin VPWR
* pin VPB
* pin sky130_gnd
.SUBCKT sky130_fd_sc_hd__o22ai_2 VGND Y B1 B2 A2 A1 VPWR VPB sky130_gnd
* device instance $1 r0 *1 2.73,1.985 sky130_fd_pr__pfet_01v8_hvt
XM$1 \$10 A2 Y VPB sky130_fd_pr__pfet_01v8_hvt L=150000 W=1000000
+ AS=280000000000 AD=135000000000 PS=2560000 PD=1270000
* device instance $2 r0 *1 3.15,1.985 sky130_fd_pr__pfet_01v8_hvt
XM$2 Y A2 \$10 VPB sky130_fd_pr__pfet_01v8_hvt L=150000 W=1000000
+ AS=135000000000 AD=135000000000 PS=1270000 PD=1270000
* device instance $3 r0 *1 3.57,1.985 sky130_fd_pr__pfet_01v8_hvt
XM$3 \$10 A1 VPWR VPB sky130_fd_pr__pfet_01v8_hvt L=150000 W=1000000
+ AS=135000000000 AD=135000000000 PS=1270000 PD=1270000
* device instance $4 r0 *1 3.99,1.985 sky130_fd_pr__pfet_01v8_hvt
XM$4 VPWR A1 \$10 VPB sky130_fd_pr__pfet_01v8_hvt L=150000 W=1000000
+ AS=135000000000 AD=280000000000 PS=1270000 PD=2560000
* device instance $5 r0 *1 0.49,1.985 sky130_fd_pr__pfet_01v8_hvt
XM$5 \$9 B1 VPWR VPB sky130_fd_pr__pfet_01v8_hvt L=150000 W=1000000
+ AS=280000000000 AD=135000000000 PS=2560000 PD=1270000
* device instance $6 r0 *1 0.91,1.985 sky130_fd_pr__pfet_01v8_hvt
XM$6 VPWR B1 \$9 VPB sky130_fd_pr__pfet_01v8_hvt L=150000 W=1000000
+ AS=135000000000 AD=135000000000 PS=1270000 PD=1270000
* device instance $7 r0 *1 1.33,1.985 sky130_fd_pr__pfet_01v8_hvt
XM$7 \$9 B2 Y VPB sky130_fd_pr__pfet_01v8_hvt L=150000 W=1000000
+ AS=135000000000 AD=135000000000 PS=1270000 PD=1270000
* device instance $8 r0 *1 1.75,1.985 sky130_fd_pr__pfet_01v8_hvt
XM$8 Y B2 \$9 VPB sky130_fd_pr__pfet_01v8_hvt L=150000 W=1000000
+ AS=135000000000 AD=280000000000 PS=1270000 PD=2560000
* device instance $9 r0 *1 0.49,0.56 sky130_fd_pr__nfet_01v8
XM$9 \$3 B1 Y sky130_gnd sky130_fd_pr__nfet_01v8 L=150000 W=650000
+ AS=182000000000 AD=87750000000 PS=1860000 PD=920000
* device instance $10 r0 *1 0.91,0.56 sky130_fd_pr__nfet_01v8
XM$10 Y B1 \$3 sky130_gnd sky130_fd_pr__nfet_01v8 L=150000 W=650000
+ AS=87750000000 AD=87750000000 PS=920000 PD=920000
* device instance $11 r0 *1 1.33,0.56 sky130_fd_pr__nfet_01v8
XM$11 \$3 B2 Y sky130_gnd sky130_fd_pr__nfet_01v8 L=150000 W=650000
+ AS=87750000000 AD=87750000000 PS=920000 PD=920000
* device instance $12 r0 *1 1.75,0.56 sky130_fd_pr__nfet_01v8
XM$12 Y B2 \$3 sky130_gnd sky130_fd_pr__nfet_01v8 L=150000 W=650000
+ AS=87750000000 AD=269750000000 PS=920000 PD=1480000
* device instance $13 r0 *1 2.73,0.56 sky130_fd_pr__nfet_01v8
XM$13 \$3 A2 VGND sky130_gnd sky130_fd_pr__nfet_01v8 L=150000 W=650000
+ AS=269750000000 AD=87750000000 PS=1480000 PD=920000
* device instance $14 r0 *1 3.15,0.56 sky130_fd_pr__nfet_01v8
XM$14 VGND A2 \$3 sky130_gnd sky130_fd_pr__nfet_01v8 L=150000 W=650000
+ AS=87750000000 AD=87750000000 PS=920000 PD=920000
* device instance $15 r0 *1 3.57,0.56 sky130_fd_pr__nfet_01v8
XM$15 \$3 A1 VGND sky130_gnd sky130_fd_pr__nfet_01v8 L=150000 W=650000
+ AS=87750000000 AD=87750000000 PS=920000 PD=920000
* device instance $16 r0 *1 3.99,0.56 sky130_fd_pr__nfet_01v8
XM$16 VGND A1 \$3 sky130_gnd sky130_fd_pr__nfet_01v8 L=150000 W=650000
+ AS=87750000000 AD=169000000000 PS=920000 PD=1820000
.ENDS sky130_fd_sc_hd__o22ai_2

* cell sky130_fd_sc_hd__o2bb2a_2
* pin VGND
* pin X
* pin A2_N
* pin A1_N
* pin B2
* pin B1
* pin VPWR
* pin VPB
* pin sky130_gnd
.SUBCKT sky130_fd_sc_hd__o2bb2a_2 VGND X A2_N A1_N B2 B1 VPWR VPB sky130_gnd
* device instance $1 r0 *1 0.495,1.985 sky130_fd_pr__pfet_01v8_hvt
XM$1 VPWR \$8 X VPB sky130_fd_pr__pfet_01v8_hvt L=150000 W=1000000
+ AS=285000000000 AD=135000000000 PS=2570000 PD=1270000
* device instance $2 r0 *1 0.915,1.985 sky130_fd_pr__pfet_01v8_hvt
XM$2 X \$8 VPWR VPB sky130_fd_pr__pfet_01v8_hvt L=150000 W=1000000
+ AS=135000000000 AD=154000000000 PS=1270000 PD=1335000
* device instance $3 r0 *1 1.4,2.165 sky130_fd_pr__pfet_01v8_hvt
XM$3 VPWR A1_N \$5 VPB sky130_fd_pr__pfet_01v8_hvt L=150000 W=640000
+ AS=154000000000 AD=173000000000 PS=1335000 PD=1400000
* device instance $4 r0 *1 1.95,2.165 sky130_fd_pr__pfet_01v8_hvt
XM$4 \$5 A2_N VPWR VPB sky130_fd_pr__pfet_01v8_hvt L=150000 W=640000
+ AS=173000000000 AD=227200000000 PS=1400000 PD=1350000
* device instance $5 r0 *1 2.81,2.165 sky130_fd_pr__pfet_01v8_hvt
XM$5 VPWR \$5 \$8 VPB sky130_fd_pr__pfet_01v8_hvt L=150000 W=640000
+ AS=227200000000 AD=92800000000 PS=1350000 PD=930000
* device instance $6 r0 *1 3.25,2.165 sky130_fd_pr__pfet_01v8_hvt
XM$6 \$8 B2 \$13 VPB sky130_fd_pr__pfet_01v8_hvt L=150000 W=640000
+ AS=92800000000 AD=86400000000 PS=930000 PD=910000
* device instance $7 r0 *1 3.67,2.165 sky130_fd_pr__pfet_01v8_hvt
XM$7 \$13 B1 VPWR VPB sky130_fd_pr__pfet_01v8_hvt L=150000 W=640000
+ AS=86400000000 AD=166400000000 PS=910000 PD=1800000
* device instance $8 r0 *1 1.395,0.445 sky130_fd_pr__nfet_01v8
XM$8 VGND A1_N \$7 sky130_gnd sky130_fd_pr__nfet_01v8 L=150000 W=420000
+ AS=98625000000 AD=66150000000 PS=980000 PD=735000
* device instance $9 r0 *1 1.86,0.445 sky130_fd_pr__nfet_01v8
XM$9 \$7 A2_N \$5 sky130_gnd sky130_fd_pr__nfet_01v8 L=150000 W=420000
+ AS=66150000000 AD=109200000000 PS=735000 PD=1360000
* device instance $10 r0 *1 0.495,0.56 sky130_fd_pr__nfet_01v8
XM$10 VGND \$8 X sky130_gnd sky130_fd_pr__nfet_01v8 L=150000 W=650000
+ AS=185250000000 AD=87750000000 PS=1870000 PD=920000
* device instance $11 r0 *1 0.915,0.56 sky130_fd_pr__nfet_01v8
XM$11 X \$8 VGND sky130_gnd sky130_fd_pr__nfet_01v8 L=150000 W=650000
+ AS=87750000000 AD=98625000000 PS=920000 PD=980000
* device instance $12 r0 *1 2.83,0.445 sky130_fd_pr__nfet_01v8
XM$12 \$8 \$5 \$6 sky130_gnd sky130_fd_pr__nfet_01v8 L=150000 W=420000
+ AS=109200000000 AD=56700000000 PS=1360000 PD=690000
* device instance $13 r0 *1 3.25,0.445 sky130_fd_pr__nfet_01v8
XM$13 \$6 B2 VGND sky130_gnd sky130_fd_pr__nfet_01v8 L=150000 W=420000
+ AS=56700000000 AD=56700000000 PS=690000 PD=690000
* device instance $14 r0 *1 3.67,0.445 sky130_fd_pr__nfet_01v8
XM$14 VGND B1 \$6 sky130_gnd sky130_fd_pr__nfet_01v8 L=150000 W=420000
+ AS=56700000000 AD=109200000000 PS=690000 PD=1360000
.ENDS sky130_fd_sc_hd__o2bb2a_2

* cell sky130_fd_sc_hd__nand3b_2
* pin VGND
* pin A_N
* pin C
* pin B
* pin Y
* pin VPWR
* pin VPB
* pin sky130_gnd
.SUBCKT sky130_fd_sc_hd__nand3b_2 VGND A_N C B Y VPWR VPB sky130_gnd
* device instance $1 r0 *1 3.215,1.985 sky130_fd_pr__pfet_01v8_hvt
XM$1 VPWR \$3 Y VPB sky130_fd_pr__pfet_01v8_hvt L=150000 W=1000000
+ AS=260000000000 AD=135000000000 PS=2520000 PD=1270000
* device instance $2 r0 *1 3.635,1.985 sky130_fd_pr__pfet_01v8_hvt
XM$2 Y \$3 VPWR VPB sky130_fd_pr__pfet_01v8_hvt L=150000 W=1000000
+ AS=135000000000 AD=260000000000 PS=1270000 PD=2520000
* device instance $3 r0 *1 0.47,2.275 sky130_fd_pr__pfet_01v8_hvt
XM$3 VPWR A_N \$3 VPB sky130_fd_pr__pfet_01v8_hvt L=150000 W=420000
+ AS=175750000000 AD=109200000000 PS=1395000 PD=1360000
* device instance $4 r0 *1 1.015,1.985 sky130_fd_pr__pfet_01v8_hvt
XM$4 VPWR C Y VPB sky130_fd_pr__pfet_01v8_hvt L=150000 W=1000000
+ AS=175750000000 AD=135000000000 PS=1395000 PD=1270000
* device instance $5 r0 *1 1.435,1.985 sky130_fd_pr__pfet_01v8_hvt
XM$5 Y C VPWR VPB sky130_fd_pr__pfet_01v8_hvt L=150000 W=1000000
+ AS=135000000000 AD=135000000000 PS=1270000 PD=1270000
* device instance $6 r0 *1 1.855,1.985 sky130_fd_pr__pfet_01v8_hvt
XM$6 VPWR B Y VPB sky130_fd_pr__pfet_01v8_hvt L=150000 W=1000000
+ AS=135000000000 AD=135000000000 PS=1270000 PD=1270000
* device instance $7 r0 *1 2.275,1.985 sky130_fd_pr__pfet_01v8_hvt
XM$7 Y B VPWR VPB sky130_fd_pr__pfet_01v8_hvt L=150000 W=1000000
+ AS=135000000000 AD=260000000000 PS=1270000 PD=2520000
* device instance $8 r0 *1 2.375,0.56 sky130_fd_pr__nfet_01v8
XM$8 \$5 B \$4 sky130_gnd sky130_fd_pr__nfet_01v8 L=150000 W=650000
+ AS=169000000000 AD=87750000000 PS=1820000 PD=920000
* device instance $9 r0 *1 2.795,0.56 sky130_fd_pr__nfet_01v8
XM$9 \$4 B \$5 sky130_gnd sky130_fd_pr__nfet_01v8 L=150000 W=650000
+ AS=87750000000 AD=87750000000 PS=920000 PD=920000
* device instance $10 r0 *1 3.215,0.56 sky130_fd_pr__nfet_01v8
XM$10 \$5 \$3 Y sky130_gnd sky130_fd_pr__nfet_01v8 L=150000 W=650000
+ AS=87750000000 AD=87750000000 PS=920000 PD=920000
* device instance $11 r0 *1 3.635,0.56 sky130_fd_pr__nfet_01v8
XM$11 Y \$3 \$5 sky130_gnd sky130_fd_pr__nfet_01v8 L=150000 W=650000
+ AS=87750000000 AD=169000000000 PS=920000 PD=1820000
* device instance $12 r0 *1 0.47,0.445 sky130_fd_pr__nfet_01v8
XM$12 \$3 A_N VGND sky130_gnd sky130_fd_pr__nfet_01v8 L=150000 W=420000
+ AS=109200000000 AD=119750000000 PS=1360000 PD=1045000
* device instance $13 r0 *1 1.015,0.56 sky130_fd_pr__nfet_01v8
XM$13 VGND C \$4 sky130_gnd sky130_fd_pr__nfet_01v8 L=150000 W=650000
+ AS=119750000000 AD=87750000000 PS=1045000 PD=920000
* device instance $14 r0 *1 1.435,0.56 sky130_fd_pr__nfet_01v8
XM$14 \$4 C VGND sky130_gnd sky130_fd_pr__nfet_01v8 L=150000 W=650000
+ AS=87750000000 AD=169000000000 PS=920000 PD=1820000
.ENDS sky130_fd_sc_hd__nand3b_2

* cell sky130_fd_sc_hd__o311a_2
* pin VGND
* pin X
* pin A1
* pin A2
* pin A3
* pin B1
* pin C1
* pin VPWR
* pin VPB
* pin sky130_gnd
.SUBCKT sky130_fd_sc_hd__o311a_2 VGND X A1 A2 A3 B1 C1 VPWR VPB sky130_gnd
* device instance $1 r0 *1 0.53,1.985 sky130_fd_pr__pfet_01v8_hvt
XM$1 VPWR \$5 X VPB sky130_fd_pr__pfet_01v8_hvt L=150000 W=1000000
+ AS=320000000000 AD=135000000000 PS=2640000 PD=1270000
* device instance $2 r0 *1 0.95,1.985 sky130_fd_pr__pfet_01v8_hvt
XM$2 X \$5 VPWR VPB sky130_fd_pr__pfet_01v8_hvt L=150000 W=1000000
+ AS=135000000000 AD=312500000000 PS=1270000 PD=1625000
* device instance $3 r0 *1 1.725,1.985 sky130_fd_pr__pfet_01v8_hvt
XM$3 VPWR A1 \$14 VPB sky130_fd_pr__pfet_01v8_hvt L=150000 W=1000000
+ AS=312500000000 AD=175000000000 PS=1625000 PD=1350000
* device instance $4 r0 *1 2.225,1.985 sky130_fd_pr__pfet_01v8_hvt
XM$4 \$14 A2 \$15 VPB sky130_fd_pr__pfet_01v8_hvt L=150000 W=1000000
+ AS=175000000000 AD=210000000000 PS=1350000 PD=1420000
* device instance $5 r0 *1 2.795,1.985 sky130_fd_pr__pfet_01v8_hvt
XM$5 \$15 A3 \$5 VPB sky130_fd_pr__pfet_01v8_hvt L=150000 W=1000000
+ AS=210000000000 AD=137500000000 PS=1420000 PD=1275000
* device instance $6 r0 *1 3.22,1.985 sky130_fd_pr__pfet_01v8_hvt
XM$6 \$5 B1 VPWR VPB sky130_fd_pr__pfet_01v8_hvt L=150000 W=1000000
+ AS=137500000000 AD=150000000000 PS=1275000 PD=1300000
* device instance $7 r0 *1 3.67,1.985 sky130_fd_pr__pfet_01v8_hvt
XM$7 VPWR C1 \$5 VPB sky130_fd_pr__pfet_01v8_hvt L=150000 W=1000000
+ AS=150000000000 AD=260000000000 PS=1300000 PD=2520000
* device instance $8 r0 *1 0.53,0.56 sky130_fd_pr__nfet_01v8
XM$8 VGND \$5 X sky130_gnd sky130_fd_pr__nfet_01v8 L=150000 W=650000
+ AS=208000000000 AD=87750000000 PS=1940000 PD=920000
* device instance $9 r0 *1 0.95,0.56 sky130_fd_pr__nfet_01v8
XM$9 X \$5 VGND sky130_gnd sky130_fd_pr__nfet_01v8 L=150000 W=650000
+ AS=87750000000 AD=203125000000 PS=920000 PD=1275000
* device instance $10 r0 *1 1.725,0.56 sky130_fd_pr__nfet_01v8
XM$10 VGND A1 \$4 sky130_gnd sky130_fd_pr__nfet_01v8 L=150000 W=650000
+ AS=203125000000 AD=113750000000 PS=1275000 PD=1000000
* device instance $11 r0 *1 2.225,0.56 sky130_fd_pr__nfet_01v8
XM$11 \$4 A2 VGND sky130_gnd sky130_fd_pr__nfet_01v8 L=150000 W=650000
+ AS=113750000000 AD=136500000000 PS=1000000 PD=1070000
* device instance $12 r0 *1 2.795,0.56 sky130_fd_pr__nfet_01v8
XM$12 VGND A3 \$4 sky130_gnd sky130_fd_pr__nfet_01v8 L=150000 W=650000
+ AS=136500000000 AD=118625000000 PS=1070000 PD=1015000
* device instance $13 r0 *1 3.31,0.56 sky130_fd_pr__nfet_01v8
XM$13 \$4 B1 \$11 sky130_gnd sky130_fd_pr__nfet_01v8 L=150000 W=650000
+ AS=118625000000 AD=68250000000 PS=1015000 PD=860000
* device instance $14 r0 *1 3.67,0.56 sky130_fd_pr__nfet_01v8
XM$14 \$11 C1 \$5 sky130_gnd sky130_fd_pr__nfet_01v8 L=150000 W=650000
+ AS=68250000000 AD=169000000000 PS=860000 PD=1820000
.ENDS sky130_fd_sc_hd__o311a_2

* cell sky130_fd_sc_hd__nor4b_2
* pin VGND
* pin Y
* pin A
* pin B
* pin C
* pin D_N
* pin VPWR
* pin VPB
* pin sky130_gnd
.SUBCKT sky130_fd_sc_hd__nor4b_2 VGND Y A B C D_N VPWR VPB sky130_gnd
* device instance $1 r0 *1 4.905,2.275 sky130_fd_pr__pfet_01v8_hvt
XM$1 \$4 D_N VPWR VPB sky130_fd_pr__pfet_01v8_hvt L=150000 W=420000
+ AS=109200000000 AD=109200000000 PS=1360000 PD=1360000
* device instance $2 r0 *1 2.705,1.985 sky130_fd_pr__pfet_01v8_hvt
XM$2 \$12 C \$11 VPB sky130_fd_pr__pfet_01v8_hvt L=150000 W=1000000
+ AS=260000000000 AD=135000000000 PS=2520000 PD=1270000
* device instance $3 r0 *1 3.125,1.985 sky130_fd_pr__pfet_01v8_hvt
XM$3 \$11 C \$12 VPB sky130_fd_pr__pfet_01v8_hvt L=150000 W=1000000
+ AS=135000000000 AD=135000000000 PS=1270000 PD=1270000
* device instance $4 r0 *1 3.545,1.985 sky130_fd_pr__pfet_01v8_hvt
XM$4 \$12 \$4 Y VPB sky130_fd_pr__pfet_01v8_hvt L=150000 W=1000000
+ AS=135000000000 AD=135000000000 PS=1270000 PD=1270000
* device instance $5 r0 *1 3.965,1.985 sky130_fd_pr__pfet_01v8_hvt
XM$5 Y \$4 \$12 VPB sky130_fd_pr__pfet_01v8_hvt L=150000 W=1000000
+ AS=135000000000 AD=260000000000 PS=1270000 PD=2520000
* device instance $6 r0 *1 0.47,1.985 sky130_fd_pr__pfet_01v8_hvt
XM$6 \$9 A VPWR VPB sky130_fd_pr__pfet_01v8_hvt L=150000 W=1000000
+ AS=260000000000 AD=135000000000 PS=2520000 PD=1270000
* device instance $7 r0 *1 0.89,1.985 sky130_fd_pr__pfet_01v8_hvt
XM$7 VPWR A \$9 VPB sky130_fd_pr__pfet_01v8_hvt L=150000 W=1000000
+ AS=135000000000 AD=135000000000 PS=1270000 PD=1270000
* device instance $8 r0 *1 1.31,1.985 sky130_fd_pr__pfet_01v8_hvt
XM$8 \$9 B \$11 VPB sky130_fd_pr__pfet_01v8_hvt L=150000 W=1000000
+ AS=135000000000 AD=135000000000 PS=1270000 PD=1270000
* device instance $9 r0 *1 1.73,1.985 sky130_fd_pr__pfet_01v8_hvt
XM$9 \$11 B \$9 VPB sky130_fd_pr__pfet_01v8_hvt L=150000 W=1000000
+ AS=135000000000 AD=260000000000 PS=1270000 PD=2520000
* device instance $10 r0 *1 2.705,0.56 sky130_fd_pr__nfet_01v8
XM$10 VGND C Y sky130_gnd sky130_fd_pr__nfet_01v8 L=150000 W=650000
+ AS=169000000000 AD=87750000000 PS=1820000 PD=920000
* device instance $11 r0 *1 3.125,0.56 sky130_fd_pr__nfet_01v8
XM$11 Y C VGND sky130_gnd sky130_fd_pr__nfet_01v8 L=150000 W=650000
+ AS=87750000000 AD=87750000000 PS=920000 PD=920000
* device instance $12 r0 *1 3.545,0.56 sky130_fd_pr__nfet_01v8
XM$12 VGND \$4 Y sky130_gnd sky130_fd_pr__nfet_01v8 L=150000 W=650000
+ AS=87750000000 AD=87750000000 PS=920000 PD=920000
* device instance $13 r0 *1 3.965,0.56 sky130_fd_pr__nfet_01v8
XM$13 Y \$4 VGND sky130_gnd sky130_fd_pr__nfet_01v8 L=150000 W=650000
+ AS=87750000000 AD=169000000000 PS=920000 PD=1820000
* device instance $14 r0 *1 4.905,0.675 sky130_fd_pr__nfet_01v8
XM$14 \$4 D_N VGND sky130_gnd sky130_fd_pr__nfet_01v8 L=150000 W=420000
+ AS=109200000000 AD=109200000000 PS=1360000 PD=1360000
* device instance $15 r0 *1 0.47,0.56 sky130_fd_pr__nfet_01v8
XM$15 VGND A Y sky130_gnd sky130_fd_pr__nfet_01v8 L=150000 W=650000
+ AS=169000000000 AD=87750000000 PS=1820000 PD=920000
* device instance $16 r0 *1 0.89,0.56 sky130_fd_pr__nfet_01v8
XM$16 Y A VGND sky130_gnd sky130_fd_pr__nfet_01v8 L=150000 W=650000
+ AS=87750000000 AD=87750000000 PS=920000 PD=920000
* device instance $17 r0 *1 1.31,0.56 sky130_fd_pr__nfet_01v8
XM$17 VGND B Y sky130_gnd sky130_fd_pr__nfet_01v8 L=150000 W=650000
+ AS=87750000000 AD=87750000000 PS=920000 PD=920000
* device instance $18 r0 *1 1.73,0.56 sky130_fd_pr__nfet_01v8
XM$18 Y B VGND sky130_gnd sky130_fd_pr__nfet_01v8 L=150000 W=650000
+ AS=87750000000 AD=169000000000 PS=920000 PD=1820000
.ENDS sky130_fd_sc_hd__nor4b_2

* cell sky130_fd_sc_hd__buf_2
* pin VPB
* pin VGND
* pin X
* pin VPWR
* pin A
* pin sky130_gnd
.SUBCKT sky130_fd_sc_hd__buf_2 VPB VGND X VPWR A sky130_gnd
* device instance $1 r0 *1 0.47,2.125 sky130_fd_pr__pfet_01v8_hvt
XM$1 VPWR A \$3 VPB sky130_fd_pr__pfet_01v8_hvt L=150000 W=640000
+ AS=149000000000 AD=166400000000 PS=1325000 PD=1800000
* device instance $2 r0 *1 0.945,1.985 sky130_fd_pr__pfet_01v8_hvt
XM$2 VPWR \$3 X VPB sky130_fd_pr__pfet_01v8_hvt L=150000 W=1000000
+ AS=149000000000 AD=135000000000 PS=1325000 PD=1270000
* device instance $3 r0 *1 1.365,1.985 sky130_fd_pr__pfet_01v8_hvt
XM$3 X \$3 VPWR VPB sky130_fd_pr__pfet_01v8_hvt L=150000 W=1000000
+ AS=135000000000 AD=265000000000 PS=1270000 PD=2530000
* device instance $4 r0 *1 0.47,0.445 sky130_fd_pr__nfet_01v8
XM$4 \$3 A VGND sky130_gnd sky130_fd_pr__nfet_01v8 L=150000 W=420000
+ AS=109200000000 AD=97000000000 PS=1360000 PD=975000
* device instance $5 r0 *1 0.945,0.56 sky130_fd_pr__nfet_01v8
XM$5 VGND \$3 X sky130_gnd sky130_fd_pr__nfet_01v8 L=150000 W=650000
+ AS=97000000000 AD=87750000000 PS=975000 PD=920000
* device instance $6 r0 *1 1.365,0.56 sky130_fd_pr__nfet_01v8
XM$6 X \$3 VGND sky130_gnd sky130_fd_pr__nfet_01v8 L=150000 W=650000
+ AS=87750000000 AD=172250000000 PS=920000 PD=1830000
.ENDS sky130_fd_sc_hd__buf_2

* cell sky130_fd_sc_hd__or4bb_2
* pin VGND
* pin X
* pin C_N
* pin D_N
* pin A
* pin VPWR
* pin B
* pin VPB
* pin sky130_gnd
.SUBCKT sky130_fd_sc_hd__or4bb_2 VGND X C_N D_N A VPWR B VPB sky130_gnd
* device instance $1 r0 *1 2.395,1.695 sky130_fd_pr__pfet_01v8_hvt
XM$1 \$14 \$8 \$11 VPB sky130_fd_pr__pfet_01v8_hvt L=150000 W=420000
+ AS=121500000000 AD=44100000000 PS=1330000 PD=630000
* device instance $2 r0 *1 2.755,1.695 sky130_fd_pr__pfet_01v8_hvt
XM$2 \$11 B \$10 VPB sky130_fd_pr__pfet_01v8_hvt L=150000 W=420000
+ AS=44100000000 AD=59850000000 PS=630000 PD=705000
* device instance $3 r0 *1 3.19,1.695 sky130_fd_pr__pfet_01v8_hvt
XM$3 \$10 A VPWR VPB sky130_fd_pr__pfet_01v8_hvt L=150000 W=420000
+ AS=59850000000 AD=148250000000 PS=705000 PD=1340000
* device instance $4 r0 *1 1.915,2.275 sky130_fd_pr__pfet_01v8_hvt
XM$4 \$14 \$7 \$3 VPB sky130_fd_pr__pfet_01v8_hvt L=150000 W=420000
+ AS=121500000000 AD=109200000000 PS=1330000 PD=1360000
* device instance $5 r0 *1 3.68,1.985 sky130_fd_pr__pfet_01v8_hvt
XM$5 VPWR \$3 X VPB sky130_fd_pr__pfet_01v8_hvt L=150000 W=1000000
+ AS=148250000000 AD=135000000000 PS=1340000 PD=1270000
* device instance $6 r0 *1 4.1,1.985 sky130_fd_pr__pfet_01v8_hvt
XM$6 X \$3 VPWR VPB sky130_fd_pr__pfet_01v8_hvt L=150000 W=1000000
+ AS=135000000000 AD=285000000000 PS=1270000 PD=2570000
* device instance $7 r0 *1 0.955,1.695 sky130_fd_pr__pfet_01v8_hvt
XM$7 VPWR D_N \$7 VPB sky130_fd_pr__pfet_01v8_hvt L=150000 W=420000
+ AS=122612500000 AD=117600000000 PS=1320000 PD=1400000
* device instance $8 r0 *1 0.47,2.26 sky130_fd_pr__pfet_01v8_hvt
XM$8 VPWR C_N \$8 VPB sky130_fd_pr__pfet_01v8_hvt L=150000 W=420000
+ AS=122612500000 AD=109200000000 PS=1320000 PD=1360000
* device instance $9 r0 *1 1.895,0.445 sky130_fd_pr__nfet_01v8
XM$9 VGND \$7 \$3 sky130_gnd sky130_fd_pr__nfet_01v8 L=150000 W=420000
+ AS=109200000000 AD=64050000000 PS=1360000 PD=725000
* device instance $10 r0 *1 2.35,0.445 sky130_fd_pr__nfet_01v8
XM$10 \$3 \$8 VGND sky130_gnd sky130_fd_pr__nfet_01v8 L=150000 W=420000
+ AS=64050000000 AD=56700000000 PS=725000 PD=690000
* device instance $11 r0 *1 2.77,0.445 sky130_fd_pr__nfet_01v8
XM$11 VGND B \$3 sky130_gnd sky130_fd_pr__nfet_01v8 L=150000 W=420000
+ AS=56700000000 AD=56700000000 PS=690000 PD=690000
* device instance $12 r0 *1 3.19,0.445 sky130_fd_pr__nfet_01v8
XM$12 \$3 A VGND sky130_gnd sky130_fd_pr__nfet_01v8 L=150000 W=420000
+ AS=56700000000 AD=101875000000 PS=690000 PD=990000
* device instance $13 r0 *1 3.68,0.56 sky130_fd_pr__nfet_01v8
XM$13 VGND \$3 X sky130_gnd sky130_fd_pr__nfet_01v8 L=150000 W=650000
+ AS=101875000000 AD=87750000000 PS=990000 PD=920000
* device instance $14 r0 *1 4.1,0.56 sky130_fd_pr__nfet_01v8
XM$14 X \$3 VGND sky130_gnd sky130_fd_pr__nfet_01v8 L=150000 W=650000
+ AS=87750000000 AD=185250000000 PS=920000 PD=1870000
* device instance $15 r0 *1 0.51,0.675 sky130_fd_pr__nfet_01v8
XM$15 \$8 C_N VGND sky130_gnd sky130_fd_pr__nfet_01v8 L=150000 W=420000
+ AS=109200000000 AD=61950000000 PS=1360000 PD=715000
* device instance $16 r0 *1 0.955,0.675 sky130_fd_pr__nfet_01v8
XM$16 VGND D_N \$7 sky130_gnd sky130_fd_pr__nfet_01v8 L=150000 W=420000
+ AS=61950000000 AD=109200000000 PS=715000 PD=1360000
.ENDS sky130_fd_sc_hd__or4bb_2

* cell sky130_fd_sc_hd__and4_2
* pin VPB
* pin B
* pin VPWR
* pin C
* pin D
* pin VGND
* pin X
* pin A
* pin sky130_gnd
.SUBCKT sky130_fd_sc_hd__and4_2 VPB B VPWR C D VGND X A sky130_gnd
* device instance $1 r0 *1 0.47,2.275 sky130_fd_pr__pfet_01v8_hvt
XM$1 VPWR A \$8 VPB sky130_fd_pr__pfet_01v8_hvt L=150000 W=420000
+ AS=109200000000 AD=74550000000 PS=1360000 PD=775000
* device instance $2 r0 *1 0.975,2.275 sky130_fd_pr__pfet_01v8_hvt
XM$2 \$8 B VPWR VPB sky130_fd_pr__pfet_01v8_hvt L=150000 W=420000
+ AS=74550000000 AD=77700000000 PS=775000 PD=790000
* device instance $3 r0 *1 1.495,2.275 sky130_fd_pr__pfet_01v8_hvt
XM$3 VPWR C \$8 VPB sky130_fd_pr__pfet_01v8_hvt L=150000 W=420000
+ AS=77700000000 AD=58800000000 PS=790000 PD=700000
* device instance $4 r0 *1 1.925,2.275 sky130_fd_pr__pfet_01v8_hvt
XM$4 VPWR D \$8 VPB sky130_fd_pr__pfet_01v8_hvt L=150000 W=420000
+ AS=279950000000 AD=58800000000 PS=1615000 PD=700000
* device instance $5 r0 *1 2.69,1.985 sky130_fd_pr__pfet_01v8_hvt
XM$5 VPWR \$8 X VPB sky130_fd_pr__pfet_01v8_hvt L=150000 W=1000000
+ AS=279950000000 AD=165000000000 PS=1615000 PD=1330000
* device instance $6 r0 *1 3.17,1.985 sky130_fd_pr__pfet_01v8_hvt
XM$6 X \$8 VPWR VPB sky130_fd_pr__pfet_01v8_hvt L=150000 W=1000000
+ AS=165000000000 AD=300000000000 PS=1330000 PD=2600000
* device instance $7 r0 *1 0.47,0.445 sky130_fd_pr__nfet_01v8
XM$7 \$8 A \$13 sky130_gnd sky130_fd_pr__nfet_01v8 L=150000 W=420000
+ AS=109200000000 AD=61950000000 PS=1360000 PD=715000
* device instance $8 r0 *1 0.915,0.445 sky130_fd_pr__nfet_01v8
XM$8 \$13 B \$12 sky130_gnd sky130_fd_pr__nfet_01v8 L=150000 W=420000
+ AS=61950000000 AD=79800000000 PS=715000 PD=800000
* device instance $9 r0 *1 1.445,0.445 sky130_fd_pr__nfet_01v8
XM$9 \$12 C \$11 sky130_gnd sky130_fd_pr__nfet_01v8 L=150000 W=420000
+ AS=79800000000 AD=69300000000 PS=800000 PD=750000
* device instance $10 r0 *1 1.925,0.445 sky130_fd_pr__nfet_01v8
XM$10 \$11 D VGND sky130_gnd sky130_fd_pr__nfet_01v8 L=150000 W=420000
+ AS=69300000000 AD=175150000000 PS=750000 PD=1265000
* device instance $11 r0 *1 2.69,0.56 sky130_fd_pr__nfet_01v8
XM$11 VGND \$8 X sky130_gnd sky130_fd_pr__nfet_01v8 L=150000 W=650000
+ AS=175150000000 AD=107250000000 PS=1265000 PD=980000
* device instance $12 r0 *1 3.17,0.56 sky130_fd_pr__nfet_01v8
XM$12 X \$8 VGND sky130_gnd sky130_fd_pr__nfet_01v8 L=150000 W=650000
+ AS=107250000000 AD=195000000000 PS=980000 PD=1900000
.ENDS sky130_fd_sc_hd__and4_2

* cell sky130_fd_sc_hd__a41oi_2
* pin VGND
* pin Y
* pin A4
* pin B1
* pin A1
* pin A2
* pin A3
* pin VPWR
* pin VPB
* pin sky130_gnd
.SUBCKT sky130_fd_sc_hd__a41oi_2 VGND Y A4 B1 A1 A2 A3 VPWR VPB sky130_gnd
* device instance $1 r0 *1 1.08,1.985 sky130_fd_pr__pfet_01v8_hvt
XM$1 \$12 B1 Y VPB sky130_fd_pr__pfet_01v8_hvt L=150000 W=1000000
+ AS=260000000000 AD=135000000000 PS=2520000 PD=1270000
* device instance $2 r0 *1 1.5,1.985 sky130_fd_pr__pfet_01v8_hvt
XM$2 Y B1 \$12 VPB sky130_fd_pr__pfet_01v8_hvt L=150000 W=1000000
+ AS=135000000000 AD=135000000000 PS=1270000 PD=1270000
* device instance $3 r0 *1 1.92,1.985 sky130_fd_pr__pfet_01v8_hvt
XM$3 \$12 A1 VPWR VPB sky130_fd_pr__pfet_01v8_hvt L=150000 W=1000000
+ AS=135000000000 AD=135000000000 PS=1270000 PD=1270000
* device instance $4 r0 *1 2.34,1.985 sky130_fd_pr__pfet_01v8_hvt
XM$4 VPWR A1 \$12 VPB sky130_fd_pr__pfet_01v8_hvt L=150000 W=1000000
+ AS=135000000000 AD=135000000000 PS=1270000 PD=1270000
* device instance $5 r0 *1 2.76,1.985 sky130_fd_pr__pfet_01v8_hvt
XM$5 \$12 A2 VPWR VPB sky130_fd_pr__pfet_01v8_hvt L=150000 W=1000000
+ AS=135000000000 AD=135000000000 PS=1270000 PD=1270000
* device instance $6 r0 *1 3.18,1.985 sky130_fd_pr__pfet_01v8_hvt
XM$6 VPWR A2 \$12 VPB sky130_fd_pr__pfet_01v8_hvt L=150000 W=1000000
+ AS=135000000000 AD=145000000000 PS=1270000 PD=1290000
* device instance $7 r0 *1 3.62,1.985 sky130_fd_pr__pfet_01v8_hvt
XM$7 \$12 A3 VPWR VPB sky130_fd_pr__pfet_01v8_hvt L=150000 W=1000000
+ AS=145000000000 AD=385000000000 PS=1290000 PD=1770000
* device instance $8 r0 *1 4.54,1.985 sky130_fd_pr__pfet_01v8_hvt
XM$8 VPWR A3 \$12 VPB sky130_fd_pr__pfet_01v8_hvt L=150000 W=1000000
+ AS=385000000000 AD=135000000000 PS=1770000 PD=1270000
* device instance $9 r0 *1 4.96,1.985 sky130_fd_pr__pfet_01v8_hvt
XM$9 \$12 A4 VPWR VPB sky130_fd_pr__pfet_01v8_hvt L=150000 W=1000000
+ AS=135000000000 AD=135000000000 PS=1270000 PD=1270000
* device instance $10 r0 *1 5.38,1.985 sky130_fd_pr__pfet_01v8_hvt
XM$10 VPWR A4 \$12 VPB sky130_fd_pr__pfet_01v8_hvt L=150000 W=1000000
+ AS=135000000000 AD=260000000000 PS=1270000 PD=2520000
* device instance $11 r0 *1 4.12,0.56 sky130_fd_pr__nfet_01v8
XM$11 \$6 A3 \$5 sky130_gnd sky130_fd_pr__nfet_01v8 L=150000 W=650000
+ AS=169000000000 AD=87750000000 PS=1820000 PD=920000
* device instance $12 r0 *1 4.54,0.56 sky130_fd_pr__nfet_01v8
XM$12 \$5 A3 \$6 sky130_gnd sky130_fd_pr__nfet_01v8 L=150000 W=650000
+ AS=87750000000 AD=87750000000 PS=920000 PD=920000
* device instance $13 r0 *1 4.96,0.56 sky130_fd_pr__nfet_01v8
XM$13 \$6 A4 VGND sky130_gnd sky130_fd_pr__nfet_01v8 L=150000 W=650000
+ AS=87750000000 AD=87750000000 PS=920000 PD=920000
* device instance $14 r0 *1 5.38,0.56 sky130_fd_pr__nfet_01v8
XM$14 VGND A4 \$6 sky130_gnd sky130_fd_pr__nfet_01v8 L=150000 W=650000
+ AS=87750000000 AD=169000000000 PS=920000 PD=1820000
* device instance $15 r0 *1 1.92,0.56 sky130_fd_pr__nfet_01v8
XM$15 \$4 A1 Y sky130_gnd sky130_fd_pr__nfet_01v8 L=150000 W=650000
+ AS=169000000000 AD=87750000000 PS=1820000 PD=920000
* device instance $16 r0 *1 2.34,0.56 sky130_fd_pr__nfet_01v8
XM$16 Y A1 \$4 sky130_gnd sky130_fd_pr__nfet_01v8 L=150000 W=650000
+ AS=87750000000 AD=87750000000 PS=920000 PD=920000
* device instance $17 r0 *1 2.76,0.56 sky130_fd_pr__nfet_01v8
XM$17 \$4 A2 \$5 sky130_gnd sky130_fd_pr__nfet_01v8 L=150000 W=650000
+ AS=87750000000 AD=87750000000 PS=920000 PD=920000
* device instance $18 r0 *1 3.18,0.56 sky130_fd_pr__nfet_01v8
XM$18 \$5 A2 \$4 sky130_gnd sky130_fd_pr__nfet_01v8 L=150000 W=650000
+ AS=87750000000 AD=169000000000 PS=920000 PD=1820000
* device instance $19 r0 *1 0.56,0.56 sky130_fd_pr__nfet_01v8
XM$19 VGND B1 Y sky130_gnd sky130_fd_pr__nfet_01v8 L=150000 W=650000
+ AS=169000000000 AD=87750000000 PS=1820000 PD=920000
* device instance $20 r0 *1 0.98,0.56 sky130_fd_pr__nfet_01v8
XM$20 Y B1 VGND sky130_gnd sky130_fd_pr__nfet_01v8 L=150000 W=650000
+ AS=87750000000 AD=169000000000 PS=920000 PD=1820000
.ENDS sky130_fd_sc_hd__a41oi_2

* cell sky130_fd_sc_hd__a221oi_2
* pin VGND
* pin C1
* pin Y
* pin B2
* pin B1
* pin A2
* pin A1
* pin VPWR
* pin VPB
* pin sky130_gnd
.SUBCKT sky130_fd_sc_hd__a221oi_2 VGND C1 Y B2 B1 A2 A1 VPWR VPB sky130_gnd
* device instance $1 r0 *1 1.84,1.985 sky130_fd_pr__pfet_01v8_hvt
XM$1 \$13 B2 \$11 VPB sky130_fd_pr__pfet_01v8_hvt L=150000 W=1000000
+ AS=260000000000 AD=135000000000 PS=2520000 PD=1270000
* device instance $2 r0 *1 2.26,1.985 sky130_fd_pr__pfet_01v8_hvt
XM$2 \$11 B1 \$13 VPB sky130_fd_pr__pfet_01v8_hvt L=150000 W=1000000
+ AS=135000000000 AD=135000000000 PS=1270000 PD=1270000
* device instance $3 r0 *1 2.68,1.985 sky130_fd_pr__pfet_01v8_hvt
XM$3 \$13 B1 \$11 VPB sky130_fd_pr__pfet_01v8_hvt L=150000 W=1000000
+ AS=135000000000 AD=135000000000 PS=1270000 PD=1270000
* device instance $4 r0 *1 3.1,1.985 sky130_fd_pr__pfet_01v8_hvt
XM$4 \$11 B2 \$13 VPB sky130_fd_pr__pfet_01v8_hvt L=150000 W=1000000
+ AS=135000000000 AD=175000000000 PS=1270000 PD=1350000
* device instance $5 r0 *1 3.6,1.985 sky130_fd_pr__pfet_01v8_hvt
XM$5 \$13 A2 VPWR VPB sky130_fd_pr__pfet_01v8_hvt L=150000 W=1000000
+ AS=175000000000 AD=135000000000 PS=1350000 PD=1270000
* device instance $6 r0 *1 4.02,1.985 sky130_fd_pr__pfet_01v8_hvt
XM$6 VPWR A1 \$13 VPB sky130_fd_pr__pfet_01v8_hvt L=150000 W=1000000
+ AS=135000000000 AD=135000000000 PS=1270000 PD=1270000
* device instance $7 r0 *1 4.44,1.985 sky130_fd_pr__pfet_01v8_hvt
XM$7 \$13 A1 VPWR VPB sky130_fd_pr__pfet_01v8_hvt L=150000 W=1000000
+ AS=135000000000 AD=135000000000 PS=1270000 PD=1270000
* device instance $8 r0 *1 4.86,1.985 sky130_fd_pr__pfet_01v8_hvt
XM$8 VPWR A2 \$13 VPB sky130_fd_pr__pfet_01v8_hvt L=150000 W=1000000
+ AS=135000000000 AD=285000000000 PS=1270000 PD=2570000
* device instance $9 r0 *1 0.48,1.985 sky130_fd_pr__pfet_01v8_hvt
XM$9 \$11 C1 Y VPB sky130_fd_pr__pfet_01v8_hvt L=150000 W=1000000
+ AS=270000000000 AD=135000000000 PS=2540000 PD=1270000
* device instance $10 r0 *1 0.9,1.985 sky130_fd_pr__pfet_01v8_hvt
XM$10 Y C1 \$11 VPB sky130_fd_pr__pfet_01v8_hvt L=150000 W=1000000
+ AS=135000000000 AD=260000000000 PS=1270000 PD=2520000
* device instance $11 r0 *1 0.48,0.56 sky130_fd_pr__nfet_01v8
XM$11 VGND C1 Y sky130_gnd sky130_fd_pr__nfet_01v8 L=150000 W=650000
+ AS=175500000000 AD=87750000000 PS=1840000 PD=920000
* device instance $12 r0 *1 0.9,0.56 sky130_fd_pr__nfet_01v8
XM$12 Y C1 VGND sky130_gnd sky130_fd_pr__nfet_01v8 L=150000 W=650000
+ AS=87750000000 AD=256750000000 PS=920000 PD=1440000
* device instance $13 r0 *1 1.84,0.56 sky130_fd_pr__nfet_01v8
XM$13 VGND B2 \$6 sky130_gnd sky130_fd_pr__nfet_01v8 L=150000 W=650000
+ AS=256750000000 AD=87750000000 PS=1440000 PD=920000
* device instance $14 r0 *1 2.26,0.56 sky130_fd_pr__nfet_01v8
XM$14 \$6 B1 Y sky130_gnd sky130_fd_pr__nfet_01v8 L=150000 W=650000
+ AS=87750000000 AD=87750000000 PS=920000 PD=920000
* device instance $15 r0 *1 2.68,0.56 sky130_fd_pr__nfet_01v8
XM$15 Y B1 \$6 sky130_gnd sky130_fd_pr__nfet_01v8 L=150000 W=650000
+ AS=87750000000 AD=87750000000 PS=920000 PD=920000
* device instance $16 r0 *1 3.1,0.56 sky130_fd_pr__nfet_01v8
XM$16 \$6 B2 VGND sky130_gnd sky130_fd_pr__nfet_01v8 L=150000 W=650000
+ AS=87750000000 AD=113750000000 PS=920000 PD=1000000
* device instance $17 r0 *1 3.6,0.56 sky130_fd_pr__nfet_01v8
XM$17 VGND A2 \$9 sky130_gnd sky130_fd_pr__nfet_01v8 L=150000 W=650000
+ AS=113750000000 AD=87750000000 PS=1000000 PD=920000
* device instance $18 r0 *1 4.02,0.56 sky130_fd_pr__nfet_01v8
XM$18 \$9 A1 Y sky130_gnd sky130_fd_pr__nfet_01v8 L=150000 W=650000
+ AS=87750000000 AD=87750000000 PS=920000 PD=920000
* device instance $19 r0 *1 4.44,0.56 sky130_fd_pr__nfet_01v8
XM$19 Y A1 \$9 sky130_gnd sky130_fd_pr__nfet_01v8 L=150000 W=650000
+ AS=87750000000 AD=87750000000 PS=920000 PD=920000
* device instance $20 r0 *1 4.86,0.56 sky130_fd_pr__nfet_01v8
XM$20 \$9 A2 VGND sky130_gnd sky130_fd_pr__nfet_01v8 L=150000 W=650000
+ AS=87750000000 AD=169000000000 PS=920000 PD=1820000
.ENDS sky130_fd_sc_hd__a221oi_2

* cell sky130_fd_sc_hd__mux2_1
* pin VGND
* pin X
* pin A1
* pin A0
* pin S
* pin VPWR
* pin VPB
* pin sky130_gnd
.SUBCKT sky130_fd_sc_hd__mux2_1 VGND X A1 A0 S VPWR VPB sky130_gnd
* device instance $1 r0 *1 1.015,2.08 sky130_fd_pr__pfet_01v8_hvt
XM$1 VPWR S \$13 VPB sky130_fd_pr__pfet_01v8_hvt L=150000 W=420000
+ AS=158350000000 AD=76650000000 PS=1395000 PD=785000
* device instance $2 r0 *1 1.53,2.08 sky130_fd_pr__pfet_01v8_hvt
XM$2 \$13 A0 \$5 VPB sky130_fd_pr__pfet_01v8_hvt L=150000 W=420000
+ AS=76650000000 AD=193200000000 PS=785000 PD=1340000
* device instance $3 r0 *1 2.6,2.08 sky130_fd_pr__pfet_01v8_hvt
XM$3 \$5 A1 \$14 VPB sky130_fd_pr__pfet_01v8_hvt L=150000 W=420000
+ AS=193200000000 AD=44100000000 PS=1340000 PD=630000
* device instance $4 r0 *1 2.96,2.08 sky130_fd_pr__pfet_01v8_hvt
XM$4 \$14 \$7 VPWR VPB sky130_fd_pr__pfet_01v8_hvt L=150000 W=420000
+ AS=44100000000 AD=69300000000 PS=630000 PD=750000
* device instance $5 r0 *1 3.44,2.08 sky130_fd_pr__pfet_01v8_hvt
XM$5 VPWR S \$7 VPB sky130_fd_pr__pfet_01v8_hvt L=150000 W=420000
+ AS=69300000000 AD=117600000000 PS=750000 PD=1400000
* device instance $6 r0 *1 0.47,1.985 sky130_fd_pr__pfet_01v8_hvt
XM$6 X \$5 VPWR VPB sky130_fd_pr__pfet_01v8_hvt L=150000 W=1000000
+ AS=260000000000 AD=158350000000 PS=2520000 PD=1395000
* device instance $7 r0 *1 1.015,0.445 sky130_fd_pr__nfet_01v8
XM$7 VGND S \$8 sky130_gnd sky130_fd_pr__nfet_01v8 L=150000 W=420000
+ AS=112850000000 AD=69300000000 PS=1045000 PD=750000
* device instance $8 r0 *1 1.495,0.445 sky130_fd_pr__nfet_01v8
XM$8 \$8 A1 \$5 sky130_gnd sky130_fd_pr__nfet_01v8 L=150000 W=420000
+ AS=69300000000 AD=99750000000 PS=750000 PD=895000
* device instance $9 r0 *1 2.12,0.445 sky130_fd_pr__nfet_01v8
XM$9 \$5 A0 \$9 sky130_gnd sky130_fd_pr__nfet_01v8 L=150000 W=420000
+ AS=99750000000 AD=69300000000 PS=895000 PD=750000
* device instance $10 r0 *1 2.6,0.445 sky130_fd_pr__nfet_01v8
XM$10 \$9 \$7 VGND sky130_gnd sky130_fd_pr__nfet_01v8 L=150000 W=420000
+ AS=69300000000 AD=144900000000 PS=750000 PD=1110000
* device instance $11 r0 *1 3.44,0.445 sky130_fd_pr__nfet_01v8
XM$11 VGND S \$7 sky130_gnd sky130_fd_pr__nfet_01v8 L=150000 W=420000
+ AS=144900000000 AD=109200000000 PS=1110000 PD=1360000
* device instance $12 r0 *1 0.47,0.56 sky130_fd_pr__nfet_01v8
XM$12 X \$5 VGND sky130_gnd sky130_fd_pr__nfet_01v8 L=150000 W=650000
+ AS=169000000000 AD=112850000000 PS=1820000 PD=1045000
.ENDS sky130_fd_sc_hd__mux2_1

* cell sky130_fd_sc_hd__conb_1
* pin VPB
* pin HI,VPWR
* pin LO,VGND
.SUBCKT sky130_fd_sc_hd__conb_1 VPB HI|VPWR LO|VGND
.ENDS sky130_fd_sc_hd__conb_1

* cell sky130_fd_sc_hd__or3b_2
* pin VPB
* pin X
* pin B
* pin A
* pin VGND
* pin VPWR
* pin C_N
* pin sky130_gnd
.SUBCKT sky130_fd_sc_hd__or3b_2 VPB X B A VGND VPWR C_N sky130_gnd
* device instance $1 r0 *1 1.865,1.695 sky130_fd_pr__pfet_01v8_hvt
XM$1 VPWR A \$12 VPB sky130_fd_pr__pfet_01v8_hvt L=150000 W=420000
+ AS=148250000000 AD=56700000000 PS=1340000 PD=690000
* device instance $2 r0 *1 2.285,1.695 sky130_fd_pr__pfet_01v8_hvt
XM$2 \$12 B \$11 VPB sky130_fd_pr__pfet_01v8_hvt L=150000 W=420000
+ AS=56700000000 AD=56700000000 PS=690000 PD=690000
* device instance $3 r0 *1 2.705,1.695 sky130_fd_pr__pfet_01v8_hvt
XM$3 \$11 \$4 \$5 VPB sky130_fd_pr__pfet_01v8_hvt L=150000 W=420000
+ AS=56700000000 AD=109200000000 PS=690000 PD=1360000
* device instance $4 r0 *1 0.47,2.01 sky130_fd_pr__pfet_01v8_hvt
XM$4 VPWR C_N \$4 VPB sky130_fd_pr__pfet_01v8_hvt L=150000 W=420000
+ AS=145750000000 AD=109200000000 PS=1335000 PD=1360000
* device instance $5 r0 *1 0.955,1.985 sky130_fd_pr__pfet_01v8_hvt
XM$5 VPWR \$5 X VPB sky130_fd_pr__pfet_01v8_hvt L=150000 W=1000000
+ AS=145750000000 AD=135000000000 PS=1335000 PD=1270000
* device instance $6 r0 *1 1.375,1.985 sky130_fd_pr__pfet_01v8_hvt
XM$6 X \$5 VPWR VPB sky130_fd_pr__pfet_01v8_hvt L=150000 W=1000000
+ AS=135000000000 AD=148250000000 PS=1270000 PD=1340000
* device instance $7 r0 *1 0.47,0.445 sky130_fd_pr__nfet_01v8
XM$7 \$4 C_N VGND sky130_gnd sky130_fd_pr__nfet_01v8 L=150000 W=420000
+ AS=109200000000 AD=100250000000 PS=1360000 PD=985000
* device instance $8 r0 *1 1.865,0.475 sky130_fd_pr__nfet_01v8
XM$8 VGND A \$5 sky130_gnd sky130_fd_pr__nfet_01v8 L=150000 W=420000
+ AS=101875000000 AD=56700000000 PS=990000 PD=690000
* device instance $9 r0 *1 2.285,0.475 sky130_fd_pr__nfet_01v8
XM$9 \$5 B VGND sky130_gnd sky130_fd_pr__nfet_01v8 L=150000 W=420000
+ AS=56700000000 AD=56700000000 PS=690000 PD=690000
* device instance $10 r0 *1 2.705,0.475 sky130_fd_pr__nfet_01v8
XM$10 VGND \$4 \$5 sky130_gnd sky130_fd_pr__nfet_01v8 L=150000 W=420000
+ AS=56700000000 AD=109200000000 PS=690000 PD=1360000
* device instance $11 r0 *1 0.955,0.56 sky130_fd_pr__nfet_01v8
XM$11 VGND \$5 X sky130_gnd sky130_fd_pr__nfet_01v8 L=150000 W=650000
+ AS=100250000000 AD=87750000000 PS=985000 PD=920000
* device instance $12 r0 *1 1.375,0.56 sky130_fd_pr__nfet_01v8
XM$12 X \$5 VGND sky130_gnd sky130_fd_pr__nfet_01v8 L=150000 W=650000
+ AS=87750000000 AD=101875000000 PS=920000 PD=990000
.ENDS sky130_fd_sc_hd__or3b_2

* cell sky130_fd_sc_hd__o32a_2
* pin VGND
* pin X
* pin A1
* pin A2
* pin A3
* pin B2
* pin B1
* pin VPWR
* pin VPB
* pin sky130_gnd
.SUBCKT sky130_fd_sc_hd__o32a_2 VGND X A1 A2 A3 B2 B1 VPWR VPB sky130_gnd
* device instance $1 r0 *1 0.47,1.985 sky130_fd_pr__pfet_01v8_hvt
XM$1 VPWR \$5 X VPB sky130_fd_pr__pfet_01v8_hvt L=150000 W=1000000
+ AS=260000000000 AD=135000000000 PS=2520000 PD=1270000
* device instance $2 r0 *1 0.89,1.985 sky130_fd_pr__pfet_01v8_hvt
XM$2 X \$5 VPWR VPB sky130_fd_pr__pfet_01v8_hvt L=150000 W=1000000
+ AS=135000000000 AD=305000000000 PS=1270000 PD=1610000
* device instance $3 r0 *1 1.65,1.985 sky130_fd_pr__pfet_01v8_hvt
XM$3 VPWR A1 \$12 VPB sky130_fd_pr__pfet_01v8_hvt L=150000 W=1000000
+ AS=305000000000 AD=135000000000 PS=1610000 PD=1270000
* device instance $4 r0 *1 2.07,1.985 sky130_fd_pr__pfet_01v8_hvt
XM$4 \$12 A2 \$13 VPB sky130_fd_pr__pfet_01v8_hvt L=150000 W=1000000
+ AS=135000000000 AD=215000000000 PS=1270000 PD=1430000
* device instance $5 r0 *1 2.65,1.985 sky130_fd_pr__pfet_01v8_hvt
XM$5 \$13 A3 \$5 VPB sky130_fd_pr__pfet_01v8_hvt L=150000 W=1000000
+ AS=215000000000 AD=135000000000 PS=1430000 PD=1270000
* device instance $6 r0 *1 3.07,1.985 sky130_fd_pr__pfet_01v8_hvt
XM$6 \$5 B2 \$14 VPB sky130_fd_pr__pfet_01v8_hvt L=150000 W=1000000
+ AS=135000000000 AD=190000000000 PS=1270000 PD=1380000
* device instance $7 r0 *1 3.6,1.985 sky130_fd_pr__pfet_01v8_hvt
XM$7 \$14 B1 VPWR VPB sky130_fd_pr__pfet_01v8_hvt L=150000 W=1000000
+ AS=190000000000 AD=330000000000 PS=1380000 PD=2660000
* device instance $8 r0 *1 0.47,0.56 sky130_fd_pr__nfet_01v8
XM$8 VGND \$5 X sky130_gnd sky130_fd_pr__nfet_01v8 L=150000 W=650000
+ AS=169000000000 AD=87750000000 PS=1820000 PD=920000
* device instance $9 r0 *1 0.89,0.56 sky130_fd_pr__nfet_01v8
XM$9 X \$5 VGND sky130_gnd sky130_fd_pr__nfet_01v8 L=150000 W=650000
+ AS=87750000000 AD=198250000000 PS=920000 PD=1260000
* device instance $10 r0 *1 1.65,0.56 sky130_fd_pr__nfet_01v8
XM$10 VGND A1 \$4 sky130_gnd sky130_fd_pr__nfet_01v8 L=150000 W=650000
+ AS=198250000000 AD=87750000000 PS=1260000 PD=920000
* device instance $11 r0 *1 2.07,0.56 sky130_fd_pr__nfet_01v8
XM$11 \$4 A2 VGND sky130_gnd sky130_fd_pr__nfet_01v8 L=150000 W=650000
+ AS=87750000000 AD=139750000000 PS=920000 PD=1080000
* device instance $12 r0 *1 2.65,0.56 sky130_fd_pr__nfet_01v8
XM$12 VGND A3 \$4 sky130_gnd sky130_fd_pr__nfet_01v8 L=150000 W=650000
+ AS=139750000000 AD=87750000000 PS=1080000 PD=920000
* device instance $13 r0 *1 3.07,0.56 sky130_fd_pr__nfet_01v8
XM$13 \$4 B2 \$5 sky130_gnd sky130_fd_pr__nfet_01v8 L=150000 W=650000
+ AS=87750000000 AD=123500000000 PS=920000 PD=1030000
* device instance $14 r0 *1 3.6,0.56 sky130_fd_pr__nfet_01v8
XM$14 \$5 B1 \$4 sky130_gnd sky130_fd_pr__nfet_01v8 L=150000 W=650000
+ AS=123500000000 AD=214500000000 PS=1030000 PD=1960000
.ENDS sky130_fd_sc_hd__o32a_2

* cell sky130_fd_sc_hd__and3b_2
* pin VPB
* pin VPWR
* pin B
* pin VGND
* pin C
* pin A_N
* pin X
* pin sky130_gnd
.SUBCKT sky130_fd_sc_hd__and3b_2 VPB VPWR B VGND C A_N X sky130_gnd
* device instance $1 r0 *1 2.305,1.695 sky130_fd_pr__pfet_01v8_hvt
XM$1 \$6 C VPWR VPB sky130_fd_pr__pfet_01v8_hvt L=150000 W=420000
+ AS=74375000000 AD=145750000000 PS=815000 PD=1335000
* device instance $2 r0 *1 1.41,1.765 sky130_fd_pr__pfet_01v8_hvt
XM$2 \$6 \$7 VPWR VPB sky130_fd_pr__pfet_01v8_hvt L=150000 W=420000
+ AS=109200000000 AD=56700000000 PS=1360000 PD=690000
* device instance $3 r0 *1 1.83,1.765 sky130_fd_pr__pfet_01v8_hvt
XM$3 \$6 B VPWR VPB sky130_fd_pr__pfet_01v8_hvt L=150000 W=420000
+ AS=74375000000 AD=56700000000 PS=815000 PD=690000
* device instance $4 r0 *1 2.79,1.985 sky130_fd_pr__pfet_01v8_hvt
XM$4 VPWR \$6 X VPB sky130_fd_pr__pfet_01v8_hvt L=150000 W=1000000
+ AS=145750000000 AD=135000000000 PS=1335000 PD=1270000
* device instance $5 r0 *1 3.21,1.985 sky130_fd_pr__pfet_01v8_hvt
XM$5 X \$6 VPWR VPB sky130_fd_pr__pfet_01v8_hvt L=150000 W=1000000
+ AS=135000000000 AD=260000000000 PS=1270000 PD=2520000
* device instance $6 r0 *1 0.47,1.765 sky130_fd_pr__pfet_01v8_hvt
XM$6 VPWR A_N \$7 VPB sky130_fd_pr__pfet_01v8_hvt L=150000 W=420000
+ AS=109200000000 AD=109200000000 PS=1360000 PD=1360000
* device instance $7 r0 *1 1.43,0.475 sky130_fd_pr__nfet_01v8
XM$7 \$6 \$7 \$12 sky130_gnd sky130_fd_pr__nfet_01v8 L=150000 W=420000
+ AS=109200000000 AD=44100000000 PS=1360000 PD=630000
* device instance $8 r0 *1 1.79,0.475 sky130_fd_pr__nfet_01v8
XM$8 \$12 B \$11 sky130_gnd sky130_fd_pr__nfet_01v8 L=150000 W=420000
+ AS=44100000000 AD=53550000000 PS=630000 PD=675000
* device instance $9 r0 *1 2.195,0.475 sky130_fd_pr__nfet_01v8
XM$9 VGND C \$11 sky130_gnd sky130_fd_pr__nfet_01v8 L=150000 W=420000
+ AS=127150000000 AD=53550000000 PS=1095000 PD=675000
* device instance $10 r0 *1 2.79,0.56 sky130_fd_pr__nfet_01v8
XM$10 VGND \$6 X sky130_gnd sky130_fd_pr__nfet_01v8 L=150000 W=650000
+ AS=127150000000 AD=87750000000 PS=1095000 PD=920000
* device instance $11 r0 *1 3.21,0.56 sky130_fd_pr__nfet_01v8
XM$11 X \$6 VGND sky130_gnd sky130_fd_pr__nfet_01v8 L=150000 W=650000
+ AS=87750000000 AD=169000000000 PS=920000 PD=1820000
* device instance $12 r0 *1 0.47,0.475 sky130_fd_pr__nfet_01v8
XM$12 VGND A_N \$7 sky130_gnd sky130_fd_pr__nfet_01v8 L=150000 W=420000
+ AS=109200000000 AD=117600000000 PS=1360000 PD=1400000
.ENDS sky130_fd_sc_hd__and3b_2

* cell VIA_M1M2_PR_MR
* pin
.SUBCKT VIA_M1M2_PR_MR \$1
.ENDS VIA_M1M2_PR_MR

* cell sky130_fd_sc_hd__o22a_2
* pin VPB
* pin VGND
* pin VPWR
* pin X
* pin B1
* pin B2
* pin A2
* pin A1
* pin sky130_gnd
.SUBCKT sky130_fd_sc_hd__o22a_2 VPB VGND VPWR X B1 B2 A2 A1 sky130_gnd
* device instance $1 r0 *1 0.49,1.985 sky130_fd_pr__pfet_01v8_hvt
XM$1 VPWR \$5 X VPB sky130_fd_pr__pfet_01v8_hvt L=150000 W=1000000
+ AS=280000000000 AD=135000000000 PS=2560000 PD=1270000
* device instance $2 r0 *1 0.91,1.985 sky130_fd_pr__pfet_01v8_hvt
XM$2 X \$5 VPWR VPB sky130_fd_pr__pfet_01v8_hvt L=150000 W=1000000
+ AS=135000000000 AD=390000000000 PS=1270000 PD=1780000
* device instance $3 r0 *1 1.84,1.985 sky130_fd_pr__pfet_01v8_hvt
XM$3 VPWR B1 \$12 VPB sky130_fd_pr__pfet_01v8_hvt L=150000 W=1000000
+ AS=390000000000 AD=105000000000 PS=1780000 PD=1210000
* device instance $4 r0 *1 2.2,1.985 sky130_fd_pr__pfet_01v8_hvt
XM$4 \$12 B2 \$5 VPB sky130_fd_pr__pfet_01v8_hvt L=150000 W=1000000
+ AS=105000000000 AD=235000000000 PS=1210000 PD=1470000
* device instance $5 r0 *1 2.82,1.985 sky130_fd_pr__pfet_01v8_hvt
XM$5 \$5 A2 \$13 VPB sky130_fd_pr__pfet_01v8_hvt L=150000 W=1000000
+ AS=235000000000 AD=105000000000 PS=1470000 PD=1210000
* device instance $6 r0 *1 3.18,1.985 sky130_fd_pr__pfet_01v8_hvt
XM$6 \$13 A1 VPWR VPB sky130_fd_pr__pfet_01v8_hvt L=150000 W=1000000
+ AS=105000000000 AD=280000000000 PS=1210000 PD=2560000
* device instance $7 r0 *1 1.84,0.56 sky130_fd_pr__nfet_01v8
XM$7 \$7 B1 \$5 sky130_gnd sky130_fd_pr__nfet_01v8 L=150000 W=650000
+ AS=169000000000 AD=87750000000 PS=1820000 PD=920000
* device instance $8 r0 *1 2.26,0.56 sky130_fd_pr__nfet_01v8
XM$8 \$5 B2 \$7 sky130_gnd sky130_fd_pr__nfet_01v8 L=150000 W=650000
+ AS=87750000000 AD=123500000000 PS=920000 PD=1030000
* device instance $9 r0 *1 2.79,0.56 sky130_fd_pr__nfet_01v8
XM$9 \$7 A2 VGND sky130_gnd sky130_fd_pr__nfet_01v8 L=150000 W=650000
+ AS=123500000000 AD=87750000000 PS=1030000 PD=920000
* device instance $10 r0 *1 3.21,0.56 sky130_fd_pr__nfet_01v8
XM$10 VGND A1 \$7 sky130_gnd sky130_fd_pr__nfet_01v8 L=150000 W=650000
+ AS=87750000000 AD=169000000000 PS=920000 PD=1820000
* device instance $11 r0 *1 0.48,0.56 sky130_fd_pr__nfet_01v8
XM$11 VGND \$5 X sky130_gnd sky130_fd_pr__nfet_01v8 L=150000 W=650000
+ AS=169000000000 AD=87750000000 PS=1820000 PD=920000
* device instance $12 r0 *1 0.9,0.56 sky130_fd_pr__nfet_01v8
XM$12 X \$5 VGND sky130_gnd sky130_fd_pr__nfet_01v8 L=150000 W=650000
+ AS=87750000000 AD=169000000000 PS=920000 PD=1820000
.ENDS sky130_fd_sc_hd__o22a_2

* cell sky130_fd_sc_hd__a22oi_2
* pin VGND
* pin B2
* pin B1
* pin Y
* pin A1
* pin A2
* pin VPWR
* pin VPB
* pin sky130_gnd
.SUBCKT sky130_fd_sc_hd__a22oi_2 VGND B2 B1 Y A1 A2 VPWR VPB sky130_gnd
* device instance $1 r0 *1 2.67,1.985 sky130_fd_pr__pfet_01v8_hvt
XM$1 \$10 A1 VPWR VPB sky130_fd_pr__pfet_01v8_hvt L=150000 W=1000000
+ AS=260000000000 AD=135000000000 PS=2520000 PD=1270000
* device instance $2 r0 *1 3.09,1.985 sky130_fd_pr__pfet_01v8_hvt
XM$2 VPWR A1 \$10 VPB sky130_fd_pr__pfet_01v8_hvt L=150000 W=1000000
+ AS=135000000000 AD=135000000000 PS=1270000 PD=1270000
* device instance $3 r0 *1 3.51,1.985 sky130_fd_pr__pfet_01v8_hvt
XM$3 \$10 A2 VPWR VPB sky130_fd_pr__pfet_01v8_hvt L=150000 W=1000000
+ AS=135000000000 AD=135000000000 PS=1270000 PD=1270000
* device instance $4 r0 *1 3.93,1.985 sky130_fd_pr__pfet_01v8_hvt
XM$4 VPWR A2 \$10 VPB sky130_fd_pr__pfet_01v8_hvt L=150000 W=1000000
+ AS=135000000000 AD=260000000000 PS=1270000 PD=2520000
* device instance $5 r0 *1 0.47,1.985 sky130_fd_pr__pfet_01v8_hvt
XM$5 Y B2 \$10 VPB sky130_fd_pr__pfet_01v8_hvt L=150000 W=1000000
+ AS=260000000000 AD=135000000000 PS=2520000 PD=1270000
* device instance $6 r0 *1 0.89,1.985 sky130_fd_pr__pfet_01v8_hvt
XM$6 \$10 B2 Y VPB sky130_fd_pr__pfet_01v8_hvt L=150000 W=1000000
+ AS=135000000000 AD=135000000000 PS=1270000 PD=1270000
* device instance $7 r0 *1 1.31,1.985 sky130_fd_pr__pfet_01v8_hvt
XM$7 Y B1 \$10 VPB sky130_fd_pr__pfet_01v8_hvt L=150000 W=1000000
+ AS=135000000000 AD=135000000000 PS=1270000 PD=1270000
* device instance $8 r0 *1 1.73,1.985 sky130_fd_pr__pfet_01v8_hvt
XM$8 \$10 B1 Y VPB sky130_fd_pr__pfet_01v8_hvt L=150000 W=1000000
+ AS=135000000000 AD=260000000000 PS=1270000 PD=2520000
* device instance $9 r0 *1 2.67,0.56 sky130_fd_pr__nfet_01v8
XM$9 \$7 A1 Y sky130_gnd sky130_fd_pr__nfet_01v8 L=150000 W=650000
+ AS=169000000000 AD=87750000000 PS=1820000 PD=920000
* device instance $10 r0 *1 3.09,0.56 sky130_fd_pr__nfet_01v8
XM$10 Y A1 \$7 sky130_gnd sky130_fd_pr__nfet_01v8 L=150000 W=650000
+ AS=87750000000 AD=87750000000 PS=920000 PD=920000
* device instance $11 r0 *1 3.51,0.56 sky130_fd_pr__nfet_01v8
XM$11 \$7 A2 VGND sky130_gnd sky130_fd_pr__nfet_01v8 L=150000 W=650000
+ AS=87750000000 AD=87750000000 PS=920000 PD=920000
* device instance $12 r0 *1 3.93,0.56 sky130_fd_pr__nfet_01v8
XM$12 VGND A2 \$7 sky130_gnd sky130_fd_pr__nfet_01v8 L=150000 W=650000
+ AS=87750000000 AD=169000000000 PS=920000 PD=1820000
* device instance $13 r0 *1 0.47,0.56 sky130_fd_pr__nfet_01v8
XM$13 \$3 B2 VGND sky130_gnd sky130_fd_pr__nfet_01v8 L=150000 W=650000
+ AS=169000000000 AD=87750000000 PS=1820000 PD=920000
* device instance $14 r0 *1 0.89,0.56 sky130_fd_pr__nfet_01v8
XM$14 VGND B2 \$3 sky130_gnd sky130_fd_pr__nfet_01v8 L=150000 W=650000
+ AS=87750000000 AD=87750000000 PS=920000 PD=920000
* device instance $15 r0 *1 1.31,0.56 sky130_fd_pr__nfet_01v8
XM$15 \$3 B1 Y sky130_gnd sky130_fd_pr__nfet_01v8 L=150000 W=650000
+ AS=87750000000 AD=87750000000 PS=920000 PD=920000
* device instance $16 r0 *1 1.73,0.56 sky130_fd_pr__nfet_01v8
XM$16 Y B1 \$3 sky130_gnd sky130_fd_pr__nfet_01v8 L=150000 W=650000
+ AS=87750000000 AD=169000000000 PS=920000 PD=1820000
.ENDS sky130_fd_sc_hd__a22oi_2

* cell sky130_fd_sc_hd__a221o_2
* pin VGND
* pin C1
* pin B2
* pin B1
* pin A1
* pin A2
* pin X
* pin VPWR
* pin VPB
* pin sky130_gnd
.SUBCKT sky130_fd_sc_hd__a221o_2 VGND C1 B2 B1 A1 A2 X VPWR VPB sky130_gnd
* device instance $1 r0 *1 2.25,1.985 sky130_fd_pr__pfet_01v8_hvt
XM$1 VPWR A1 \$13 VPB sky130_fd_pr__pfet_01v8_hvt L=150000 W=1000000
+ AS=260000000000 AD=165000000000 PS=2520000 PD=1330000
* device instance $2 r0 *1 2.73,1.985 sky130_fd_pr__pfet_01v8_hvt
XM$2 \$13 A2 VPWR VPB sky130_fd_pr__pfet_01v8_hvt L=150000 W=1000000
+ AS=165000000000 AD=157500000000 PS=1330000 PD=1315000
* device instance $3 r0 *1 3.195,1.985 sky130_fd_pr__pfet_01v8_hvt
XM$3 VPWR \$3 X VPB sky130_fd_pr__pfet_01v8_hvt L=150000 W=1000000
+ AS=157500000000 AD=135000000000 PS=1315000 PD=1270000
* device instance $4 r0 *1 3.615,1.985 sky130_fd_pr__pfet_01v8_hvt
XM$4 X \$3 VPWR VPB sky130_fd_pr__pfet_01v8_hvt L=150000 W=1000000
+ AS=135000000000 AD=285000000000 PS=1270000 PD=2570000
* device instance $5 r0 *1 0.47,1.985 sky130_fd_pr__pfet_01v8_hvt
XM$5 \$3 C1 \$12 VPB sky130_fd_pr__pfet_01v8_hvt L=150000 W=1000000
+ AS=260000000000 AD=135000000000 PS=2520000 PD=1270000
* device instance $6 r0 *1 0.89,1.985 sky130_fd_pr__pfet_01v8_hvt
XM$6 \$12 B2 \$13 VPB sky130_fd_pr__pfet_01v8_hvt L=150000 W=1000000
+ AS=135000000000 AD=135000000000 PS=1270000 PD=1270000
* device instance $7 r0 *1 1.31,1.985 sky130_fd_pr__pfet_01v8_hvt
XM$7 \$13 B1 \$12 VPB sky130_fd_pr__pfet_01v8_hvt L=150000 W=1000000
+ AS=135000000000 AD=260000000000 PS=1270000 PD=2520000
* device instance $8 r0 *1 2.25,0.56 sky130_fd_pr__nfet_01v8
XM$8 \$3 A1 \$11 sky130_gnd sky130_fd_pr__nfet_01v8 L=150000 W=650000
+ AS=169000000000 AD=107250000000 PS=1820000 PD=980000
* device instance $9 r0 *1 2.73,0.56 sky130_fd_pr__nfet_01v8
XM$9 \$11 A2 VGND sky130_gnd sky130_fd_pr__nfet_01v8 L=150000 W=650000
+ AS=107250000000 AD=102375000000 PS=980000 PD=965000
* device instance $10 r0 *1 3.195,0.56 sky130_fd_pr__nfet_01v8
XM$10 VGND \$3 X sky130_gnd sky130_fd_pr__nfet_01v8 L=150000 W=650000
+ AS=102375000000 AD=87750000000 PS=965000 PD=920000
* device instance $11 r0 *1 3.615,0.56 sky130_fd_pr__nfet_01v8
XM$11 X \$3 VGND sky130_gnd sky130_fd_pr__nfet_01v8 L=150000 W=650000
+ AS=87750000000 AD=185250000000 PS=920000 PD=1870000
* device instance $12 r0 *1 0.47,0.56 sky130_fd_pr__nfet_01v8
XM$12 \$3 C1 VGND sky130_gnd sky130_fd_pr__nfet_01v8 L=150000 W=650000
+ AS=169000000000 AD=107250000000 PS=1820000 PD=980000
* device instance $13 r0 *1 0.95,0.56 sky130_fd_pr__nfet_01v8
XM$13 VGND B2 \$10 sky130_gnd sky130_fd_pr__nfet_01v8 L=150000 W=650000
+ AS=107250000000 AD=68250000000 PS=980000 PD=860000
* device instance $14 r0 *1 1.31,0.56 sky130_fd_pr__nfet_01v8
XM$14 \$10 B1 \$3 sky130_gnd sky130_fd_pr__nfet_01v8 L=150000 W=650000
+ AS=68250000000 AD=169000000000 PS=860000 PD=1820000
.ENDS sky130_fd_sc_hd__a221o_2

* cell sky130_fd_sc_hd__dfstp_2
* pin VGND
* pin SET_B
* pin Q
* pin CLK
* pin D
* pin VPWR
* pin VPB
* pin sky130_gnd
.SUBCKT sky130_fd_sc_hd__dfstp_2 VGND SET_B Q CLK D VPWR VPB sky130_gnd
* device instance $1 r0 *1 1.83,2.065 sky130_fd_pr__pfet_01v8_hvt
XM$1 VPWR D \$6 VPB sky130_fd_pr__pfet_01v8_hvt L=150000 W=840000
+ AS=218400000000 AD=124950000000 PS=2200000 PD=1175000
* device instance $2 r0 *1 2.315,2.275 sky130_fd_pr__pfet_01v8_hvt
XM$2 \$6 \$5 \$7 VPB sky130_fd_pr__pfet_01v8_hvt L=150000 W=420000
+ AS=124950000000 AD=56700000000 PS=1175000 PD=690000
* device instance $3 r0 *1 2.735,2.275 sky130_fd_pr__pfet_01v8_hvt
XM$3 \$7 \$4 \$22 VPB sky130_fd_pr__pfet_01v8_hvt L=150000 W=420000
+ AS=56700000000 AD=94500000000 PS=690000 PD=870000
* device instance $4 r0 *1 3.335,2.275 sky130_fd_pr__pfet_01v8_hvt
XM$4 \$22 \$20 VPWR VPB sky130_fd_pr__pfet_01v8_hvt L=150000 W=420000
+ AS=94500000000 AD=79800000000 PS=870000 PD=800000
* device instance $5 r0 *1 3.865,2.275 sky130_fd_pr__pfet_01v8_hvt
XM$5 VPWR SET_B \$20 VPB sky130_fd_pr__pfet_01v8_hvt L=150000 W=420000
+ AS=79800000000 AD=56700000000 PS=800000 PD=690000
* device instance $6 r0 *1 4.285,2.275 sky130_fd_pr__pfet_01v8_hvt
XM$6 \$20 \$7 VPWR VPB sky130_fd_pr__pfet_01v8_hvt L=150000 W=420000
+ AS=56700000000 AD=56700000000 PS=690000 PD=690000
* device instance $7 r0 *1 4.705,2.275 sky130_fd_pr__pfet_01v8_hvt
XM$7 VPWR \$7 \$23 VPB sky130_fd_pr__pfet_01v8_hvt L=150000 W=420000
+ AS=56700000000 AD=44100000000 PS=690000 PD=630000
* device instance $8 r0 *1 5.065,2.275 sky130_fd_pr__pfet_01v8_hvt
XM$8 \$23 \$4 \$9 VPB sky130_fd_pr__pfet_01v8_hvt L=150000 W=420000
+ AS=44100000000 AD=81900000000 PS=630000 PD=810000
* device instance $9 r0 *1 5.605,2.275 sky130_fd_pr__pfet_01v8_hvt
XM$9 \$9 \$5 \$24 VPB sky130_fd_pr__pfet_01v8_hvt L=150000 W=420000
+ AS=81900000000 AD=44100000000 PS=810000 PD=630000
* device instance $10 r0 *1 5.965,2.275 sky130_fd_pr__pfet_01v8_hvt
XM$10 \$24 \$19 VPWR VPB sky130_fd_pr__pfet_01v8_hvt L=150000 W=420000
+ AS=44100000000 AD=109200000000 PS=630000 PD=1360000
* device instance $11 r0 *1 6.905,2.275 sky130_fd_pr__pfet_01v8_hvt
XM$11 VPWR SET_B \$9 VPB sky130_fd_pr__pfet_01v8_hvt L=150000 W=420000
+ AS=120750000000 AD=109200000000 PS=1165000 PD=1360000
* device instance $12 r0 *1 7.38,2.065 sky130_fd_pr__pfet_01v8_hvt
XM$12 VPWR \$9 \$19 VPB sky130_fd_pr__pfet_01v8_hvt L=150000 W=840000
+ AS=120750000000 AD=222600000000 PS=1165000 PD=2210000
* device instance $13 r0 *1 0.47,2.135 sky130_fd_pr__pfet_01v8_hvt
XM$13 \$4 CLK VPWR VPB sky130_fd_pr__pfet_01v8_hvt L=150000 W=640000
+ AS=166400000000 AD=86400000000 PS=1800000 PD=910000
* device instance $14 r0 *1 0.89,2.135 sky130_fd_pr__pfet_01v8_hvt
XM$14 VPWR \$4 \$5 VPB sky130_fd_pr__pfet_01v8_hvt L=150000 W=640000
+ AS=86400000000 AD=166400000000 PS=910000 PD=1800000
* device instance $15 r0 *1 8.345,1.985 sky130_fd_pr__pfet_01v8_hvt
XM$15 \$10 \$9 VPWR VPB sky130_fd_pr__pfet_01v8_hvt L=150000 W=1000000
+ AS=260000000000 AD=135000000000 PS=2520000 PD=1270000
* device instance $16 r0 *1 8.765,1.985 sky130_fd_pr__pfet_01v8_hvt
XM$16 VPWR \$10 Q VPB sky130_fd_pr__pfet_01v8_hvt L=150000 W=1000000
+ AS=135000000000 AD=135000000000 PS=1270000 PD=1270000
* device instance $17 r0 *1 9.185,1.985 sky130_fd_pr__pfet_01v8_hvt
XM$17 Q \$10 VPWR VPB sky130_fd_pr__pfet_01v8_hvt L=150000 W=1000000
+ AS=135000000000 AD=260000000000 PS=1270000 PD=2520000
* device instance $18 r0 *1 2.305,0.415 sky130_fd_pr__nfet_01v8
XM$18 \$6 \$4 \$7 sky130_gnd sky130_fd_pr__nfet_01v8 L=150000 W=360000
+ AS=93500000000 AD=72000000000 PS=965000 PD=760000
* device instance $19 r0 *1 2.855,0.415 sky130_fd_pr__nfet_01v8
XM$19 \$7 \$5 \$13 sky130_gnd sky130_fd_pr__nfet_01v8 L=150000 W=360000
+ AS=72000000000 AD=67050000000 PS=760000 PD=750000
* device instance $20 r0 *1 3.335,0.445 sky130_fd_pr__nfet_01v8
XM$20 \$13 \$20 VGND sky130_gnd sky130_fd_pr__nfet_01v8 L=150000 W=420000
+ AS=67050000000 AD=88200000000 PS=750000 PD=840000
* device instance $21 r0 *1 3.905,0.445 sky130_fd_pr__nfet_01v8
XM$21 VGND SET_B \$16 sky130_gnd sky130_fd_pr__nfet_01v8 L=150000 W=420000
+ AS=88200000000 AD=44100000000 PS=840000 PD=630000
* device instance $22 r0 *1 4.265,0.445 sky130_fd_pr__nfet_01v8
XM$22 \$16 \$7 \$20 sky130_gnd sky130_fd_pr__nfet_01v8 L=150000 W=420000
+ AS=44100000000 AD=109200000000 PS=630000 PD=1360000
* device instance $23 r0 *1 1.83,0.555 sky130_fd_pr__nfet_01v8
XM$23 VGND D \$6 sky130_gnd sky130_fd_pr__nfet_01v8 L=150000 W=640000
+ AS=166400000000 AD=93500000000 PS=1800000 PD=965000
* device instance $24 r0 *1 5.205,0.445 sky130_fd_pr__nfet_01v8
XM$24 VGND \$7 \$15 sky130_gnd sky130_fd_pr__nfet_01v8 L=150000 W=420000
+ AS=109200000000 AD=44100000000 PS=1360000 PD=630000
* device instance $25 r0 *1 5.565,0.445 sky130_fd_pr__nfet_01v8
XM$25 \$15 \$5 \$9 sky130_gnd sky130_fd_pr__nfet_01v8 L=150000 W=420000
+ AS=44100000000 AD=73500000000 PS=630000 PD=770000
* device instance $26 r0 *1 6.065,0.445 sky130_fd_pr__nfet_01v8
XM$26 \$9 \$4 \$12 sky130_gnd sky130_fd_pr__nfet_01v8 L=150000 W=420000
+ AS=73500000000 AD=44100000000 PS=770000 PD=630000
* device instance $27 r0 *1 6.425,0.445 sky130_fd_pr__nfet_01v8
XM$27 \$12 \$19 \$14 sky130_gnd sky130_fd_pr__nfet_01v8 L=150000 W=420000
+ AS=44100000000 AD=44100000000 PS=630000 PD=630000
* device instance $28 r0 *1 6.785,0.445 sky130_fd_pr__nfet_01v8
XM$28 \$14 SET_B VGND sky130_gnd sky130_fd_pr__nfet_01v8 L=150000 W=420000
+ AS=44100000000 AD=113700000000 PS=630000 PD=1010000
* device instance $29 r0 *1 7.405,0.505 sky130_fd_pr__nfet_01v8
XM$29 VGND \$9 \$19 sky130_gnd sky130_fd_pr__nfet_01v8 L=150000 W=540000
+ AS=113700000000 AD=140400000000 PS=1010000 PD=1600000
* device instance $30 r0 *1 8.345,0.56 sky130_fd_pr__nfet_01v8
XM$30 \$10 \$9 VGND sky130_gnd sky130_fd_pr__nfet_01v8 L=150000 W=650000
+ AS=169000000000 AD=87750000000 PS=1820000 PD=920000
* device instance $31 r0 *1 8.765,0.56 sky130_fd_pr__nfet_01v8
XM$31 VGND \$10 Q sky130_gnd sky130_fd_pr__nfet_01v8 L=150000 W=650000
+ AS=87750000000 AD=87750000000 PS=920000 PD=920000
* device instance $32 r0 *1 9.185,0.56 sky130_fd_pr__nfet_01v8
XM$32 Q \$10 VGND sky130_gnd sky130_fd_pr__nfet_01v8 L=150000 W=650000
+ AS=87750000000 AD=169000000000 PS=920000 PD=1820000
* device instance $33 r0 *1 0.47,0.445 sky130_fd_pr__nfet_01v8
XM$33 \$4 CLK VGND sky130_gnd sky130_fd_pr__nfet_01v8 L=150000 W=420000
+ AS=109200000000 AD=56700000000 PS=1360000 PD=690000
* device instance $34 r0 *1 0.89,0.445 sky130_fd_pr__nfet_01v8
XM$34 VGND \$4 \$5 sky130_gnd sky130_fd_pr__nfet_01v8 L=150000 W=420000
+ AS=56700000000 AD=109200000000 PS=690000 PD=1360000
.ENDS sky130_fd_sc_hd__dfstp_2

* cell sky130_fd_sc_hd__a2111oi_2
* pin VGND
* pin Y
* pin C1
* pin D1
* pin B1
* pin A1
* pin A2
* pin VPWR
* pin VPB
* pin sky130_gnd
.SUBCKT sky130_fd_sc_hd__a2111oi_2 VGND Y C1 D1 B1 A1 A2 VPWR VPB sky130_gnd
* device instance $1 r0 *1 3.64,1.985 sky130_fd_pr__pfet_01v8_hvt
XM$1 \$12 A1 VPWR VPB sky130_fd_pr__pfet_01v8_hvt L=150000 W=1000000
+ AS=260000000000 AD=140000000000 PS=2520000 PD=1280000
* device instance $2 r0 *1 4.07,1.985 sky130_fd_pr__pfet_01v8_hvt
XM$2 VPWR A2 \$12 VPB sky130_fd_pr__pfet_01v8_hvt L=150000 W=1000000
+ AS=140000000000 AD=140000000000 PS=1280000 PD=1280000
* device instance $3 r0 *1 4.5,1.985 sky130_fd_pr__pfet_01v8_hvt
XM$3 \$12 A2 VPWR VPB sky130_fd_pr__pfet_01v8_hvt L=150000 W=1000000
+ AS=140000000000 AD=160000000000 PS=1280000 PD=1320000
* device instance $4 r0 *1 4.97,1.985 sky130_fd_pr__pfet_01v8_hvt
XM$4 VPWR A1 \$12 VPB sky130_fd_pr__pfet_01v8_hvt L=150000 W=1000000
+ AS=160000000000 AD=335000000000 PS=1320000 PD=2670000
* device instance $5 r0 *1 0.5,1.985 sky130_fd_pr__pfet_01v8_hvt
XM$5 \$11 C1 \$15 VPB sky130_fd_pr__pfet_01v8_hvt L=150000 W=1000000
+ AS=285000000000 AD=140000000000 PS=2570000 PD=1280000
* device instance $6 r0 *1 0.93,1.985 sky130_fd_pr__pfet_01v8_hvt
XM$6 \$15 D1 Y VPB sky130_fd_pr__pfet_01v8_hvt L=150000 W=1000000
+ AS=140000000000 AD=140000000000 PS=1280000 PD=1280000
* device instance $7 r0 *1 1.36,1.985 sky130_fd_pr__pfet_01v8_hvt
XM$7 Y D1 \$16 VPB sky130_fd_pr__pfet_01v8_hvt L=150000 W=1000000
+ AS=140000000000 AD=140000000000 PS=1280000 PD=1280000
* device instance $8 r0 *1 1.79,1.985 sky130_fd_pr__pfet_01v8_hvt
XM$8 \$16 C1 \$11 VPB sky130_fd_pr__pfet_01v8_hvt L=150000 W=1000000
+ AS=140000000000 AD=160000000000 PS=1280000 PD=1320000
* device instance $9 r0 *1 2.26,1.985 sky130_fd_pr__pfet_01v8_hvt
XM$9 \$11 B1 \$12 VPB sky130_fd_pr__pfet_01v8_hvt L=150000 W=1000000
+ AS=160000000000 AD=140000000000 PS=1320000 PD=1280000
* device instance $10 r0 *1 2.69,1.985 sky130_fd_pr__pfet_01v8_hvt
XM$10 \$12 B1 \$11 VPB sky130_fd_pr__pfet_01v8_hvt L=150000 W=1000000
+ AS=140000000000 AD=260000000000 PS=1280000 PD=2520000
* device instance $11 r0 *1 0.5,0.56 sky130_fd_pr__nfet_01v8
XM$11 Y C1 VGND sky130_gnd sky130_fd_pr__nfet_01v8 L=150000 W=650000
+ AS=185250000000 AD=91000000000 PS=1870000 PD=930000
* device instance $12 r0 *1 0.93,0.56 sky130_fd_pr__nfet_01v8
XM$12 VGND D1 Y sky130_gnd sky130_fd_pr__nfet_01v8 L=150000 W=650000
+ AS=91000000000 AD=91000000000 PS=930000 PD=930000
* device instance $13 r0 *1 1.36,0.56 sky130_fd_pr__nfet_01v8
XM$13 Y D1 VGND sky130_gnd sky130_fd_pr__nfet_01v8 L=150000 W=650000
+ AS=91000000000 AD=126750000000 PS=930000 PD=1040000
* device instance $14 r0 *1 1.9,0.56 sky130_fd_pr__nfet_01v8
XM$14 VGND C1 Y sky130_gnd sky130_fd_pr__nfet_01v8 L=150000 W=650000
+ AS=126750000000 AD=105625000000 PS=1040000 PD=975000
* device instance $15 r0 *1 2.375,0.56 sky130_fd_pr__nfet_01v8
XM$15 Y B1 VGND sky130_gnd sky130_fd_pr__nfet_01v8 L=150000 W=650000
+ AS=105625000000 AD=126750000000 PS=975000 PD=1040000
* device instance $16 r0 *1 2.915,0.56 sky130_fd_pr__nfet_01v8
XM$16 VGND B1 Y sky130_gnd sky130_fd_pr__nfet_01v8 L=150000 W=650000
+ AS=126750000000 AD=91000000000 PS=1040000 PD=930000
* device instance $17 r0 *1 3.345,0.56 sky130_fd_pr__nfet_01v8
XM$17 Y A1 \$5 sky130_gnd sky130_fd_pr__nfet_01v8 L=150000 W=650000
+ AS=91000000000 AD=178750000000 PS=930000 PD=1200000
* device instance $18 r0 *1 4.045,0.56 sky130_fd_pr__nfet_01v8
XM$18 \$5 A2 VGND sky130_gnd sky130_fd_pr__nfet_01v8 L=150000 W=650000
+ AS=178750000000 AD=112125000000 PS=1200000 PD=995000
* device instance $19 r0 *1 4.54,0.56 sky130_fd_pr__nfet_01v8
XM$19 VGND A2 \$4 sky130_gnd sky130_fd_pr__nfet_01v8 L=150000 W=650000
+ AS=112125000000 AD=91000000000 PS=995000 PD=930000
* device instance $20 r0 *1 4.97,0.56 sky130_fd_pr__nfet_01v8
XM$20 \$4 A1 Y sky130_gnd sky130_fd_pr__nfet_01v8 L=150000 W=650000
+ AS=91000000000 AD=172250000000 PS=930000 PD=1830000
.ENDS sky130_fd_sc_hd__a2111oi_2

* cell sky130_fd_sc_hd__o221a_2
* pin VGND
* pin X
* pin C1
* pin B1
* pin B2
* pin A2
* pin A1
* pin VPWR
* pin VPB
* pin sky130_gnd
.SUBCKT sky130_fd_sc_hd__o221a_2 VGND X C1 B1 B2 A2 A1 VPWR VPB sky130_gnd
* device instance $1 r0 *1 0.63,1.985 sky130_fd_pr__pfet_01v8_hvt
XM$1 \$3 C1 VPWR VPB sky130_fd_pr__pfet_01v8_hvt L=150000 W=1000000
+ AS=325000000000 AD=165000000000 PS=2650000 PD=1330000
* device instance $2 r0 *1 1.11,1.985 sky130_fd_pr__pfet_01v8_hvt
XM$2 VPWR B1 \$14 VPB sky130_fd_pr__pfet_01v8_hvt L=150000 W=1000000
+ AS=165000000000 AD=112500000000 PS=1330000 PD=1225000
* device instance $3 r0 *1 1.485,1.985 sky130_fd_pr__pfet_01v8_hvt
XM$3 \$14 B2 \$3 VPB sky130_fd_pr__pfet_01v8_hvt L=150000 W=1000000
+ AS=112500000000 AD=387500000000 PS=1225000 PD=1775000
* device instance $4 r0 *1 2.41,1.985 sky130_fd_pr__pfet_01v8_hvt
XM$4 \$3 A2 \$15 VPB sky130_fd_pr__pfet_01v8_hvt L=150000 W=1000000
+ AS=387500000000 AD=105000000000 PS=1775000 PD=1210000
* device instance $5 r0 *1 2.77,1.985 sky130_fd_pr__pfet_01v8_hvt
XM$5 \$15 A1 VPWR VPB sky130_fd_pr__pfet_01v8_hvt L=150000 W=1000000
+ AS=105000000000 AD=165000000000 PS=1210000 PD=1330000
* device instance $6 r0 *1 3.25,1.985 sky130_fd_pr__pfet_01v8_hvt
XM$6 VPWR \$3 X VPB sky130_fd_pr__pfet_01v8_hvt L=150000 W=1000000
+ AS=165000000000 AD=135000000000 PS=1330000 PD=1270000
* device instance $7 r0 *1 3.67,1.985 sky130_fd_pr__pfet_01v8_hvt
XM$7 X \$3 VPWR VPB sky130_fd_pr__pfet_01v8_hvt L=150000 W=1000000
+ AS=135000000000 AD=260000000000 PS=1270000 PD=2520000
* device instance $8 r0 *1 2.41,0.56 sky130_fd_pr__nfet_01v8
XM$8 VGND A2 \$5 sky130_gnd sky130_fd_pr__nfet_01v8 L=150000 W=650000
+ AS=169000000000 AD=87750000000 PS=1820000 PD=920000
* device instance $9 r0 *1 2.83,0.56 sky130_fd_pr__nfet_01v8
XM$9 \$5 A1 VGND sky130_gnd sky130_fd_pr__nfet_01v8 L=150000 W=650000
+ AS=87750000000 AD=87750000000 PS=920000 PD=920000
* device instance $10 r0 *1 3.25,0.56 sky130_fd_pr__nfet_01v8
XM$10 VGND \$3 X sky130_gnd sky130_fd_pr__nfet_01v8 L=150000 W=650000
+ AS=87750000000 AD=87750000000 PS=920000 PD=920000
* device instance $11 r0 *1 3.67,0.56 sky130_fd_pr__nfet_01v8
XM$11 X \$3 VGND sky130_gnd sky130_fd_pr__nfet_01v8 L=150000 W=650000
+ AS=87750000000 AD=169000000000 PS=920000 PD=1820000
* device instance $12 r0 *1 0.63,0.56 sky130_fd_pr__nfet_01v8
XM$12 \$3 C1 \$4 sky130_gnd sky130_fd_pr__nfet_01v8 L=150000 W=650000
+ AS=237250000000 AD=87750000000 PS=2030000 PD=920000
* device instance $13 r0 *1 1.05,0.56 sky130_fd_pr__nfet_01v8
XM$13 \$4 B1 \$5 sky130_gnd sky130_fd_pr__nfet_01v8 L=150000 W=650000
+ AS=87750000000 AD=87750000000 PS=920000 PD=920000
* device instance $14 r0 *1 1.47,0.56 sky130_fd_pr__nfet_01v8
XM$14 \$5 B2 \$4 sky130_gnd sky130_fd_pr__nfet_01v8 L=150000 W=650000
+ AS=87750000000 AD=169000000000 PS=920000 PD=1820000
.ENDS sky130_fd_sc_hd__o221a_2

* cell sky130_fd_sc_hd__o21ai_2
* pin VPB
* pin VPWR
* pin A1
* pin VGND
* pin A2
* pin Y
* pin B1
* pin sky130_gnd
.SUBCKT sky130_fd_sc_hd__o21ai_2 VPB VPWR A1 VGND A2 Y B1 sky130_gnd
* device instance $1 r0 *1 0.485,1.985 sky130_fd_pr__pfet_01v8_hvt
XM$1 VPWR A1 \$5 VPB sky130_fd_pr__pfet_01v8_hvt L=150000 W=1000000
+ AS=265000000000 AD=140000000000 PS=2530000 PD=1280000
* device instance $2 r0 *1 0.915,1.985 sky130_fd_pr__pfet_01v8_hvt
XM$2 \$5 A2 Y VPB sky130_fd_pr__pfet_01v8_hvt L=150000 W=1000000
+ AS=140000000000 AD=140000000000 PS=1280000 PD=1280000
* device instance $3 r0 *1 1.345,1.985 sky130_fd_pr__pfet_01v8_hvt
XM$3 Y A2 \$5 VPB sky130_fd_pr__pfet_01v8_hvt L=150000 W=1000000
+ AS=140000000000 AD=175000000000 PS=1280000 PD=1350000
* device instance $4 r0 *1 1.845,1.985 sky130_fd_pr__pfet_01v8_hvt
XM$4 \$5 A1 VPWR VPB sky130_fd_pr__pfet_01v8_hvt L=150000 W=1000000
+ AS=175000000000 AD=160000000000 PS=1350000 PD=1320000
* device instance $5 r0 *1 2.315,1.985 sky130_fd_pr__pfet_01v8_hvt
XM$5 VPWR B1 Y VPB sky130_fd_pr__pfet_01v8_hvt L=150000 W=1000000
+ AS=160000000000 AD=140000000000 PS=1320000 PD=1280000
* device instance $6 r0 *1 2.745,1.985 sky130_fd_pr__pfet_01v8_hvt
XM$6 Y B1 VPWR VPB sky130_fd_pr__pfet_01v8_hvt L=150000 W=1000000
+ AS=140000000000 AD=265000000000 PS=1280000 PD=2530000
* device instance $7 r0 *1 0.485,0.56 sky130_fd_pr__nfet_01v8
XM$7 \$2 A1 VGND sky130_gnd sky130_fd_pr__nfet_01v8 L=150000 W=650000
+ AS=172250000000 AD=91000000000 PS=1830000 PD=930000
* device instance $8 r0 *1 0.915,0.56 sky130_fd_pr__nfet_01v8
XM$8 VGND A2 \$2 sky130_gnd sky130_fd_pr__nfet_01v8 L=150000 W=650000
+ AS=91000000000 AD=91000000000 PS=930000 PD=930000
* device instance $9 r0 *1 1.345,0.56 sky130_fd_pr__nfet_01v8
XM$9 \$2 A2 VGND sky130_gnd sky130_fd_pr__nfet_01v8 L=150000 W=650000
+ AS=91000000000 AD=126750000000 PS=930000 PD=1040000
* device instance $10 r0 *1 1.885,0.56 sky130_fd_pr__nfet_01v8
XM$10 VGND A1 \$2 sky130_gnd sky130_fd_pr__nfet_01v8 L=150000 W=650000
+ AS=126750000000 AD=91000000000 PS=1040000 PD=930000
* device instance $11 r0 *1 2.315,0.56 sky130_fd_pr__nfet_01v8
XM$11 \$2 B1 Y sky130_gnd sky130_fd_pr__nfet_01v8 L=150000 W=650000
+ AS=91000000000 AD=91000000000 PS=930000 PD=930000
* device instance $12 r0 *1 2.745,0.56 sky130_fd_pr__nfet_01v8
XM$12 Y B1 \$2 sky130_gnd sky130_fd_pr__nfet_01v8 L=150000 W=650000
+ AS=91000000000 AD=172250000000 PS=930000 PD=1830000
.ENDS sky130_fd_sc_hd__o21ai_2

* cell sky130_fd_sc_hd__nor4_2
* pin VGND
* pin Y
* pin A
* pin B
* pin C
* pin D
* pin VPWR
* pin VPB
* pin sky130_gnd
.SUBCKT sky130_fd_sc_hd__nor4_2 VGND Y A B C D VPWR VPB sky130_gnd
* device instance $1 r0 *1 2.73,1.985 sky130_fd_pr__pfet_01v8_hvt
XM$1 \$11 C \$10 VPB sky130_fd_pr__pfet_01v8_hvt L=150000 W=1000000
+ AS=280000000000 AD=135000000000 PS=2560000 PD=1270000
* device instance $2 r0 *1 3.15,1.985 sky130_fd_pr__pfet_01v8_hvt
XM$2 \$10 C \$11 VPB sky130_fd_pr__pfet_01v8_hvt L=150000 W=1000000
+ AS=135000000000 AD=135000000000 PS=1270000 PD=1270000
* device instance $3 r0 *1 3.57,1.985 sky130_fd_pr__pfet_01v8_hvt
XM$3 \$11 D Y VPB sky130_fd_pr__pfet_01v8_hvt L=150000 W=1000000
+ AS=135000000000 AD=135000000000 PS=1270000 PD=1270000
* device instance $4 r0 *1 3.99,1.985 sky130_fd_pr__pfet_01v8_hvt
XM$4 Y D \$11 VPB sky130_fd_pr__pfet_01v8_hvt L=150000 W=1000000
+ AS=135000000000 AD=260000000000 PS=1270000 PD=2520000
* device instance $5 r0 *1 0.49,1.985 sky130_fd_pr__pfet_01v8_hvt
XM$5 \$8 A VPWR VPB sky130_fd_pr__pfet_01v8_hvt L=150000 W=1000000
+ AS=280000000000 AD=135000000000 PS=2560000 PD=1270000
* device instance $6 r0 *1 0.91,1.985 sky130_fd_pr__pfet_01v8_hvt
XM$6 VPWR A \$8 VPB sky130_fd_pr__pfet_01v8_hvt L=150000 W=1000000
+ AS=135000000000 AD=135000000000 PS=1270000 PD=1270000
* device instance $7 r0 *1 1.33,1.985 sky130_fd_pr__pfet_01v8_hvt
XM$7 \$8 B \$10 VPB sky130_fd_pr__pfet_01v8_hvt L=150000 W=1000000
+ AS=135000000000 AD=135000000000 PS=1270000 PD=1270000
* device instance $8 r0 *1 1.75,1.985 sky130_fd_pr__pfet_01v8_hvt
XM$8 \$10 B \$8 VPB sky130_fd_pr__pfet_01v8_hvt L=150000 W=1000000
+ AS=135000000000 AD=280000000000 PS=1270000 PD=2560000
* device instance $9 r0 *1 2.73,0.56 sky130_fd_pr__nfet_01v8
XM$9 VGND C Y sky130_gnd sky130_fd_pr__nfet_01v8 L=150000 W=650000
+ AS=182000000000 AD=87750000000 PS=1860000 PD=920000
* device instance $10 r0 *1 3.15,0.56 sky130_fd_pr__nfet_01v8
XM$10 Y C VGND sky130_gnd sky130_fd_pr__nfet_01v8 L=150000 W=650000
+ AS=87750000000 AD=87750000000 PS=920000 PD=920000
* device instance $11 r0 *1 3.57,0.56 sky130_fd_pr__nfet_01v8
XM$11 VGND D Y sky130_gnd sky130_fd_pr__nfet_01v8 L=150000 W=650000
+ AS=87750000000 AD=87750000000 PS=920000 PD=920000
* device instance $12 r0 *1 3.99,0.56 sky130_fd_pr__nfet_01v8
XM$12 Y D VGND sky130_gnd sky130_fd_pr__nfet_01v8 L=150000 W=650000
+ AS=87750000000 AD=169000000000 PS=920000 PD=1820000
* device instance $13 r0 *1 0.49,0.56 sky130_fd_pr__nfet_01v8
XM$13 VGND A Y sky130_gnd sky130_fd_pr__nfet_01v8 L=150000 W=650000
+ AS=182000000000 AD=87750000000 PS=1860000 PD=920000
* device instance $14 r0 *1 0.91,0.56 sky130_fd_pr__nfet_01v8
XM$14 Y A VGND sky130_gnd sky130_fd_pr__nfet_01v8 L=150000 W=650000
+ AS=87750000000 AD=87750000000 PS=920000 PD=920000
* device instance $15 r0 *1 1.33,0.56 sky130_fd_pr__nfet_01v8
XM$15 VGND B Y sky130_gnd sky130_fd_pr__nfet_01v8 L=150000 W=650000
+ AS=87750000000 AD=87750000000 PS=920000 PD=920000
* device instance $16 r0 *1 1.75,0.56 sky130_fd_pr__nfet_01v8
XM$16 Y B VGND sky130_gnd sky130_fd_pr__nfet_01v8 L=150000 W=650000
+ AS=87750000000 AD=182000000000 PS=920000 PD=1860000
.ENDS sky130_fd_sc_hd__nor4_2

* cell sky130_fd_sc_hd__clkbuf_16
* pin VGND
* pin A
* pin X
* pin VPWR
* pin VPB
* pin sky130_gnd
.SUBCKT sky130_fd_sc_hd__clkbuf_16 VGND A X VPWR VPB sky130_gnd
* device instance $1 r0 *1 0.475,1.985 sky130_fd_pr__pfet_01v8_hvt
XM$1 VPWR A \$3 VPB sky130_fd_pr__pfet_01v8_hvt L=150000 W=1000000
+ AS=265000000000 AD=140000000000 PS=2530000 PD=1280000
* device instance $2 r0 *1 0.905,1.985 sky130_fd_pr__pfet_01v8_hvt
XM$2 \$3 A VPWR VPB sky130_fd_pr__pfet_01v8_hvt L=150000 W=1000000
+ AS=140000000000 AD=140000000000 PS=1280000 PD=1280000
* device instance $3 r0 *1 1.335,1.985 sky130_fd_pr__pfet_01v8_hvt
XM$3 VPWR A \$3 VPB sky130_fd_pr__pfet_01v8_hvt L=150000 W=1000000
+ AS=140000000000 AD=140000000000 PS=1280000 PD=1280000
* device instance $4 r0 *1 1.765,1.985 sky130_fd_pr__pfet_01v8_hvt
XM$4 \$3 A VPWR VPB sky130_fd_pr__pfet_01v8_hvt L=150000 W=1000000
+ AS=140000000000 AD=140000000000 PS=1280000 PD=1280000
* device instance $5 r0 *1 2.195,1.985 sky130_fd_pr__pfet_01v8_hvt
XM$5 VPWR \$3 X VPB sky130_fd_pr__pfet_01v8_hvt L=150000 W=1000000
+ AS=140000000000 AD=140000000000 PS=1280000 PD=1280000
* device instance $6 r0 *1 2.625,1.985 sky130_fd_pr__pfet_01v8_hvt
XM$6 X \$3 VPWR VPB sky130_fd_pr__pfet_01v8_hvt L=150000 W=1000000
+ AS=140000000000 AD=140000000000 PS=1280000 PD=1280000
* device instance $7 r0 *1 3.055,1.985 sky130_fd_pr__pfet_01v8_hvt
XM$7 VPWR \$3 X VPB sky130_fd_pr__pfet_01v8_hvt L=150000 W=1000000
+ AS=140000000000 AD=140000000000 PS=1280000 PD=1280000
* device instance $8 r0 *1 3.485,1.985 sky130_fd_pr__pfet_01v8_hvt
XM$8 X \$3 VPWR VPB sky130_fd_pr__pfet_01v8_hvt L=150000 W=1000000
+ AS=140000000000 AD=140000000000 PS=1280000 PD=1280000
* device instance $9 r0 *1 3.915,1.985 sky130_fd_pr__pfet_01v8_hvt
XM$9 VPWR \$3 X VPB sky130_fd_pr__pfet_01v8_hvt L=150000 W=1000000
+ AS=140000000000 AD=140000000000 PS=1280000 PD=1280000
* device instance $10 r0 *1 4.345,1.985 sky130_fd_pr__pfet_01v8_hvt
XM$10 X \$3 VPWR VPB sky130_fd_pr__pfet_01v8_hvt L=150000 W=1000000
+ AS=140000000000 AD=140000000000 PS=1280000 PD=1280000
* device instance $11 r0 *1 4.775,1.985 sky130_fd_pr__pfet_01v8_hvt
XM$11 VPWR \$3 X VPB sky130_fd_pr__pfet_01v8_hvt L=150000 W=1000000
+ AS=140000000000 AD=140000000000 PS=1280000 PD=1280000
* device instance $12 r0 *1 5.205,1.985 sky130_fd_pr__pfet_01v8_hvt
XM$12 X \$3 VPWR VPB sky130_fd_pr__pfet_01v8_hvt L=150000 W=1000000
+ AS=140000000000 AD=137500000000 PS=1280000 PD=1275000
* device instance $13 r0 *1 5.63,1.985 sky130_fd_pr__pfet_01v8_hvt
XM$13 VPWR \$3 X VPB sky130_fd_pr__pfet_01v8_hvt L=150000 W=1000000
+ AS=137500000000 AD=140000000000 PS=1275000 PD=1280000
* device instance $14 r0 *1 6.06,1.985 sky130_fd_pr__pfet_01v8_hvt
XM$14 X \$3 VPWR VPB sky130_fd_pr__pfet_01v8_hvt L=150000 W=1000000
+ AS=140000000000 AD=140000000000 PS=1280000 PD=1280000
* device instance $15 r0 *1 6.49,1.985 sky130_fd_pr__pfet_01v8_hvt
XM$15 VPWR \$3 X VPB sky130_fd_pr__pfet_01v8_hvt L=150000 W=1000000
+ AS=140000000000 AD=140000000000 PS=1280000 PD=1280000
* device instance $16 r0 *1 6.92,1.985 sky130_fd_pr__pfet_01v8_hvt
XM$16 X \$3 VPWR VPB sky130_fd_pr__pfet_01v8_hvt L=150000 W=1000000
+ AS=140000000000 AD=140000000000 PS=1280000 PD=1280000
* device instance $17 r0 *1 7.35,1.985 sky130_fd_pr__pfet_01v8_hvt
XM$17 VPWR \$3 X VPB sky130_fd_pr__pfet_01v8_hvt L=150000 W=1000000
+ AS=140000000000 AD=140000000000 PS=1280000 PD=1280000
* device instance $18 r0 *1 7.78,1.985 sky130_fd_pr__pfet_01v8_hvt
XM$18 X \$3 VPWR VPB sky130_fd_pr__pfet_01v8_hvt L=150000 W=1000000
+ AS=140000000000 AD=140000000000 PS=1280000 PD=1280000
* device instance $19 r0 *1 8.21,1.985 sky130_fd_pr__pfet_01v8_hvt
XM$19 VPWR \$3 X VPB sky130_fd_pr__pfet_01v8_hvt L=150000 W=1000000
+ AS=140000000000 AD=140000000000 PS=1280000 PD=1280000
* device instance $20 r0 *1 8.64,1.985 sky130_fd_pr__pfet_01v8_hvt
XM$20 X \$3 VPWR VPB sky130_fd_pr__pfet_01v8_hvt L=150000 W=1000000
+ AS=140000000000 AD=265000000000 PS=1280000 PD=2530000
* device instance $21 r0 *1 0.475,0.445 sky130_fd_pr__nfet_01v8
XM$21 VGND A \$3 sky130_gnd sky130_fd_pr__nfet_01v8 L=150000 W=420000
+ AS=111300000000 AD=58800000000 PS=1370000 PD=700000
* device instance $22 r0 *1 0.905,0.445 sky130_fd_pr__nfet_01v8
XM$22 \$3 A VGND sky130_gnd sky130_fd_pr__nfet_01v8 L=150000 W=420000
+ AS=58800000000 AD=58800000000 PS=700000 PD=700000
* device instance $23 r0 *1 1.335,0.445 sky130_fd_pr__nfet_01v8
XM$23 VGND A \$3 sky130_gnd sky130_fd_pr__nfet_01v8 L=150000 W=420000
+ AS=58800000000 AD=58800000000 PS=700000 PD=700000
* device instance $24 r0 *1 1.765,0.445 sky130_fd_pr__nfet_01v8
XM$24 \$3 A VGND sky130_gnd sky130_fd_pr__nfet_01v8 L=150000 W=420000
+ AS=58800000000 AD=58800000000 PS=700000 PD=700000
* device instance $25 r0 *1 2.195,0.445 sky130_fd_pr__nfet_01v8
XM$25 VGND \$3 X sky130_gnd sky130_fd_pr__nfet_01v8 L=150000 W=420000
+ AS=58800000000 AD=58800000000 PS=700000 PD=700000
* device instance $26 r0 *1 2.625,0.445 sky130_fd_pr__nfet_01v8
XM$26 X \$3 VGND sky130_gnd sky130_fd_pr__nfet_01v8 L=150000 W=420000
+ AS=58800000000 AD=58800000000 PS=700000 PD=700000
* device instance $27 r0 *1 3.055,0.445 sky130_fd_pr__nfet_01v8
XM$27 VGND \$3 X sky130_gnd sky130_fd_pr__nfet_01v8 L=150000 W=420000
+ AS=58800000000 AD=58800000000 PS=700000 PD=700000
* device instance $28 r0 *1 3.485,0.445 sky130_fd_pr__nfet_01v8
XM$28 X \$3 VGND sky130_gnd sky130_fd_pr__nfet_01v8 L=150000 W=420000
+ AS=58800000000 AD=58800000000 PS=700000 PD=700000
* device instance $29 r0 *1 3.915,0.445 sky130_fd_pr__nfet_01v8
XM$29 VGND \$3 X sky130_gnd sky130_fd_pr__nfet_01v8 L=150000 W=420000
+ AS=58800000000 AD=58800000000 PS=700000 PD=700000
* device instance $30 r0 *1 4.345,0.445 sky130_fd_pr__nfet_01v8
XM$30 X \$3 VGND sky130_gnd sky130_fd_pr__nfet_01v8 L=150000 W=420000
+ AS=58800000000 AD=58800000000 PS=700000 PD=700000
* device instance $31 r0 *1 4.775,0.445 sky130_fd_pr__nfet_01v8
XM$31 VGND \$3 X sky130_gnd sky130_fd_pr__nfet_01v8 L=150000 W=420000
+ AS=58800000000 AD=58800000000 PS=700000 PD=700000
* device instance $32 r0 *1 5.205,0.445 sky130_fd_pr__nfet_01v8
XM$32 X \$3 VGND sky130_gnd sky130_fd_pr__nfet_01v8 L=150000 W=420000
+ AS=58800000000 AD=57750000000 PS=700000 PD=695000
* device instance $33 r0 *1 5.63,0.445 sky130_fd_pr__nfet_01v8
XM$33 VGND \$3 X sky130_gnd sky130_fd_pr__nfet_01v8 L=150000 W=420000
+ AS=57750000000 AD=58800000000 PS=695000 PD=700000
* device instance $34 r0 *1 6.06,0.445 sky130_fd_pr__nfet_01v8
XM$34 X \$3 VGND sky130_gnd sky130_fd_pr__nfet_01v8 L=150000 W=420000
+ AS=58800000000 AD=58800000000 PS=700000 PD=700000
* device instance $35 r0 *1 6.49,0.445 sky130_fd_pr__nfet_01v8
XM$35 VGND \$3 X sky130_gnd sky130_fd_pr__nfet_01v8 L=150000 W=420000
+ AS=58800000000 AD=58800000000 PS=700000 PD=700000
* device instance $36 r0 *1 6.92,0.445 sky130_fd_pr__nfet_01v8
XM$36 X \$3 VGND sky130_gnd sky130_fd_pr__nfet_01v8 L=150000 W=420000
+ AS=58800000000 AD=58800000000 PS=700000 PD=700000
* device instance $37 r0 *1 7.35,0.445 sky130_fd_pr__nfet_01v8
XM$37 VGND \$3 X sky130_gnd sky130_fd_pr__nfet_01v8 L=150000 W=420000
+ AS=58800000000 AD=58800000000 PS=700000 PD=700000
* device instance $38 r0 *1 7.78,0.445 sky130_fd_pr__nfet_01v8
XM$38 X \$3 VGND sky130_gnd sky130_fd_pr__nfet_01v8 L=150000 W=420000
+ AS=58800000000 AD=58800000000 PS=700000 PD=700000
* device instance $39 r0 *1 8.21,0.445 sky130_fd_pr__nfet_01v8
XM$39 VGND \$3 X sky130_gnd sky130_fd_pr__nfet_01v8 L=150000 W=420000
+ AS=58800000000 AD=58800000000 PS=700000 PD=700000
* device instance $40 r0 *1 8.64,0.445 sky130_fd_pr__nfet_01v8
XM$40 X \$3 VGND sky130_gnd sky130_fd_pr__nfet_01v8 L=150000 W=420000
+ AS=58800000000 AD=111300000000 PS=700000 PD=1370000
.ENDS sky130_fd_sc_hd__clkbuf_16

* cell sky130_fd_sc_hd__and2b_2
* pin VPB
* pin A_N
* pin VPWR
* pin B
* pin VGND
* pin X
* pin sky130_gnd
.SUBCKT sky130_fd_sc_hd__and2b_2 VPB A_N VPWR B VGND X sky130_gnd
* device instance $1 r0 *1 0.47,2.275 sky130_fd_pr__pfet_01v8_hvt
XM$1 \$4 A_N VPWR VPB sky130_fd_pr__pfet_01v8_hvt L=150000 W=420000
+ AS=109200000000 AD=76650000000 PS=1360000 PD=785000
* device instance $2 r0 *1 0.985,2.275 sky130_fd_pr__pfet_01v8_hvt
XM$2 VPWR \$4 \$5 VPB sky130_fd_pr__pfet_01v8_hvt L=150000 W=420000
+ AS=76650000000 AD=60900000000 PS=785000 PD=710000
* device instance $3 r0 *1 1.425,2.275 sky130_fd_pr__pfet_01v8_hvt
XM$3 VPWR B \$5 VPB sky130_fd_pr__pfet_01v8_hvt L=150000 W=420000
+ AS=228950000000 AD=60900000000 PS=1745000 PD=710000
* device instance $4 r0 *1 2.32,1.985 sky130_fd_pr__pfet_01v8_hvt
XM$4 VPWR \$5 X VPB sky130_fd_pr__pfet_01v8_hvt L=150000 W=1000000
+ AS=228950000000 AD=135000000000 PS=1745000 PD=1270000
* device instance $5 r0 *1 2.74,1.985 sky130_fd_pr__pfet_01v8_hvt
XM$5 X \$5 VPWR VPB sky130_fd_pr__pfet_01v8_hvt L=150000 W=1000000
+ AS=135000000000 AD=260000000000 PS=1270000 PD=2520000
* device instance $6 r0 *1 1.41,0.445 sky130_fd_pr__nfet_01v8
XM$6 \$5 \$4 \$10 sky130_gnd sky130_fd_pr__nfet_01v8 L=150000 W=420000
+ AS=109200000000 AD=56700000000 PS=1360000 PD=690000
* device instance $7 r0 *1 1.83,0.445 sky130_fd_pr__nfet_01v8
XM$7 \$10 B VGND sky130_gnd sky130_fd_pr__nfet_01v8 L=150000 W=420000
+ AS=56700000000 AD=101875000000 PS=690000 PD=990000
* device instance $8 r0 *1 2.32,0.56 sky130_fd_pr__nfet_01v8
XM$8 VGND \$5 X sky130_gnd sky130_fd_pr__nfet_01v8 L=150000 W=650000
+ AS=101875000000 AD=87750000000 PS=990000 PD=920000
* device instance $9 r0 *1 2.74,0.56 sky130_fd_pr__nfet_01v8
XM$9 X \$5 VGND sky130_gnd sky130_fd_pr__nfet_01v8 L=150000 W=650000
+ AS=87750000000 AD=175500000000 PS=920000 PD=1840000
* device instance $10 r0 *1 0.47,0.445 sky130_fd_pr__nfet_01v8
XM$10 VGND A_N \$4 sky130_gnd sky130_fd_pr__nfet_01v8 L=150000 W=420000
+ AS=109200000000 AD=109200000000 PS=1360000 PD=1360000
.ENDS sky130_fd_sc_hd__and2b_2

* cell sky130_fd_sc_hd__and4bb_2
* pin VGND
* pin X
* pin C
* pin D
* pin B_N
* pin A_N
* pin VPWR
* pin VPB
* pin sky130_gnd
.SUBCKT sky130_fd_sc_hd__and4bb_2 VGND X C D B_N A_N VPWR VPB sky130_gnd
* device instance $1 r0 *1 0.47,2.275 sky130_fd_pr__pfet_01v8_hvt
XM$1 VPWR A_N \$3 VPB sky130_fd_pr__pfet_01v8_hvt L=150000 W=420000
+ AS=140750000000 AD=109200000000 PS=1325000 PD=1360000
* device instance $2 r0 *1 0.945,1.985 sky130_fd_pr__pfet_01v8_hvt
XM$2 VPWR \$5 X VPB sky130_fd_pr__pfet_01v8_hvt L=150000 W=1000000
+ AS=140750000000 AD=135000000000 PS=1325000 PD=1270000
* device instance $3 r0 *1 1.365,1.985 sky130_fd_pr__pfet_01v8_hvt
XM$3 X \$5 VPWR VPB sky130_fd_pr__pfet_01v8_hvt L=150000 W=1000000
+ AS=135000000000 AD=330750000000 PS=1270000 PD=1705000
* device instance $4 r0 *1 2.22,2.275 sky130_fd_pr__pfet_01v8_hvt
XM$4 VPWR \$3 \$5 VPB sky130_fd_pr__pfet_01v8_hvt L=150000 W=420000
+ AS=330750000000 AD=67200000000 PS=1705000 PD=740000
* device instance $5 r0 *1 2.69,2.275 sky130_fd_pr__pfet_01v8_hvt
XM$5 \$5 \$13 VPWR VPB sky130_fd_pr__pfet_01v8_hvt L=150000 W=420000
+ AS=67200000000 AD=58800000000 PS=740000 PD=700000
* device instance $6 r0 *1 3.12,2.275 sky130_fd_pr__pfet_01v8_hvt
XM$6 VPWR C \$5 VPB sky130_fd_pr__pfet_01v8_hvt L=150000 W=420000
+ AS=58800000000 AD=56700000000 PS=700000 PD=690000
* device instance $7 r0 *1 3.54,2.275 sky130_fd_pr__pfet_01v8_hvt
XM$7 \$5 D VPWR VPB sky130_fd_pr__pfet_01v8_hvt L=150000 W=420000
+ AS=56700000000 AD=92400000000 PS=690000 PD=860000
* device instance $8 r0 *1 4.13,2.275 sky130_fd_pr__pfet_01v8_hvt
XM$8 VPWR B_N \$13 VPB sky130_fd_pr__pfet_01v8_hvt L=150000 W=420000
+ AS=92400000000 AD=109200000000 PS=860000 PD=1360000
* device instance $9 r0 *1 2.305,0.445 sky130_fd_pr__nfet_01v8
XM$9 \$5 \$3 \$10 sky130_gnd sky130_fd_pr__nfet_01v8 L=150000 W=420000
+ AS=109200000000 AD=44100000000 PS=1360000 PD=630000
* device instance $10 r0 *1 2.665,0.445 sky130_fd_pr__nfet_01v8
XM$10 \$10 \$13 \$11 sky130_gnd sky130_fd_pr__nfet_01v8 L=150000 W=420000
+ AS=44100000000 AD=64050000000 PS=630000 PD=725000
* device instance $11 r0 *1 3.12,0.445 sky130_fd_pr__nfet_01v8
XM$11 \$11 C \$9 sky130_gnd sky130_fd_pr__nfet_01v8 L=150000 W=420000
+ AS=64050000000 AD=56700000000 PS=725000 PD=690000
* device instance $12 r0 *1 3.54,0.445 sky130_fd_pr__nfet_01v8
XM$12 \$9 D VGND sky130_gnd sky130_fd_pr__nfet_01v8 L=150000 W=420000
+ AS=56700000000 AD=92400000000 PS=690000 PD=860000
* device instance $13 r0 *1 4.13,0.445 sky130_fd_pr__nfet_01v8
XM$13 VGND B_N \$13 sky130_gnd sky130_fd_pr__nfet_01v8 L=150000 W=420000
+ AS=92400000000 AD=109200000000 PS=860000 PD=1360000
* device instance $14 r0 *1 0.47,0.445 sky130_fd_pr__nfet_01v8
XM$14 \$3 A_N VGND sky130_gnd sky130_fd_pr__nfet_01v8 L=150000 W=420000
+ AS=109200000000 AD=97000000000 PS=1360000 PD=975000
* device instance $15 r0 *1 0.945,0.56 sky130_fd_pr__nfet_01v8
XM$15 VGND \$5 X sky130_gnd sky130_fd_pr__nfet_01v8 L=150000 W=650000
+ AS=97000000000 AD=87750000000 PS=975000 PD=920000
* device instance $16 r0 *1 1.365,0.56 sky130_fd_pr__nfet_01v8
XM$16 X \$5 VGND sky130_gnd sky130_fd_pr__nfet_01v8 L=150000 W=650000
+ AS=87750000000 AD=169000000000 PS=920000 PD=1820000
.ENDS sky130_fd_sc_hd__and4bb_2

* cell sky130_fd_sc_hd__nor3_2
* pin VPB
* pin C
* pin Y
* pin VGND
* pin A
* pin VPWR
* pin B
* pin sky130_gnd
.SUBCKT sky130_fd_sc_hd__nor3_2 VPB C Y VGND A VPWR B sky130_gnd
* device instance $1 r0 *1 2.71,1.985 sky130_fd_pr__pfet_01v8_hvt
XM$1 \$3 C Y VPB sky130_fd_pr__pfet_01v8_hvt L=150000 W=1000000 AS=260000000000
+ AD=135000000000 PS=2520000 PD=1270000
* device instance $2 r0 *1 3.13,1.985 sky130_fd_pr__pfet_01v8_hvt
XM$2 Y C \$3 VPB sky130_fd_pr__pfet_01v8_hvt L=150000 W=1000000 AS=135000000000
+ AD=260000000000 PS=1270000 PD=2520000
* device instance $3 r0 *1 0.49,1.985 sky130_fd_pr__pfet_01v8_hvt
XM$3 \$2 A VPWR VPB sky130_fd_pr__pfet_01v8_hvt L=150000 W=1000000
+ AS=280000000000 AD=135000000000 PS=2560000 PD=1270000
* device instance $4 r0 *1 0.91,1.985 sky130_fd_pr__pfet_01v8_hvt
XM$4 VPWR A \$2 VPB sky130_fd_pr__pfet_01v8_hvt L=150000 W=1000000
+ AS=135000000000 AD=135000000000 PS=1270000 PD=1270000
* device instance $5 r0 *1 1.33,1.985 sky130_fd_pr__pfet_01v8_hvt
XM$5 \$2 B \$3 VPB sky130_fd_pr__pfet_01v8_hvt L=150000 W=1000000
+ AS=135000000000 AD=135000000000 PS=1270000 PD=1270000
* device instance $6 r0 *1 1.75,1.985 sky130_fd_pr__pfet_01v8_hvt
XM$6 \$3 B \$2 VPB sky130_fd_pr__pfet_01v8_hvt L=150000 W=1000000
+ AS=135000000000 AD=280000000000 PS=1270000 PD=2560000
* device instance $7 r0 *1 2.71,0.56 sky130_fd_pr__nfet_01v8
XM$7 VGND C Y sky130_gnd sky130_fd_pr__nfet_01v8 L=150000 W=650000
+ AS=169000000000 AD=87750000000 PS=1820000 PD=920000
* device instance $8 r0 *1 3.13,0.56 sky130_fd_pr__nfet_01v8
XM$8 Y C VGND sky130_gnd sky130_fd_pr__nfet_01v8 L=150000 W=650000
+ AS=87750000000 AD=169000000000 PS=920000 PD=1820000
* device instance $9 r0 *1 0.49,0.56 sky130_fd_pr__nfet_01v8
XM$9 VGND A Y sky130_gnd sky130_fd_pr__nfet_01v8 L=150000 W=650000
+ AS=178750000000 AD=87750000000 PS=1850000 PD=920000
* device instance $10 r0 *1 0.91,0.56 sky130_fd_pr__nfet_01v8
XM$10 Y A VGND sky130_gnd sky130_fd_pr__nfet_01v8 L=150000 W=650000
+ AS=87750000000 AD=87750000000 PS=920000 PD=920000
* device instance $11 r0 *1 1.33,0.56 sky130_fd_pr__nfet_01v8
XM$11 VGND B Y sky130_gnd sky130_fd_pr__nfet_01v8 L=150000 W=650000
+ AS=87750000000 AD=87750000000 PS=920000 PD=920000
* device instance $12 r0 *1 1.75,0.56 sky130_fd_pr__nfet_01v8
XM$12 Y B VGND sky130_gnd sky130_fd_pr__nfet_01v8 L=150000 W=650000
+ AS=87750000000 AD=169000000000 PS=920000 PD=1820000
.ENDS sky130_fd_sc_hd__nor3_2

* cell sky130_fd_sc_hd__nor3b_2
* pin VGND
* pin Y
* pin A
* pin B
* pin C_N
* pin VPWR
* pin VPB
* pin sky130_gnd
.SUBCKT sky130_fd_sc_hd__nor3b_2 VGND Y A B C_N VPWR VPB sky130_gnd
* device instance $1 r0 *1 2.73,1.985 sky130_fd_pr__pfet_01v8_hvt
XM$1 \$10 \$6 Y VPB sky130_fd_pr__pfet_01v8_hvt L=150000 W=1000000
+ AS=280000000000 AD=135000000000 PS=2560000 PD=1270000
* device instance $2 r0 *1 3.15,1.985 sky130_fd_pr__pfet_01v8_hvt
XM$2 Y \$6 \$10 VPB sky130_fd_pr__pfet_01v8_hvt L=150000 W=1000000
+ AS=135000000000 AD=280000000000 PS=1270000 PD=2560000
* device instance $3 r0 *1 0.49,1.985 sky130_fd_pr__pfet_01v8_hvt
XM$3 \$8 A VPWR VPB sky130_fd_pr__pfet_01v8_hvt L=150000 W=1000000
+ AS=280000000000 AD=135000000000 PS=2560000 PD=1270000
* device instance $4 r0 *1 0.91,1.985 sky130_fd_pr__pfet_01v8_hvt
XM$4 VPWR A \$8 VPB sky130_fd_pr__pfet_01v8_hvt L=150000 W=1000000
+ AS=135000000000 AD=135000000000 PS=1270000 PD=1270000
* device instance $5 r0 *1 1.33,1.985 sky130_fd_pr__pfet_01v8_hvt
XM$5 \$8 B \$10 VPB sky130_fd_pr__pfet_01v8_hvt L=150000 W=1000000
+ AS=135000000000 AD=135000000000 PS=1270000 PD=1270000
* device instance $6 r0 *1 1.75,1.985 sky130_fd_pr__pfet_01v8_hvt
XM$6 \$10 B \$8 VPB sky130_fd_pr__pfet_01v8_hvt L=150000 W=1000000
+ AS=135000000000 AD=280000000000 PS=1270000 PD=2560000
* device instance $7 r0 *1 4.13,1.695 sky130_fd_pr__pfet_01v8_hvt
XM$7 \$6 C_N VPWR VPB sky130_fd_pr__pfet_01v8_hvt L=150000 W=420000
+ AS=109200000000 AD=109200000000 PS=1360000 PD=1360000
* device instance $8 r0 *1 4.13,0.675 sky130_fd_pr__nfet_01v8
XM$8 \$6 C_N VGND sky130_gnd sky130_fd_pr__nfet_01v8 L=150000 W=420000
+ AS=109200000000 AD=109200000000 PS=1360000 PD=1360000
* device instance $9 r0 *1 2.73,0.56 sky130_fd_pr__nfet_01v8
XM$9 VGND \$6 Y sky130_gnd sky130_fd_pr__nfet_01v8 L=150000 W=650000
+ AS=169000000000 AD=87750000000 PS=1820000 PD=920000
* device instance $10 r0 *1 3.15,0.56 sky130_fd_pr__nfet_01v8
XM$10 Y \$6 VGND sky130_gnd sky130_fd_pr__nfet_01v8 L=150000 W=650000
+ AS=87750000000 AD=182000000000 PS=920000 PD=1860000
* device instance $11 r0 *1 0.49,0.56 sky130_fd_pr__nfet_01v8
XM$11 VGND A Y sky130_gnd sky130_fd_pr__nfet_01v8 L=150000 W=650000
+ AS=182000000000 AD=87750000000 PS=1860000 PD=920000
* device instance $12 r0 *1 0.91,0.56 sky130_fd_pr__nfet_01v8
XM$12 Y A VGND sky130_gnd sky130_fd_pr__nfet_01v8 L=150000 W=650000
+ AS=87750000000 AD=87750000000 PS=920000 PD=920000
* device instance $13 r0 *1 1.33,0.56 sky130_fd_pr__nfet_01v8
XM$13 VGND B Y sky130_gnd sky130_fd_pr__nfet_01v8 L=150000 W=650000
+ AS=87750000000 AD=87750000000 PS=920000 PD=920000
* device instance $14 r0 *1 1.75,0.56 sky130_fd_pr__nfet_01v8
XM$14 Y B VGND sky130_gnd sky130_fd_pr__nfet_01v8 L=150000 W=650000
+ AS=87750000000 AD=169000000000 PS=920000 PD=1820000
.ENDS sky130_fd_sc_hd__nor3b_2

* cell VIA_M3M4_PR
* pin
.SUBCKT VIA_M3M4_PR \$1
.ENDS VIA_M3M4_PR

* cell sky130_fd_sc_hd__o211a_2
* pin VPB
* pin C1
* pin VPWR
* pin B1
* pin VGND
* pin A2
* pin A1
* pin X
* pin sky130_gnd
.SUBCKT sky130_fd_sc_hd__o211a_2 VPB C1 VPWR B1 VGND A2 A1 X sky130_gnd
* device instance $1 r0 *1 0.475,1.985 sky130_fd_pr__pfet_01v8_hvt
XM$1 \$2 C1 VPWR VPB sky130_fd_pr__pfet_01v8_hvt L=150000 W=1000000
+ AS=265000000000 AD=140000000000 PS=2530000 PD=1280000
* device instance $2 r0 *1 0.905,1.985 sky130_fd_pr__pfet_01v8_hvt
XM$2 VPWR B1 \$2 VPB sky130_fd_pr__pfet_01v8_hvt L=150000 W=1000000
+ AS=140000000000 AD=367500000000 PS=1280000 PD=1735000
* device instance $3 r0 *1 1.79,1.985 sky130_fd_pr__pfet_01v8_hvt
XM$3 \$2 A2 \$13 VPB sky130_fd_pr__pfet_01v8_hvt L=150000 W=1000000
+ AS=367500000000 AD=105000000000 PS=1735000 PD=1210000
* device instance $4 r0 *1 2.15,1.985 sky130_fd_pr__pfet_01v8_hvt
XM$4 \$13 A1 VPWR VPB sky130_fd_pr__pfet_01v8_hvt L=150000 W=1000000
+ AS=105000000000 AD=195000000000 PS=1210000 PD=1390000
* device instance $5 r0 *1 2.69,1.985 sky130_fd_pr__pfet_01v8_hvt
XM$5 VPWR \$2 X VPB sky130_fd_pr__pfet_01v8_hvt L=150000 W=1000000
+ AS=195000000000 AD=140000000000 PS=1390000 PD=1280000
* device instance $6 r0 *1 3.12,1.985 sky130_fd_pr__pfet_01v8_hvt
XM$6 X \$2 VPWR VPB sky130_fd_pr__pfet_01v8_hvt L=150000 W=1000000
+ AS=140000000000 AD=265000000000 PS=1280000 PD=2530000
* device instance $7 r0 *1 1.77,0.56 sky130_fd_pr__nfet_01v8
XM$7 VGND A2 \$6 sky130_gnd sky130_fd_pr__nfet_01v8 L=150000 W=650000
+ AS=165350000000 AD=91000000000 PS=1820000 PD=930000
* device instance $8 r0 *1 2.2,0.56 sky130_fd_pr__nfet_01v8
XM$8 \$6 A1 VGND sky130_gnd sky130_fd_pr__nfet_01v8 L=150000 W=650000
+ AS=91000000000 AD=104000000000 PS=930000 PD=970000
* device instance $9 r0 *1 2.67,0.56 sky130_fd_pr__nfet_01v8
XM$9 VGND \$2 X sky130_gnd sky130_fd_pr__nfet_01v8 L=150000 W=650000
+ AS=104000000000 AD=91000000000 PS=970000 PD=930000
* device instance $10 r0 *1 3.1,0.56 sky130_fd_pr__nfet_01v8
XM$10 X \$2 VGND sky130_gnd sky130_fd_pr__nfet_01v8 L=150000 W=650000
+ AS=91000000000 AD=230750000000 PS=930000 PD=2010000
* device instance $11 r0 *1 0.475,0.56 sky130_fd_pr__nfet_01v8
XM$11 \$2 C1 \$12 sky130_gnd sky130_fd_pr__nfet_01v8 L=150000 W=650000
+ AS=172250000000 AD=68250000000 PS=1830000 PD=860000
* device instance $12 r0 *1 0.835,0.56 sky130_fd_pr__nfet_01v8
XM$12 \$12 B1 \$6 sky130_gnd sky130_fd_pr__nfet_01v8 L=150000 W=650000
+ AS=68250000000 AD=165350000000 PS=860000 PD=1820000
.ENDS sky130_fd_sc_hd__o211a_2

* cell sky130_fd_sc_hd__or3_2
* pin VPB
* pin C
* pin VPWR
* pin VGND
* pin X
* pin A
* pin B
* pin sky130_gnd
.SUBCKT sky130_fd_sc_hd__or3_2 VPB C VPWR VGND X A B sky130_gnd
* device instance $1 r0 *1 0.485,1.695 sky130_fd_pr__pfet_01v8_hvt
XM$1 \$7 C \$11 VPB sky130_fd_pr__pfet_01v8_hvt L=150000 W=420000
+ AS=109200000000 AD=44100000000 PS=1360000 PD=630000
* device instance $2 r0 *1 0.845,1.695 sky130_fd_pr__pfet_01v8_hvt
XM$2 \$11 B \$10 VPB sky130_fd_pr__pfet_01v8_hvt L=150000 W=420000
+ AS=44100000000 AD=69300000000 PS=630000 PD=750000
* device instance $3 r0 *1 1.325,1.695 sky130_fd_pr__pfet_01v8_hvt
XM$3 \$10 A VPWR VPB sky130_fd_pr__pfet_01v8_hvt L=150000 W=420000
+ AS=69300000000 AD=148250000000 PS=750000 PD=1340000
* device instance $4 r0 *1 1.815,1.985 sky130_fd_pr__pfet_01v8_hvt
XM$4 VPWR \$7 X VPB sky130_fd_pr__pfet_01v8_hvt L=150000 W=1000000
+ AS=148250000000 AD=135000000000 PS=1340000 PD=1270000
* device instance $5 r0 *1 2.235,1.985 sky130_fd_pr__pfet_01v8_hvt
XM$5 X \$7 VPWR VPB sky130_fd_pr__pfet_01v8_hvt L=150000 W=1000000
+ AS=135000000000 AD=315000000000 PS=1270000 PD=2630000
* device instance $6 r0 *1 0.485,0.475 sky130_fd_pr__nfet_01v8
XM$6 \$7 C VGND sky130_gnd sky130_fd_pr__nfet_01v8 L=150000 W=420000
+ AS=109200000000 AD=56700000000 PS=1360000 PD=690000
* device instance $7 r0 *1 0.905,0.475 sky130_fd_pr__nfet_01v8
XM$7 VGND B \$7 sky130_gnd sky130_fd_pr__nfet_01v8 L=150000 W=420000
+ AS=56700000000 AD=56700000000 PS=690000 PD=690000
* device instance $8 r0 *1 1.325,0.475 sky130_fd_pr__nfet_01v8
XM$8 VGND A \$7 sky130_gnd sky130_fd_pr__nfet_01v8 L=150000 W=420000
+ AS=101875000000 AD=56700000000 PS=990000 PD=690000
* device instance $9 r0 *1 1.815,0.56 sky130_fd_pr__nfet_01v8
XM$9 VGND \$7 X sky130_gnd sky130_fd_pr__nfet_01v8 L=150000 W=650000
+ AS=101875000000 AD=87750000000 PS=990000 PD=920000
* device instance $10 r0 *1 2.235,0.56 sky130_fd_pr__nfet_01v8
XM$10 X \$7 VGND sky130_gnd sky130_fd_pr__nfet_01v8 L=150000 W=650000
+ AS=87750000000 AD=185250000000 PS=920000 PD=1870000
.ENDS sky130_fd_sc_hd__or3_2

* cell sky130_fd_sc_hd__or4b_2
* pin VPB
* pin
* pin VGND
* pin C
* pin B
* pin A
* pin VPWR
* pin X
* pin
* pin D_N
* pin
* pin
* pin
* pin sky130_gnd
.SUBCKT sky130_fd_sc_hd__or4b_2 VPB \$2 VGND C B A VPWR X \$9 D_N \$12 \$13
+ \$14 sky130_gnd
* device instance $1 r0 *1 0.47,0.475 sky130_fd_pr__nfet_01v8
XM$1 VGND D_N \$9 sky130_gnd sky130_fd_pr__nfet_01v8 L=150000 W=420000
+ AS=100250000000 AD=109200000000 PS=985000 PD=1360000
* device instance $2 r0 *1 1.86,0.475 sky130_fd_pr__nfet_01v8
XM$2 VGND A \$2 sky130_gnd sky130_fd_pr__nfet_01v8 L=150000 W=420000
+ AS=100250000000 AD=69300000000 PS=985000 PD=750000
* device instance $3 r0 *1 2.34,0.475 sky130_fd_pr__nfet_01v8
XM$3 \$2 B VGND sky130_gnd sky130_fd_pr__nfet_01v8 L=150000 W=420000
+ AS=69300000000 AD=56700000000 PS=750000 PD=690000
* device instance $4 r0 *1 2.76,0.475 sky130_fd_pr__nfet_01v8
XM$4 VGND C \$2 sky130_gnd sky130_fd_pr__nfet_01v8 L=150000 W=420000
+ AS=56700000000 AD=56700000000 PS=690000 PD=690000
* device instance $5 r0 *1 3.18,0.475 sky130_fd_pr__nfet_01v8
XM$5 \$2 \$9 VGND sky130_gnd sky130_fd_pr__nfet_01v8 L=150000 W=420000
+ AS=56700000000 AD=109200000000 PS=690000 PD=1360000
* device instance $6 r0 *1 0.955,0.56 sky130_fd_pr__nfet_01v8
XM$6 VGND \$2 X sky130_gnd sky130_fd_pr__nfet_01v8 L=150000 W=650000
+ AS=100250000000 AD=87750000000 PS=985000 PD=920000
* device instance $7 r0 *1 1.375,0.56 sky130_fd_pr__nfet_01v8
XM$7 X \$2 VGND sky130_gnd sky130_fd_pr__nfet_01v8 L=150000 W=650000
+ AS=87750000000 AD=100250000000 PS=920000 PD=985000
.ENDS sky130_fd_sc_hd__or4b_2

* cell sky130_fd_sc_hd__nor2_2
* pin VPB
* pin VGND
* pin A
* pin VPWR
* pin Y
* pin B
* pin sky130_gnd
.SUBCKT sky130_fd_sc_hd__nor2_2 VPB VGND A VPWR Y B sky130_gnd
* device instance $1 r0 *1 0.49,1.985 sky130_fd_pr__pfet_01v8_hvt
XM$1 \$3 A VPWR VPB sky130_fd_pr__pfet_01v8_hvt L=150000 W=1000000
+ AS=280000000000 AD=135000000000 PS=2560000 PD=1270000
* device instance $2 r0 *1 0.91,1.985 sky130_fd_pr__pfet_01v8_hvt
XM$2 VPWR A \$3 VPB sky130_fd_pr__pfet_01v8_hvt L=150000 W=1000000
+ AS=135000000000 AD=135000000000 PS=1270000 PD=1270000
* device instance $3 r0 *1 1.33,1.985 sky130_fd_pr__pfet_01v8_hvt
XM$3 \$3 B Y VPB sky130_fd_pr__pfet_01v8_hvt L=150000 W=1000000 AS=135000000000
+ AD=135000000000 PS=1270000 PD=1270000
* device instance $4 r0 *1 1.75,1.985 sky130_fd_pr__pfet_01v8_hvt
XM$4 Y B \$3 VPB sky130_fd_pr__pfet_01v8_hvt L=150000 W=1000000 AS=135000000000
+ AD=260000000000 PS=1270000 PD=2520000
* device instance $5 r0 *1 0.49,0.56 sky130_fd_pr__nfet_01v8
XM$5 VGND A Y sky130_gnd sky130_fd_pr__nfet_01v8 L=150000 W=650000
+ AS=182000000000 AD=87750000000 PS=1860000 PD=920000
* device instance $6 r0 *1 0.91,0.56 sky130_fd_pr__nfet_01v8
XM$6 Y A VGND sky130_gnd sky130_fd_pr__nfet_01v8 L=150000 W=650000
+ AS=87750000000 AD=87750000000 PS=920000 PD=920000
* device instance $7 r0 *1 1.33,0.56 sky130_fd_pr__nfet_01v8
XM$7 VGND B Y sky130_gnd sky130_fd_pr__nfet_01v8 L=150000 W=650000
+ AS=87750000000 AD=87750000000 PS=920000 PD=920000
* device instance $8 r0 *1 1.75,0.56 sky130_fd_pr__nfet_01v8
XM$8 Y B VGND sky130_gnd sky130_fd_pr__nfet_01v8 L=150000 W=650000
+ AS=87750000000 AD=169000000000 PS=920000 PD=1820000
.ENDS sky130_fd_sc_hd__nor2_2

* cell sky130_fd_sc_hd__nand3_2
* pin VGND
* pin Y
* pin A
* pin B
* pin C
* pin VPWR
* pin VPB
* pin sky130_gnd
.SUBCKT sky130_fd_sc_hd__nand3_2 VGND Y A B C VPWR VPB sky130_gnd
* device instance $1 r0 *1 2.67,1.985 sky130_fd_pr__pfet_01v8_hvt
XM$1 VPWR C Y VPB sky130_fd_pr__pfet_01v8_hvt L=150000 W=1000000
+ AS=260000000000 AD=135000000000 PS=2520000 PD=1270000
* device instance $2 r0 *1 3.09,1.985 sky130_fd_pr__pfet_01v8_hvt
XM$2 Y C VPWR VPB sky130_fd_pr__pfet_01v8_hvt L=150000 W=1000000
+ AS=135000000000 AD=310000000000 PS=1270000 PD=2620000
* device instance $3 r0 *1 0.47,1.985 sky130_fd_pr__pfet_01v8_hvt
XM$3 VPWR A Y VPB sky130_fd_pr__pfet_01v8_hvt L=150000 W=1000000
+ AS=260000000000 AD=135000000000 PS=2520000 PD=1270000
* device instance $4 r0 *1 0.89,1.985 sky130_fd_pr__pfet_01v8_hvt
XM$4 Y A VPWR VPB sky130_fd_pr__pfet_01v8_hvt L=150000 W=1000000
+ AS=135000000000 AD=135000000000 PS=1270000 PD=1270000
* device instance $5 r0 *1 1.31,1.985 sky130_fd_pr__pfet_01v8_hvt
XM$5 VPWR B Y VPB sky130_fd_pr__pfet_01v8_hvt L=150000 W=1000000
+ AS=135000000000 AD=135000000000 PS=1270000 PD=1270000
* device instance $6 r0 *1 1.73,1.985 sky130_fd_pr__pfet_01v8_hvt
XM$6 Y B VPWR VPB sky130_fd_pr__pfet_01v8_hvt L=150000 W=1000000
+ AS=135000000000 AD=260000000000 PS=1270000 PD=2520000
* device instance $7 r0 *1 2.67,0.56 sky130_fd_pr__nfet_01v8
XM$7 VGND C \$5 sky130_gnd sky130_fd_pr__nfet_01v8 L=150000 W=650000
+ AS=169000000000 AD=87750000000 PS=1820000 PD=920000
* device instance $8 r0 *1 3.09,0.56 sky130_fd_pr__nfet_01v8
XM$8 \$5 C VGND sky130_gnd sky130_fd_pr__nfet_01v8 L=150000 W=650000
+ AS=87750000000 AD=201500000000 PS=920000 PD=1920000
* device instance $9 r0 *1 0.47,0.56 sky130_fd_pr__nfet_01v8
XM$9 \$3 A Y sky130_gnd sky130_fd_pr__nfet_01v8 L=150000 W=650000
+ AS=169000000000 AD=87750000000 PS=1820000 PD=920000
* device instance $10 r0 *1 0.89,0.56 sky130_fd_pr__nfet_01v8
XM$10 Y A \$3 sky130_gnd sky130_fd_pr__nfet_01v8 L=150000 W=650000
+ AS=87750000000 AD=87750000000 PS=920000 PD=920000
* device instance $11 r0 *1 1.31,0.56 sky130_fd_pr__nfet_01v8
XM$11 \$3 B \$5 sky130_gnd sky130_fd_pr__nfet_01v8 L=150000 W=650000
+ AS=87750000000 AD=87750000000 PS=920000 PD=920000
* device instance $12 r0 *1 1.73,0.56 sky130_fd_pr__nfet_01v8
XM$12 \$5 B \$3 sky130_gnd sky130_fd_pr__nfet_01v8 L=150000 W=650000
+ AS=87750000000 AD=169000000000 PS=920000 PD=1820000
.ENDS sky130_fd_sc_hd__nand3_2

* cell sky130_fd_sc_hd__and4b_2
* pin VGND
* pin B
* pin C
* pin X
* pin A_N
* pin D
* pin VPWR
* pin VPB
* pin sky130_gnd
.SUBCKT sky130_fd_sc_hd__and4b_2 VGND B C X A_N D VPWR VPB sky130_gnd
* device instance $1 r0 *1 0.47,2.275 sky130_fd_pr__pfet_01v8_hvt
XM$1 \$3 A_N VPWR VPB sky130_fd_pr__pfet_01v8_hvt L=150000 W=420000
+ AS=109200000000 AD=56700000000 PS=1360000 PD=690000
* device instance $2 r0 *1 0.89,2.275 sky130_fd_pr__pfet_01v8_hvt
XM$2 VPWR \$3 \$4 VPB sky130_fd_pr__pfet_01v8_hvt L=150000 W=420000
+ AS=56700000000 AD=98700000000 PS=690000 PD=890000
* device instance $3 r0 *1 1.51,2.275 sky130_fd_pr__pfet_01v8_hvt
XM$3 \$4 B VPWR VPB sky130_fd_pr__pfet_01v8_hvt L=150000 W=420000
+ AS=98700000000 AD=128100000000 PS=890000 PD=1030000
* device instance $4 r0 *1 2.27,2.275 sky130_fd_pr__pfet_01v8_hvt
XM$4 VPWR C \$4 VPB sky130_fd_pr__pfet_01v8_hvt L=150000 W=420000
+ AS=128100000000 AD=66150000000 PS=1030000 PD=735000
* device instance $5 r0 *1 2.735,2.275 sky130_fd_pr__pfet_01v8_hvt
XM$5 VPWR D \$4 VPB sky130_fd_pr__pfet_01v8_hvt L=150000 W=420000
+ AS=143250000000 AD=66150000000 PS=1330000 PD=735000
* device instance $6 r0 *1 3.215,1.985 sky130_fd_pr__pfet_01v8_hvt
XM$6 VPWR \$4 X VPB sky130_fd_pr__pfet_01v8_hvt L=150000 W=1000000
+ AS=143250000000 AD=152500000000 PS=1330000 PD=1305000
* device instance $7 r0 *1 3.67,1.985 sky130_fd_pr__pfet_01v8_hvt
XM$7 X \$4 VPWR VPB sky130_fd_pr__pfet_01v8_hvt L=150000 W=1000000
+ AS=152500000000 AD=260000000000 PS=1305000 PD=2520000
* device instance $8 r0 *1 1.41,0.445 sky130_fd_pr__nfet_01v8
XM$8 \$4 \$3 \$9 sky130_gnd sky130_fd_pr__nfet_01v8 L=150000 W=420000
+ AS=109200000000 AD=44100000000 PS=1360000 PD=630000
* device instance $9 r0 *1 1.77,0.445 sky130_fd_pr__nfet_01v8
XM$9 \$9 B \$10 sky130_gnd sky130_fd_pr__nfet_01v8 L=150000 W=420000
+ AS=44100000000 AD=73500000000 PS=630000 PD=770000
* device instance $10 r0 *1 2.27,0.445 sky130_fd_pr__nfet_01v8
XM$10 \$10 C \$8 sky130_gnd sky130_fd_pr__nfet_01v8 L=150000 W=420000
+ AS=73500000000 AD=61950000000 PS=770000 PD=715000
* device instance $11 r0 *1 2.715,0.445 sky130_fd_pr__nfet_01v8
XM$11 \$8 D VGND sky130_gnd sky130_fd_pr__nfet_01v8 L=150000 W=420000
+ AS=61950000000 AD=103975000000 PS=715000 PD=1000000
* device instance $12 r0 *1 3.215,0.56 sky130_fd_pr__nfet_01v8
XM$12 VGND \$4 X sky130_gnd sky130_fd_pr__nfet_01v8 L=150000 W=650000
+ AS=103975000000 AD=99125000000 PS=1000000 PD=955000
* device instance $13 r0 *1 3.67,0.56 sky130_fd_pr__nfet_01v8
XM$13 X \$4 VGND sky130_gnd sky130_fd_pr__nfet_01v8 L=150000 W=650000
+ AS=99125000000 AD=169000000000 PS=955000 PD=1820000
* device instance $14 r0 *1 0.47,0.445 sky130_fd_pr__nfet_01v8
XM$14 VGND A_N \$3 sky130_gnd sky130_fd_pr__nfet_01v8 L=150000 W=420000
+ AS=109200000000 AD=109200000000 PS=1360000 PD=1360000
.ENDS sky130_fd_sc_hd__and4b_2

* cell sky130_fd_sc_hd__nand2b_2
* pin VPB
* pin B
* pin VPWR
* pin VGND
* pin Y
* pin A_N
* pin sky130_gnd
.SUBCKT sky130_fd_sc_hd__nand2b_2 VPB B VPWR VGND Y A_N sky130_gnd
* device instance $1 r0 *1 0.47,1.695 sky130_fd_pr__pfet_01v8_hvt
XM$1 \$2 A_N VPWR VPB sky130_fd_pr__pfet_01v8_hvt L=150000 W=420000
+ AS=109200000000 AD=146800000000 PS=1360000 PD=1340000
* device instance $2 r0 *1 0.96,1.985 sky130_fd_pr__pfet_01v8_hvt
XM$2 VPWR \$2 Y VPB sky130_fd_pr__pfet_01v8_hvt L=150000 W=1000000
+ AS=146800000000 AD=165000000000 PS=1340000 PD=1330000
* device instance $3 r0 *1 1.44,1.985 sky130_fd_pr__pfet_01v8_hvt
XM$3 Y \$2 VPWR VPB sky130_fd_pr__pfet_01v8_hvt L=150000 W=1000000
+ AS=165000000000 AD=335000000000 PS=1330000 PD=1670000
* device instance $4 r0 *1 2.26,1.985 sky130_fd_pr__pfet_01v8_hvt
XM$4 VPWR B Y VPB sky130_fd_pr__pfet_01v8_hvt L=150000 W=1000000
+ AS=335000000000 AD=135000000000 PS=1670000 PD=1270000
* device instance $5 r0 *1 2.68,1.985 sky130_fd_pr__pfet_01v8_hvt
XM$5 Y B VPWR VPB sky130_fd_pr__pfet_01v8_hvt L=150000 W=1000000
+ AS=135000000000 AD=275000000000 PS=1270000 PD=2550000
* device instance $6 r0 *1 1.48,0.56 sky130_fd_pr__nfet_01v8
XM$6 \$3 \$2 Y sky130_gnd sky130_fd_pr__nfet_01v8 L=150000 W=650000
+ AS=169000000000 AD=87750000000 PS=1820000 PD=920000
* device instance $7 r0 *1 1.9,0.56 sky130_fd_pr__nfet_01v8
XM$7 Y \$2 \$3 sky130_gnd sky130_fd_pr__nfet_01v8 L=150000 W=650000
+ AS=87750000000 AD=87750000000 PS=920000 PD=920000
* device instance $8 r0 *1 2.32,0.56 sky130_fd_pr__nfet_01v8
XM$8 \$3 B VGND sky130_gnd sky130_fd_pr__nfet_01v8 L=150000 W=650000
+ AS=87750000000 AD=87750000000 PS=920000 PD=920000
* device instance $9 r0 *1 2.74,0.56 sky130_fd_pr__nfet_01v8
XM$9 VGND B \$3 sky130_gnd sky130_fd_pr__nfet_01v8 L=150000 W=650000
+ AS=87750000000 AD=169000000000 PS=920000 PD=1820000
* device instance $10 r0 *1 0.47,0.675 sky130_fd_pr__nfet_01v8
XM$10 VGND A_N \$2 sky130_gnd sky130_fd_pr__nfet_01v8 L=150000 W=420000
+ AS=194000000000 AD=109200000000 PS=1950000 PD=1360000
.ENDS sky130_fd_sc_hd__nand2b_2

* cell sky130_fd_sc_hd__o21ba_2
* pin VPB
* pin VPWR
* pin B1_N
* pin VGND
* pin X
* pin A2
* pin A1
* pin sky130_gnd
.SUBCKT sky130_fd_sc_hd__o21ba_2 VPB VPWR B1_N VGND X A2 A1 sky130_gnd
* device instance $1 r0 *1 0.47,1.695 sky130_fd_pr__pfet_01v8_hvt
XM$1 \$7 B1_N VPWR VPB sky130_fd_pr__pfet_01v8_hvt L=150000 W=420000
+ AS=109200000000 AD=145750000000 PS=1360000 PD=1335000
* device instance $2 r0 *1 0.955,1.985 sky130_fd_pr__pfet_01v8_hvt
XM$2 VPWR \$2 X VPB sky130_fd_pr__pfet_01v8_hvt L=150000 W=1000000
+ AS=145750000000 AD=135000000000 PS=1335000 PD=1270000
* device instance $3 r0 *1 1.375,1.985 sky130_fd_pr__pfet_01v8_hvt
XM$3 X \$2 VPWR VPB sky130_fd_pr__pfet_01v8_hvt L=150000 W=1000000
+ AS=135000000000 AD=395000000000 PS=1270000 PD=1790000
* device instance $4 r0 *1 2.315,1.985 sky130_fd_pr__pfet_01v8_hvt
XM$4 VPWR \$7 \$2 VPB sky130_fd_pr__pfet_01v8_hvt L=150000 W=1000000
+ AS=395000000000 AD=165000000000 PS=1790000 PD=1330000
* device instance $5 r0 *1 2.795,1.985 sky130_fd_pr__pfet_01v8_hvt
XM$5 \$2 A2 \$12 VPB sky130_fd_pr__pfet_01v8_hvt L=150000 W=1000000
+ AS=165000000000 AD=105000000000 PS=1330000 PD=1210000
* device instance $6 r0 *1 3.155,1.985 sky130_fd_pr__pfet_01v8_hvt
XM$6 \$12 A1 VPWR VPB sky130_fd_pr__pfet_01v8_hvt L=150000 W=1000000
+ AS=105000000000 AD=280000000000 PS=1210000 PD=2560000
* device instance $7 r0 *1 2.315,0.56 sky130_fd_pr__nfet_01v8
XM$7 \$2 \$7 \$8 sky130_gnd sky130_fd_pr__nfet_01v8 L=150000 W=650000
+ AS=169000000000 AD=105625000000 PS=1820000 PD=975000
* device instance $8 r0 *1 2.79,0.56 sky130_fd_pr__nfet_01v8
XM$8 \$8 A2 VGND sky130_gnd sky130_fd_pr__nfet_01v8 L=150000 W=650000
+ AS=105625000000 AD=87750000000 PS=975000 PD=920000
* device instance $9 r0 *1 3.21,0.56 sky130_fd_pr__nfet_01v8
XM$9 VGND A1 \$8 sky130_gnd sky130_fd_pr__nfet_01v8 L=150000 W=650000
+ AS=87750000000 AD=169000000000 PS=920000 PD=1820000
* device instance $10 r0 *1 0.47,0.675 sky130_fd_pr__nfet_01v8
XM$10 VGND B1_N \$7 sky130_gnd sky130_fd_pr__nfet_01v8 L=150000 W=420000
+ AS=97000000000 AD=109200000000 PS=975000 PD=1360000
* device instance $11 r0 *1 0.945,0.56 sky130_fd_pr__nfet_01v8
XM$11 VGND \$2 X sky130_gnd sky130_fd_pr__nfet_01v8 L=150000 W=650000
+ AS=97000000000 AD=87750000000 PS=975000 PD=920000
* device instance $12 r0 *1 1.365,0.56 sky130_fd_pr__nfet_01v8
XM$12 X \$2 VGND sky130_gnd sky130_fd_pr__nfet_01v8 L=150000 W=650000
+ AS=87750000000 AD=169000000000 PS=920000 PD=1820000
.ENDS sky130_fd_sc_hd__o21ba_2

* cell sky130_fd_sc_hd__diode_2
* pin VPB
* pin DIODE
* pin VPWR
* pin VGND
.SUBCKT sky130_fd_sc_hd__diode_2 VPB DIODE VPWR VGND
.ENDS sky130_fd_sc_hd__diode_2

* cell sky130_fd_sc_hd__nand4_2
* pin VGND
* pin D
* pin C
* pin B
* pin A
* pin VPWR
* pin Y
* pin VPB
* pin sky130_gnd
.SUBCKT sky130_fd_sc_hd__nand4_2 VGND D C B A VPWR Y VPB sky130_gnd
* device instance $1 r0 *1 0.47,1.985 sky130_fd_pr__pfet_01v8_hvt
XM$1 VPWR D Y VPB sky130_fd_pr__pfet_01v8_hvt L=150000 W=1000000
+ AS=260000000000 AD=135000000000 PS=2520000 PD=1270000
* device instance $2 r0 *1 0.89,1.985 sky130_fd_pr__pfet_01v8_hvt
XM$2 Y D VPWR VPB sky130_fd_pr__pfet_01v8_hvt L=150000 W=1000000
+ AS=135000000000 AD=135000000000 PS=1270000 PD=1270000
* device instance $3 r0 *1 1.31,1.985 sky130_fd_pr__pfet_01v8_hvt
XM$3 VPWR C Y VPB sky130_fd_pr__pfet_01v8_hvt L=150000 W=1000000
+ AS=135000000000 AD=135000000000 PS=1270000 PD=1270000
* device instance $4 r0 *1 1.73,1.985 sky130_fd_pr__pfet_01v8_hvt
XM$4 Y C VPWR VPB sky130_fd_pr__pfet_01v8_hvt L=150000 W=1000000
+ AS=135000000000 AD=215000000000 PS=1270000 PD=1430000
* device instance $5 r0 *1 2.31,1.985 sky130_fd_pr__pfet_01v8_hvt
XM$5 VPWR B Y VPB sky130_fd_pr__pfet_01v8_hvt L=150000 W=1000000
+ AS=215000000000 AD=135000000000 PS=1430000 PD=1270000
* device instance $6 r0 *1 2.73,1.985 sky130_fd_pr__pfet_01v8_hvt
XM$6 Y B VPWR VPB sky130_fd_pr__pfet_01v8_hvt L=150000 W=1000000
+ AS=135000000000 AD=335000000000 PS=1270000 PD=1670000
* device instance $7 r0 *1 3.55,1.985 sky130_fd_pr__pfet_01v8_hvt
XM$7 VPWR A Y VPB sky130_fd_pr__pfet_01v8_hvt L=150000 W=1000000
+ AS=335000000000 AD=135000000000 PS=1670000 PD=1270000
* device instance $8 r0 *1 3.97,1.985 sky130_fd_pr__pfet_01v8_hvt
XM$8 Y A VPWR VPB sky130_fd_pr__pfet_01v8_hvt L=150000 W=1000000
+ AS=135000000000 AD=420000000000 PS=1270000 PD=2840000
* device instance $9 r0 *1 2.71,0.56 sky130_fd_pr__nfet_01v8
XM$9 \$5 B \$4 sky130_gnd sky130_fd_pr__nfet_01v8 L=150000 W=650000
+ AS=182000000000 AD=87750000000 PS=1860000 PD=920000
* device instance $10 r0 *1 3.13,0.56 sky130_fd_pr__nfet_01v8
XM$10 \$4 B \$5 sky130_gnd sky130_fd_pr__nfet_01v8 L=150000 W=650000
+ AS=87750000000 AD=87750000000 PS=920000 PD=920000
* device instance $11 r0 *1 3.55,0.56 sky130_fd_pr__nfet_01v8
XM$11 \$5 A Y sky130_gnd sky130_fd_pr__nfet_01v8 L=150000 W=650000
+ AS=87750000000 AD=87750000000 PS=920000 PD=920000
* device instance $12 r0 *1 3.97,0.56 sky130_fd_pr__nfet_01v8
XM$12 Y A \$5 sky130_gnd sky130_fd_pr__nfet_01v8 L=150000 W=650000
+ AS=87750000000 AD=234000000000 PS=920000 PD=2020000
* device instance $13 r0 *1 0.47,0.56 sky130_fd_pr__nfet_01v8
XM$13 \$3 D VGND sky130_gnd sky130_fd_pr__nfet_01v8 L=150000 W=650000
+ AS=169000000000 AD=87750000000 PS=1820000 PD=920000
* device instance $14 r0 *1 0.89,0.56 sky130_fd_pr__nfet_01v8
XM$14 VGND D \$3 sky130_gnd sky130_fd_pr__nfet_01v8 L=150000 W=650000
+ AS=87750000000 AD=87750000000 PS=920000 PD=920000
* device instance $15 r0 *1 1.31,0.56 sky130_fd_pr__nfet_01v8
XM$15 \$3 C \$4 sky130_gnd sky130_fd_pr__nfet_01v8 L=150000 W=650000
+ AS=87750000000 AD=87750000000 PS=920000 PD=920000
* device instance $16 r0 *1 1.73,0.56 sky130_fd_pr__nfet_01v8
XM$16 \$4 C \$3 sky130_gnd sky130_fd_pr__nfet_01v8 L=150000 W=650000
+ AS=87750000000 AD=182000000000 PS=920000 PD=1860000
.ENDS sky130_fd_sc_hd__nand4_2

* cell sky130_fd_sc_hd__dfxtp_2
* pin VGND
* pin Q
* pin CLK
* pin D
* pin VPWR
* pin VPB
* pin sky130_gnd
.SUBCKT sky130_fd_sc_hd__dfxtp_2 VGND Q CLK D VPWR VPB sky130_gnd
* device instance $1 r0 *1 1.83,2.275 sky130_fd_pr__pfet_01v8_hvt
XM$1 VPWR D \$6 VPB sky130_fd_pr__pfet_01v8_hvt L=150000 W=420000
+ AS=109200000000 AD=57750000000 PS=1360000 PD=695000
* device instance $2 r0 *1 2.255,2.275 sky130_fd_pr__pfet_01v8_hvt
XM$2 \$6 \$5 \$7 VPB sky130_fd_pr__pfet_01v8_hvt L=150000 W=420000
+ AS=57750000000 AD=68250000000 PS=695000 PD=745000
* device instance $3 r0 *1 2.73,2.275 sky130_fd_pr__pfet_01v8_hvt
XM$3 \$7 \$4 \$17 VPB sky130_fd_pr__pfet_01v8_hvt L=150000 W=420000
+ AS=68250000000 AD=76650000000 PS=745000 PD=785000
* device instance $4 r0 *1 3.245,2.275 sky130_fd_pr__pfet_01v8_hvt
XM$4 VPWR \$8 \$17 VPB sky130_fd_pr__pfet_01v8_hvt L=150000 W=420000
+ AS=178875000000 AD=76650000000 PS=1260000 PD=785000
* device instance $5 r0 *1 3.905,2.11 sky130_fd_pr__pfet_01v8_hvt
XM$5 VPWR \$7 \$8 VPB sky130_fd_pr__pfet_01v8_hvt L=150000 W=750000
+ AS=178875000000 AD=109500000000 PS=1260000 PD=1075000
* device instance $6 r0 *1 4.38,2.275 sky130_fd_pr__pfet_01v8_hvt
XM$6 \$8 \$4 \$9 VPB sky130_fd_pr__pfet_01v8_hvt L=150000 W=420000
+ AS=109500000000 AD=56700000000 PS=1075000 PD=690000
* device instance $7 r0 *1 4.8,2.275 sky130_fd_pr__pfet_01v8_hvt
XM$7 \$9 \$5 \$18 VPB sky130_fd_pr__pfet_01v8_hvt L=150000 W=420000
+ AS=56700000000 AD=88200000000 PS=690000 PD=840000
* device instance $8 r0 *1 5.37,2.275 sky130_fd_pr__pfet_01v8_hvt
XM$8 \$18 \$10 VPWR VPB sky130_fd_pr__pfet_01v8_hvt L=150000 W=420000
+ AS=88200000000 AD=111300000000 PS=840000 PD=1370000
* device instance $9 r0 *1 0.47,2.135 sky130_fd_pr__pfet_01v8_hvt
XM$9 \$4 CLK VPWR VPB sky130_fd_pr__pfet_01v8_hvt L=150000 W=640000
+ AS=166400000000 AD=86400000000 PS=1800000 PD=910000
* device instance $10 r0 *1 0.89,2.135 sky130_fd_pr__pfet_01v8_hvt
XM$10 VPWR \$4 \$5 VPB sky130_fd_pr__pfet_01v8_hvt L=150000 W=640000
+ AS=86400000000 AD=166400000000 PS=910000 PD=1800000
* device instance $11 r0 *1 6.42,1.985 sky130_fd_pr__pfet_01v8_hvt
XM$11 \$10 \$9 VPWR VPB sky130_fd_pr__pfet_01v8_hvt L=150000 W=1000000
+ AS=270000000000 AD=135000000000 PS=2540000 PD=1270000
* device instance $12 r0 *1 6.84,1.985 sky130_fd_pr__pfet_01v8_hvt
XM$12 VPWR \$10 Q VPB sky130_fd_pr__pfet_01v8_hvt L=150000 W=1000000
+ AS=135000000000 AD=135000000000 PS=1270000 PD=1270000
* device instance $13 r0 *1 7.26,1.985 sky130_fd_pr__pfet_01v8_hvt
XM$13 Q \$10 VPWR VPB sky130_fd_pr__pfet_01v8_hvt L=150000 W=1000000
+ AS=135000000000 AD=260000000000 PS=1270000 PD=2520000
* device instance $14 r0 *1 6.43,0.56 sky130_fd_pr__nfet_01v8
XM$14 \$10 \$9 VGND sky130_gnd sky130_fd_pr__nfet_01v8 L=150000 W=650000
+ AS=169000000000 AD=87750000000 PS=1820000 PD=920000
* device instance $15 r0 *1 6.85,0.56 sky130_fd_pr__nfet_01v8
XM$15 VGND \$10 Q sky130_gnd sky130_fd_pr__nfet_01v8 L=150000 W=650000
+ AS=87750000000 AD=87750000000 PS=920000 PD=920000
* device instance $16 r0 *1 7.27,0.56 sky130_fd_pr__nfet_01v8
XM$16 Q \$10 VGND sky130_gnd sky130_fd_pr__nfet_01v8 L=150000 W=650000
+ AS=87750000000 AD=169000000000 PS=920000 PD=1820000
* device instance $17 r0 *1 2.39,0.415 sky130_fd_pr__nfet_01v8
XM$17 \$6 \$4 \$7 sky130_gnd sky130_fd_pr__nfet_01v8 L=150000 W=360000
+ AS=81300000000 AD=62100000000 PS=830000 PD=705000
* device instance $18 r0 *1 2.885,0.415 sky130_fd_pr__nfet_01v8
XM$18 \$7 \$5 \$13 sky130_gnd sky130_fd_pr__nfet_01v8 L=150000 W=360000
+ AS=62100000000 AD=69600000000 PS=705000 PD=765000
* device instance $19 r0 *1 4.48,0.415 sky130_fd_pr__nfet_01v8
XM$19 \$8 \$5 \$9 sky130_gnd sky130_fd_pr__nfet_01v8 L=150000 W=360000
+ AS=98900000000 AD=68400000000 PS=995000 PD=740000
* device instance $20 r0 *1 5.01,0.415 sky130_fd_pr__nfet_01v8
XM$20 \$9 \$4 \$12 sky130_gnd sky130_fd_pr__nfet_01v8 L=150000 W=360000
+ AS=68400000000 AD=66000000000 PS=740000 PD=745000
* device instance $21 r0 *1 1.83,0.445 sky130_fd_pr__nfet_01v8
XM$21 VGND D \$6 sky130_gnd sky130_fd_pr__nfet_01v8 L=150000 W=420000
+ AS=109200000000 AD=81300000000 PS=1360000 PD=830000
* device instance $22 r0 *1 3.38,0.445 sky130_fd_pr__nfet_01v8
XM$22 \$13 \$8 VGND sky130_gnd sky130_fd_pr__nfet_01v8 L=150000 W=420000
+ AS=69600000000 AD=120950000000 PS=765000 PD=1085000
* device instance $23 r0 *1 5.485,0.445 sky130_fd_pr__nfet_01v8
XM$23 \$12 \$10 VGND sky130_gnd sky130_fd_pr__nfet_01v8 L=150000 W=420000
+ AS=66000000000 AD=109200000000 PS=745000 PD=1360000
* device instance $24 r0 *1 3.975,0.555 sky130_fd_pr__nfet_01v8
XM$24 VGND \$7 \$8 sky130_gnd sky130_fd_pr__nfet_01v8 L=150000 W=640000
+ AS=120950000000 AD=98900000000 PS=1085000 PD=995000
* device instance $25 r0 *1 0.47,0.445 sky130_fd_pr__nfet_01v8
XM$25 \$4 CLK VGND sky130_gnd sky130_fd_pr__nfet_01v8 L=150000 W=420000
+ AS=109200000000 AD=56700000000 PS=1360000 PD=690000
* device instance $26 r0 *1 0.89,0.445 sky130_fd_pr__nfet_01v8
XM$26 VGND \$4 \$5 sky130_gnd sky130_fd_pr__nfet_01v8 L=150000 W=420000
+ AS=56700000000 AD=109200000000 PS=690000 PD=1360000
.ENDS sky130_fd_sc_hd__dfxtp_2

* cell sky130_fd_sc_hd__a32o_2
* pin VGND
* pin X
* pin B2
* pin A1
* pin A2
* pin B1
* pin A3
* pin VPWR
* pin VPB
* pin sky130_gnd
.SUBCKT sky130_fd_sc_hd__a32o_2 VGND X B2 A1 A2 B1 A3 VPWR VPB sky130_gnd
* device instance $1 r0 *1 1.83,1.985 sky130_fd_pr__pfet_01v8_hvt
XM$1 \$14 B2 \$5 VPB sky130_fd_pr__pfet_01v8_hvt L=150000 W=1000000
+ AS=260000000000 AD=135000000000 PS=2520000 PD=1270000
* device instance $2 r0 *1 2.25,1.985 sky130_fd_pr__pfet_01v8_hvt
XM$2 \$5 B1 \$14 VPB sky130_fd_pr__pfet_01v8_hvt L=150000 W=1000000
+ AS=135000000000 AD=135000000000 PS=1270000 PD=1270000
* device instance $3 r0 *1 2.67,1.985 sky130_fd_pr__pfet_01v8_hvt
XM$3 \$14 A1 VPWR VPB sky130_fd_pr__pfet_01v8_hvt L=150000 W=1000000
+ AS=135000000000 AD=215000000000 PS=1270000 PD=1430000
* device instance $4 r0 *1 3.25,1.985 sky130_fd_pr__pfet_01v8_hvt
XM$4 VPWR A2 \$14 VPB sky130_fd_pr__pfet_01v8_hvt L=150000 W=1000000
+ AS=215000000000 AD=135000000000 PS=1430000 PD=1270000
* device instance $5 r0 *1 3.67,1.985 sky130_fd_pr__pfet_01v8_hvt
XM$5 \$14 A3 VPWR VPB sky130_fd_pr__pfet_01v8_hvt L=150000 W=1000000
+ AS=135000000000 AD=260000000000 PS=1270000 PD=2520000
* device instance $6 r0 *1 0.47,1.985 sky130_fd_pr__pfet_01v8_hvt
XM$6 X \$5 VPWR VPB sky130_fd_pr__pfet_01v8_hvt L=150000 W=1000000
+ AS=260000000000 AD=135000000000 PS=2520000 PD=1270000
* device instance $7 r0 *1 0.89,1.985 sky130_fd_pr__pfet_01v8_hvt
XM$7 VPWR \$5 X VPB sky130_fd_pr__pfet_01v8_hvt L=150000 W=1000000
+ AS=135000000000 AD=260000000000 PS=1270000 PD=2520000
* device instance $8 r0 *1 0.47,0.56 sky130_fd_pr__nfet_01v8
XM$8 VGND \$5 X sky130_gnd sky130_fd_pr__nfet_01v8 L=150000 W=650000
+ AS=169000000000 AD=87750000000 PS=1820000 PD=920000
* device instance $9 r0 *1 0.89,0.56 sky130_fd_pr__nfet_01v8
XM$9 X \$5 VGND sky130_gnd sky130_fd_pr__nfet_01v8 L=150000 W=650000
+ AS=87750000000 AD=209625000000 PS=920000 PD=1295000
* device instance $10 r0 *1 1.685,0.56 sky130_fd_pr__nfet_01v8
XM$10 VGND B2 \$10 sky130_gnd sky130_fd_pr__nfet_01v8 L=150000 W=650000
+ AS=209625000000 AD=115375000000 PS=1295000 PD=1005000
* device instance $11 r0 *1 2.19,0.56 sky130_fd_pr__nfet_01v8
XM$11 \$10 B1 \$5 sky130_gnd sky130_fd_pr__nfet_01v8 L=150000 W=650000
+ AS=115375000000 AD=107250000000 PS=1005000 PD=980000
* device instance $12 r0 *1 2.67,0.56 sky130_fd_pr__nfet_01v8
XM$12 \$5 A1 \$12 sky130_gnd sky130_fd_pr__nfet_01v8 L=150000 W=650000
+ AS=107250000000 AD=139750000000 PS=980000 PD=1080000
* device instance $13 r0 *1 3.25,0.56 sky130_fd_pr__nfet_01v8
XM$13 \$12 A2 \$11 sky130_gnd sky130_fd_pr__nfet_01v8 L=150000 W=650000
+ AS=139750000000 AD=87750000000 PS=1080000 PD=920000
* device instance $14 r0 *1 3.67,0.56 sky130_fd_pr__nfet_01v8
XM$14 \$11 A3 VGND sky130_gnd sky130_fd_pr__nfet_01v8 L=150000 W=650000
+ AS=87750000000 AD=169000000000 PS=920000 PD=1820000
.ENDS sky130_fd_sc_hd__a32o_2

* cell sky130_fd_sc_hd__dfrtp_2
* pin VGND
* pin RESET_B
* pin Q
* pin CLK
* pin D
* pin VPWR
* pin VPB
* pin sky130_gnd
.SUBCKT sky130_fd_sc_hd__dfrtp_2 VGND RESET_B Q CLK D VPWR VPB sky130_gnd
* device instance $1 r0 *1 5.35,2.065 sky130_fd_pr__pfet_01v8_hvt
XM$1 VPWR \$6 \$17 VPB sky130_fd_pr__pfet_01v8_hvt L=150000 W=840000
+ AS=218400000000 AD=129150000000 PS=2200000 PD=1185000
* device instance $2 r0 *1 5.845,2.275 sky130_fd_pr__pfet_01v8_hvt
XM$2 \$17 \$3 \$8 VPB sky130_fd_pr__pfet_01v8_hvt L=150000 W=420000
+ AS=129150000000 AD=58800000000 PS=1185000 PD=700000
* device instance $3 r0 *1 6.275,2.275 sky130_fd_pr__pfet_01v8_hvt
XM$3 \$8 \$4 \$20 VPB sky130_fd_pr__pfet_01v8_hvt L=150000 W=420000
+ AS=58800000000 AD=56700000000 PS=700000 PD=690000
* device instance $4 r0 *1 6.695,2.275 sky130_fd_pr__pfet_01v8_hvt
XM$4 \$20 \$9 VPWR VPB sky130_fd_pr__pfet_01v8_hvt L=150000 W=420000
+ AS=56700000000 AD=81900000000 PS=690000 PD=810000
* device instance $5 r0 *1 7.235,2.275 sky130_fd_pr__pfet_01v8_hvt
XM$5 VPWR RESET_B \$9 VPB sky130_fd_pr__pfet_01v8_hvt L=150000 W=420000
+ AS=81900000000 AD=56700000000 PS=810000 PD=690000
* device instance $6 r0 *1 7.655,2.275 sky130_fd_pr__pfet_01v8_hvt
XM$6 \$9 \$8 VPWR VPB sky130_fd_pr__pfet_01v8_hvt L=150000 W=420000
+ AS=56700000000 AD=113400000000 PS=690000 PD=1380000
* device instance $7 r0 *1 0.47,2.135 sky130_fd_pr__pfet_01v8_hvt
XM$7 \$3 CLK VPWR VPB sky130_fd_pr__pfet_01v8_hvt L=150000 W=640000
+ AS=166400000000 AD=86400000000 PS=1800000 PD=910000
* device instance $8 r0 *1 0.89,2.135 sky130_fd_pr__pfet_01v8_hvt
XM$8 VPWR \$3 \$4 VPB sky130_fd_pr__pfet_01v8_hvt L=150000 W=640000
+ AS=86400000000 AD=166400000000 PS=910000 PD=1800000
* device instance $9 r0 *1 2.225,2.275 sky130_fd_pr__pfet_01v8_hvt
XM$9 VPWR D \$5 VPB sky130_fd_pr__pfet_01v8_hvt L=150000 W=420000
+ AS=109200000000 AD=65100000000 PS=1360000 PD=730000
* device instance $10 r0 *1 2.685,2.275 sky130_fd_pr__pfet_01v8_hvt
XM$10 \$5 \$4 \$6 VPB sky130_fd_pr__pfet_01v8_hvt L=150000 W=420000
+ AS=65100000000 AD=72450000000 PS=730000 PD=765000
* device instance $11 r0 *1 3.18,2.275 sky130_fd_pr__pfet_01v8_hvt
XM$11 \$6 \$3 \$19 VPB sky130_fd_pr__pfet_01v8_hvt L=150000 W=420000
+ AS=72450000000 AD=115500000000 PS=765000 PD=970000
* device instance $12 r0 *1 3.88,2.275 sky130_fd_pr__pfet_01v8_hvt
XM$12 \$19 \$17 VPWR VPB sky130_fd_pr__pfet_01v8_hvt L=150000 W=420000
+ AS=115500000000 AD=70350000000 PS=970000 PD=755000
* device instance $13 r0 *1 4.365,2.275 sky130_fd_pr__pfet_01v8_hvt
XM$13 VPWR RESET_B \$19 VPB sky130_fd_pr__pfet_01v8_hvt L=150000 W=420000
+ AS=70350000000 AD=109200000000 PS=755000 PD=1360000
* device instance $14 r0 *1 8.73,1.985 sky130_fd_pr__pfet_01v8_hvt
XM$14 VPWR \$9 Q VPB sky130_fd_pr__pfet_01v8_hvt L=150000 W=1000000
+ AS=301200000000 AD=135000000000 PS=2660000 PD=1270000
* device instance $15 r0 *1 9.15,1.985 sky130_fd_pr__pfet_01v8_hvt
XM$15 Q \$9 VPWR VPB sky130_fd_pr__pfet_01v8_hvt L=150000 W=1000000
+ AS=135000000000 AD=260000000000 PS=1270000 PD=2520000
* device instance $16 r0 *1 2.64,0.415 sky130_fd_pr__nfet_01v8
XM$16 \$5 \$3 \$6 sky130_gnd sky130_fd_pr__nfet_01v8 L=150000 W=360000
+ AS=66000000000 AD=59400000000 PS=745000 PD=690000
* device instance $17 r0 *1 3.12,0.415 sky130_fd_pr__nfet_01v8
XM$17 \$6 \$4 \$13 sky130_gnd sky130_fd_pr__nfet_01v8 L=150000 W=360000
+ AS=59400000000 AD=140100000000 PS=690000 PD=1100000
* device instance $18 r0 *1 5.465,0.415 sky130_fd_pr__nfet_01v8
XM$18 \$17 \$4 \$8 sky130_gnd sky130_fd_pr__nfet_01v8 L=150000 W=360000
+ AS=99900000000 AD=71100000000 PS=985000 PD=755000
* device instance $19 r0 *1 6.01,0.415 sky130_fd_pr__nfet_01v8
XM$19 \$8 \$3 \$12 sky130_gnd sky130_fd_pr__nfet_01v8 L=150000 W=360000
+ AS=71100000000 AD=66900000000 PS=755000 PD=750000
* device instance $20 r0 *1 2.165,0.445 sky130_fd_pr__nfet_01v8
XM$20 VGND D \$5 sky130_gnd sky130_fd_pr__nfet_01v8 L=150000 W=420000
+ AS=220500000000 AD=66000000000 PS=1890000 PD=745000
* device instance $21 r0 *1 3.95,0.445 sky130_fd_pr__nfet_01v8
XM$21 \$13 \$17 \$14 sky130_gnd sky130_fd_pr__nfet_01v8 L=150000 W=420000
+ AS=140100000000 AD=44100000000 PS=1100000 PD=630000
* device instance $22 r0 *1 4.31,0.445 sky130_fd_pr__nfet_01v8
XM$22 \$14 RESET_B VGND sky130_gnd sky130_fd_pr__nfet_01v8 L=150000 W=420000
+ AS=44100000000 AD=134600000000 PS=630000 PD=1150000
* device instance $23 r0 *1 6.49,0.445 sky130_fd_pr__nfet_01v8
XM$23 \$12 \$9 VGND sky130_gnd sky130_fd_pr__nfet_01v8 L=150000 W=420000
+ AS=66900000000 AD=124950000000 PS=750000 PD=1015000
* device instance $24 r0 *1 7.235,0.445 sky130_fd_pr__nfet_01v8
XM$24 VGND RESET_B \$11 sky130_gnd sky130_fd_pr__nfet_01v8 L=150000 W=420000
+ AS=124950000000 AD=64050000000 PS=1015000 PD=725000
* device instance $25 r0 *1 7.69,0.445 sky130_fd_pr__nfet_01v8
XM$25 \$11 \$8 \$9 sky130_gnd sky130_fd_pr__nfet_01v8 L=150000 W=420000
+ AS=64050000000 AD=109200000000 PS=725000 PD=1360000
* device instance $26 r0 *1 4.97,0.555 sky130_fd_pr__nfet_01v8
XM$26 VGND \$6 \$17 sky130_gnd sky130_fd_pr__nfet_01v8 L=150000 W=640000
+ AS=134600000000 AD=99900000000 PS=1150000 PD=985000
* device instance $27 r0 *1 0.47,0.445 sky130_fd_pr__nfet_01v8
XM$27 \$3 CLK VGND sky130_gnd sky130_fd_pr__nfet_01v8 L=150000 W=420000
+ AS=109200000000 AD=56700000000 PS=1360000 PD=690000
* device instance $28 r0 *1 0.89,0.445 sky130_fd_pr__nfet_01v8
XM$28 VGND \$3 \$4 sky130_gnd sky130_fd_pr__nfet_01v8 L=150000 W=420000
+ AS=56700000000 AD=109200000000 PS=690000 PD=1360000
* device instance $29 r0 *1 8.73,0.56 sky130_fd_pr__nfet_01v8
XM$29 VGND \$9 Q sky130_gnd sky130_fd_pr__nfet_01v8 L=150000 W=650000
+ AS=208700000000 AD=87750000000 PS=2020000 PD=920000
* device instance $30 r0 *1 9.15,0.56 sky130_fd_pr__nfet_01v8
XM$30 Q \$9 VGND sky130_gnd sky130_fd_pr__nfet_01v8 L=150000 W=650000
+ AS=87750000000 AD=169000000000 PS=920000 PD=1820000
.ENDS sky130_fd_sc_hd__dfrtp_2

* cell sky130_fd_sc_hd__and3_2
* pin VPB
* pin A
* pin B
* pin C
* pin VGND
* pin VPWR
* pin X
* pin sky130_gnd
.SUBCKT sky130_fd_sc_hd__and3_2 VPB A B C VGND VPWR X sky130_gnd
* device instance $1 r0 *1 1.375,1.695 sky130_fd_pr__pfet_01v8_hvt
XM$1 \$4 C VPWR VPB sky130_fd_pr__pfet_01v8_hvt L=150000 W=420000
+ AS=74375000000 AD=150750000000 PS=815000 PD=1345000
* device instance $2 r0 *1 0.48,1.765 sky130_fd_pr__pfet_01v8_hvt
XM$2 \$4 A VPWR VPB sky130_fd_pr__pfet_01v8_hvt L=150000 W=420000
+ AS=109200000000 AD=56700000000 PS=1360000 PD=690000
* device instance $3 r0 *1 0.9,1.765 sky130_fd_pr__pfet_01v8_hvt
XM$3 \$4 B VPWR VPB sky130_fd_pr__pfet_01v8_hvt L=150000 W=420000
+ AS=74375000000 AD=56700000000 PS=815000 PD=690000
* device instance $4 r0 *1 1.87,1.985 sky130_fd_pr__pfet_01v8_hvt
XM$4 VPWR \$4 X VPB sky130_fd_pr__pfet_01v8_hvt L=150000 W=1000000
+ AS=150750000000 AD=135000000000 PS=1345000 PD=1270000
* device instance $5 r0 *1 2.29,1.985 sky130_fd_pr__pfet_01v8_hvt
XM$5 X \$4 VPWR VPB sky130_fd_pr__pfet_01v8_hvt L=150000 W=1000000
+ AS=135000000000 AD=260000000000 PS=1270000 PD=2520000
* device instance $6 r0 *1 0.485,0.475 sky130_fd_pr__nfet_01v8
XM$6 \$4 A \$11 sky130_gnd sky130_fd_pr__nfet_01v8 L=150000 W=420000
+ AS=109200000000 AD=44100000000 PS=1360000 PD=630000
* device instance $7 r0 *1 0.845,0.475 sky130_fd_pr__nfet_01v8
XM$7 \$11 B \$10 sky130_gnd sky130_fd_pr__nfet_01v8 L=150000 W=420000
+ AS=44100000000 AD=53550000000 PS=630000 PD=675000
* device instance $8 r0 *1 1.25,0.475 sky130_fd_pr__nfet_01v8
XM$8 VGND C \$10 sky130_gnd sky130_fd_pr__nfet_01v8 L=150000 W=420000
+ AS=130400000000 AD=53550000000 PS=1105000 PD=675000
* device instance $9 r0 *1 1.855,0.56 sky130_fd_pr__nfet_01v8
XM$9 VGND \$4 X sky130_gnd sky130_fd_pr__nfet_01v8 L=150000 W=650000
+ AS=130400000000 AD=87750000000 PS=1105000 PD=920000
* device instance $10 r0 *1 2.275,0.56 sky130_fd_pr__nfet_01v8
XM$10 X \$4 VGND sky130_gnd sky130_fd_pr__nfet_01v8 L=150000 W=650000
+ AS=87750000000 AD=178750000000 PS=920000 PD=1850000
.ENDS sky130_fd_sc_hd__and3_2

* cell sky130_fd_sc_hd__o31a_2
* pin VGND
* pin X
* pin A1
* pin A2
* pin A3
* pin B1
* pin VPWR
* pin VPB
* pin sky130_gnd
.SUBCKT sky130_fd_sc_hd__o31a_2 VGND X A1 A2 A3 B1 VPWR VPB sky130_gnd
* device instance $1 r0 *1 0.615,1.985 sky130_fd_pr__pfet_01v8_hvt
XM$1 VPWR \$5 X VPB sky130_fd_pr__pfet_01v8_hvt L=150000 W=1000000
+ AS=405000000000 AD=175000000000 PS=2810000 PD=1350000
* device instance $2 r0 *1 1.115,1.985 sky130_fd_pr__pfet_01v8_hvt
XM$2 X \$5 VPWR VPB sky130_fd_pr__pfet_01v8_hvt L=150000 W=1000000
+ AS=175000000000 AD=195000000000 PS=1350000 PD=1390000
* device instance $3 r0 *1 1.655,1.985 sky130_fd_pr__pfet_01v8_hvt
XM$3 VPWR A1 \$12 VPB sky130_fd_pr__pfet_01v8_hvt L=150000 W=1000000
+ AS=195000000000 AD=135000000000 PS=1390000 PD=1270000
* device instance $4 r0 *1 2.075,1.985 sky130_fd_pr__pfet_01v8_hvt
XM$4 \$12 A2 \$13 VPB sky130_fd_pr__pfet_01v8_hvt L=150000 W=1000000
+ AS=135000000000 AD=165000000000 PS=1270000 PD=1330000
* device instance $5 r0 *1 2.555,1.985 sky130_fd_pr__pfet_01v8_hvt
XM$5 \$13 A3 \$5 VPB sky130_fd_pr__pfet_01v8_hvt L=150000 W=1000000
+ AS=165000000000 AD=212500000000 PS=1330000 PD=1425000
* device instance $6 r0 *1 3.13,1.985 sky130_fd_pr__pfet_01v8_hvt
XM$6 \$5 B1 VPWR VPB sky130_fd_pr__pfet_01v8_hvt L=150000 W=1000000
+ AS=212500000000 AD=340000000000 PS=1425000 PD=2680000
* device instance $7 r0 *1 0.615,0.56 sky130_fd_pr__nfet_01v8
XM$7 VGND \$5 X sky130_gnd sky130_fd_pr__nfet_01v8 L=150000 W=650000
+ AS=263250000000 AD=113750000000 PS=2110000 PD=1000000
* device instance $8 r0 *1 1.115,0.56 sky130_fd_pr__nfet_01v8
XM$8 X \$5 VGND sky130_gnd sky130_fd_pr__nfet_01v8 L=150000 W=650000
+ AS=113750000000 AD=126750000000 PS=1000000 PD=1040000
* device instance $9 r0 *1 1.655,0.56 sky130_fd_pr__nfet_01v8
XM$9 VGND A1 \$4 sky130_gnd sky130_fd_pr__nfet_01v8 L=150000 W=650000
+ AS=126750000000 AD=87750000000 PS=1040000 PD=920000
* device instance $10 r0 *1 2.075,0.56 sky130_fd_pr__nfet_01v8
XM$10 \$4 A2 VGND sky130_gnd sky130_fd_pr__nfet_01v8 L=150000 W=650000
+ AS=87750000000 AD=107250000000 PS=920000 PD=980000
* device instance $11 r0 *1 2.555,0.56 sky130_fd_pr__nfet_01v8
XM$11 VGND A3 \$4 sky130_gnd sky130_fd_pr__nfet_01v8 L=150000 W=650000
+ AS=107250000000 AD=107250000000 PS=980000 PD=980000
* device instance $12 r0 *1 3.035,0.56 sky130_fd_pr__nfet_01v8
XM$12 \$4 B1 \$5 sky130_gnd sky130_fd_pr__nfet_01v8 L=150000 W=650000
+ AS=107250000000 AD=201500000000 PS=980000 PD=1920000
.ENDS sky130_fd_sc_hd__o31a_2

* cell VIA_M2M3_PR
* pin
.SUBCKT VIA_M2M3_PR \$1
.ENDS VIA_M2M3_PR

* cell sky130_fd_sc_hd__xnor2_2
* pin VGND
* pin Y
* pin B
* pin A
* pin VPWR
* pin VPB
* pin sky130_gnd
.SUBCKT sky130_fd_sc_hd__xnor2_2 VGND Y B A VPWR VPB sky130_gnd
* device instance $1 r0 *1 4.96,1.985 sky130_fd_pr__pfet_01v8_hvt
XM$1 VPWR \$4 Y VPB sky130_fd_pr__pfet_01v8_hvt L=150000 W=1000000
+ AS=260000000000 AD=135000000000 PS=2520000 PD=1270000
* device instance $2 r0 *1 5.38,1.985 sky130_fd_pr__pfet_01v8_hvt
XM$2 Y \$4 VPWR VPB sky130_fd_pr__pfet_01v8_hvt L=150000 W=1000000
+ AS=135000000000 AD=280000000000 PS=1270000 PD=2560000
* device instance $3 r0 *1 2.725,1.985 sky130_fd_pr__pfet_01v8_hvt
XM$3 \$10 A VPWR VPB sky130_fd_pr__pfet_01v8_hvt L=150000 W=1000000
+ AS=280000000000 AD=135000000000 PS=2560000 PD=1270000
* device instance $4 r0 *1 3.145,1.985 sky130_fd_pr__pfet_01v8_hvt
XM$4 VPWR A \$10 VPB sky130_fd_pr__pfet_01v8_hvt L=150000 W=1000000
+ AS=135000000000 AD=135000000000 PS=1270000 PD=1270000
* device instance $5 r0 *1 3.565,1.985 sky130_fd_pr__pfet_01v8_hvt
XM$5 \$10 B Y VPB sky130_fd_pr__pfet_01v8_hvt L=150000 W=1000000
+ AS=135000000000 AD=152500000000 PS=1270000 PD=1305000
* device instance $6 r0 *1 4.02,1.985 sky130_fd_pr__pfet_01v8_hvt
XM$6 Y B \$10 VPB sky130_fd_pr__pfet_01v8_hvt L=150000 W=1000000
+ AS=152500000000 AD=260000000000 PS=1305000 PD=2520000
* device instance $7 r0 *1 0.485,1.985 sky130_fd_pr__pfet_01v8_hvt
XM$7 \$4 B VPWR VPB sky130_fd_pr__pfet_01v8_hvt L=150000 W=1000000
+ AS=275000000000 AD=135000000000 PS=2550000 PD=1270000
* device instance $8 r0 *1 0.905,1.985 sky130_fd_pr__pfet_01v8_hvt
XM$8 VPWR B \$4 VPB sky130_fd_pr__pfet_01v8_hvt L=150000 W=1000000
+ AS=135000000000 AD=135000000000 PS=1270000 PD=1270000
* device instance $9 r0 *1 1.325,1.985 sky130_fd_pr__pfet_01v8_hvt
XM$9 \$4 A VPWR VPB sky130_fd_pr__pfet_01v8_hvt L=150000 W=1000000
+ AS=135000000000 AD=135000000000 PS=1270000 PD=1270000
* device instance $10 r0 *1 1.745,1.985 sky130_fd_pr__pfet_01v8_hvt
XM$10 VPWR A \$4 VPB sky130_fd_pr__pfet_01v8_hvt L=150000 W=1000000
+ AS=135000000000 AD=280000000000 PS=1270000 PD=2560000
* device instance $11 r0 *1 4.96,0.56 sky130_fd_pr__nfet_01v8
XM$11 Y \$4 \$5 sky130_gnd sky130_fd_pr__nfet_01v8 L=150000 W=650000
+ AS=169000000000 AD=87750000000 PS=1820000 PD=920000
* device instance $12 r0 *1 5.38,0.56 sky130_fd_pr__nfet_01v8
XM$12 \$5 \$4 Y sky130_gnd sky130_fd_pr__nfet_01v8 L=150000 W=650000
+ AS=87750000000 AD=169000000000 PS=920000 PD=1820000
* device instance $13 r0 *1 2.725,0.56 sky130_fd_pr__nfet_01v8
XM$13 VGND A \$5 sky130_gnd sky130_fd_pr__nfet_01v8 L=150000 W=650000
+ AS=182000000000 AD=87750000000 PS=1860000 PD=920000
* device instance $14 r0 *1 3.145,0.56 sky130_fd_pr__nfet_01v8
XM$14 \$5 A VGND sky130_gnd sky130_fd_pr__nfet_01v8 L=150000 W=650000
+ AS=87750000000 AD=87750000000 PS=920000 PD=920000
* device instance $15 r0 *1 3.565,0.56 sky130_fd_pr__nfet_01v8
XM$15 VGND B \$5 sky130_gnd sky130_fd_pr__nfet_01v8 L=150000 W=650000
+ AS=87750000000 AD=99125000000 PS=920000 PD=955000
* device instance $16 r0 *1 4.02,0.56 sky130_fd_pr__nfet_01v8
XM$16 \$5 B VGND sky130_gnd sky130_fd_pr__nfet_01v8 L=150000 W=650000
+ AS=99125000000 AD=169000000000 PS=955000 PD=1820000
* device instance $17 r0 *1 0.485,0.56 sky130_fd_pr__nfet_01v8
XM$17 \$3 B \$4 sky130_gnd sky130_fd_pr__nfet_01v8 L=150000 W=650000
+ AS=178750000000 AD=87750000000 PS=1850000 PD=920000
* device instance $18 r0 *1 0.905,0.56 sky130_fd_pr__nfet_01v8
XM$18 \$4 B \$3 sky130_gnd sky130_fd_pr__nfet_01v8 L=150000 W=650000
+ AS=87750000000 AD=87750000000 PS=920000 PD=920000
* device instance $19 r0 *1 1.325,0.56 sky130_fd_pr__nfet_01v8
XM$19 \$3 A VGND sky130_gnd sky130_fd_pr__nfet_01v8 L=150000 W=650000
+ AS=87750000000 AD=87750000000 PS=920000 PD=920000
* device instance $20 r0 *1 1.745,0.56 sky130_fd_pr__nfet_01v8
XM$20 VGND A \$3 sky130_gnd sky130_fd_pr__nfet_01v8 L=150000 W=650000
+ AS=87750000000 AD=182000000000 PS=920000 PD=1860000
.ENDS sky130_fd_sc_hd__xnor2_2

* cell sky130_fd_sc_hd__inv_2
* pin VPB
* pin VGND
* pin VPWR
* pin Y
* pin A
* pin sky130_gnd
.SUBCKT sky130_fd_sc_hd__inv_2 VPB VGND VPWR Y A sky130_gnd
* device instance $1 r0 *1 0.48,1.985 sky130_fd_pr__pfet_01v8_hvt
XM$1 VPWR A Y VPB sky130_fd_pr__pfet_01v8_hvt L=150000 W=1000000
+ AS=260000000000 AD=135000000000 PS=2520000 PD=1270000
* device instance $2 r0 *1 0.9,1.985 sky130_fd_pr__pfet_01v8_hvt
XM$2 Y A VPWR VPB sky130_fd_pr__pfet_01v8_hvt L=150000 W=1000000
+ AS=135000000000 AD=260000000000 PS=1270000 PD=2520000
* device instance $3 r0 *1 0.48,0.56 sky130_fd_pr__nfet_01v8
XM$3 VGND A Y sky130_gnd sky130_fd_pr__nfet_01v8 L=150000 W=650000
+ AS=169000000000 AD=87750000000 PS=1820000 PD=920000
* device instance $4 r0 *1 0.9,0.56 sky130_fd_pr__nfet_01v8
XM$4 Y A VGND sky130_gnd sky130_fd_pr__nfet_01v8 L=150000 W=650000
+ AS=87750000000 AD=169000000000 PS=920000 PD=1820000
.ENDS sky130_fd_sc_hd__inv_2

* cell sky130_fd_sc_hd__a21boi_2
* pin VGND
* pin B1_N
* pin Y
* pin A2
* pin A1
* pin VPWR
* pin VPB
* pin sky130_gnd
.SUBCKT sky130_fd_sc_hd__a21boi_2 VGND B1_N Y A2 A1 VPWR VPB sky130_gnd
* device instance $1 r0 *1 1.42,1.985 sky130_fd_pr__pfet_01v8_hvt
XM$1 \$11 \$4 Y VPB sky130_fd_pr__pfet_01v8_hvt L=150000 W=1000000
+ AS=260000000000 AD=135000000000 PS=2520000 PD=1270000
* device instance $2 r0 *1 1.84,1.985 sky130_fd_pr__pfet_01v8_hvt
XM$2 Y \$4 \$11 VPB sky130_fd_pr__pfet_01v8_hvt L=150000 W=1000000
+ AS=135000000000 AD=135000000000 PS=1270000 PD=1270000
* device instance $3 r0 *1 2.26,1.985 sky130_fd_pr__pfet_01v8_hvt
XM$3 \$11 A2 VPWR VPB sky130_fd_pr__pfet_01v8_hvt L=150000 W=1000000
+ AS=135000000000 AD=135000000000 PS=1270000 PD=1270000
* device instance $4 r0 *1 2.68,1.985 sky130_fd_pr__pfet_01v8_hvt
XM$4 VPWR A1 \$11 VPB sky130_fd_pr__pfet_01v8_hvt L=150000 W=1000000
+ AS=135000000000 AD=140000000000 PS=1270000 PD=1280000
* device instance $5 r0 *1 3.11,1.985 sky130_fd_pr__pfet_01v8_hvt
XM$5 \$11 A1 VPWR VPB sky130_fd_pr__pfet_01v8_hvt L=150000 W=1000000
+ AS=140000000000 AD=140000000000 PS=1280000 PD=1280000
* device instance $6 r0 *1 3.54,1.985 sky130_fd_pr__pfet_01v8_hvt
XM$6 VPWR A2 \$11 VPB sky130_fd_pr__pfet_01v8_hvt L=150000 W=1000000
+ AS=140000000000 AD=285000000000 PS=1280000 PD=2570000
* device instance $7 r0 *1 0.475,2.1 sky130_fd_pr__pfet_01v8_hvt
XM$7 VPWR B1_N \$4 VPB sky130_fd_pr__pfet_01v8_hvt L=150000 W=420000
+ AS=111300000000 AD=111300000000 PS=1370000 PD=1370000
* device instance $8 r0 *1 0.68,0.445 sky130_fd_pr__nfet_01v8
XM$8 \$4 B1_N VGND sky130_gnd sky130_fd_pr__nfet_01v8 L=150000 W=420000
+ AS=126000000000 AD=183125000000 PS=1440000 PD=1240000
* device instance $9 r0 *1 1.42,0.56 sky130_fd_pr__nfet_01v8
XM$9 VGND \$4 Y sky130_gnd sky130_fd_pr__nfet_01v8 L=150000 W=650000
+ AS=183125000000 AD=87750000000 PS=1240000 PD=920000
* device instance $10 r0 *1 1.84,0.56 sky130_fd_pr__nfet_01v8
XM$10 Y \$4 VGND sky130_gnd sky130_fd_pr__nfet_01v8 L=150000 W=650000
+ AS=87750000000 AD=107250000000 PS=920000 PD=980000
* device instance $11 r0 *1 2.32,0.56 sky130_fd_pr__nfet_01v8
XM$11 VGND A2 \$9 sky130_gnd sky130_fd_pr__nfet_01v8 L=150000 W=650000
+ AS=107250000000 AD=68250000000 PS=980000 PD=860000
* device instance $12 r0 *1 2.68,0.56 sky130_fd_pr__nfet_01v8
XM$12 \$9 A1 Y sky130_gnd sky130_fd_pr__nfet_01v8 L=150000 W=650000
+ AS=68250000000 AD=91000000000 PS=860000 PD=930000
* device instance $13 r0 *1 3.11,0.56 sky130_fd_pr__nfet_01v8
XM$13 Y A1 \$8 sky130_gnd sky130_fd_pr__nfet_01v8 L=150000 W=650000
+ AS=91000000000 AD=91000000000 PS=930000 PD=930000
* device instance $14 r0 *1 3.54,0.56 sky130_fd_pr__nfet_01v8
XM$14 \$8 A2 VGND sky130_gnd sky130_fd_pr__nfet_01v8 L=150000 W=650000
+ AS=91000000000 AD=185250000000 PS=930000 PD=1870000
.ENDS sky130_fd_sc_hd__a21boi_2

* cell sky130_fd_sc_hd__and2_2
* pin VPB
* pin VPWR
* pin A
* pin B
* pin X
* pin VGND
* pin sky130_gnd
.SUBCKT sky130_fd_sc_hd__and2_2 VPB VPWR A B X VGND sky130_gnd
* device instance $1 r0 *1 0.66,2.065 sky130_fd_pr__pfet_01v8_hvt
XM$1 VPWR A \$2 VPB sky130_fd_pr__pfet_01v8_hvt L=150000 W=420000
+ AS=117600000000 AD=56700000000 PS=1400000 PD=690000
* device instance $2 r0 *1 1.08,2.065 sky130_fd_pr__pfet_01v8_hvt
XM$2 VPWR B \$2 VPB sky130_fd_pr__pfet_01v8_hvt L=150000 W=420000
+ AS=166550000000 AD=56700000000 PS=1390000 PD=690000
* device instance $3 r0 *1 1.62,1.985 sky130_fd_pr__pfet_01v8_hvt
XM$3 VPWR \$2 X VPB sky130_fd_pr__pfet_01v8_hvt L=150000 W=1000000
+ AS=166550000000 AD=195000000000 PS=1390000 PD=1390000
* device instance $4 r0 *1 2.16,1.985 sky130_fd_pr__pfet_01v8_hvt
XM$4 X \$2 VPWR VPB sky130_fd_pr__pfet_01v8_hvt L=150000 W=1000000
+ AS=195000000000 AD=380000000000 PS=1390000 PD=2760000
* device instance $5 r0 *1 0.66,0.585 sky130_fd_pr__nfet_01v8
XM$5 \$2 A \$9 sky130_gnd sky130_fd_pr__nfet_01v8 L=150000 W=420000
+ AS=117600000000 AD=56700000000 PS=1400000 PD=690000
* device instance $6 r0 *1 1.08,0.585 sky130_fd_pr__nfet_01v8
XM$6 VGND B \$9 sky130_gnd sky130_fd_pr__nfet_01v8 L=150000 W=420000
+ AS=111800000000 AD=56700000000 PS=1040000 PD=690000
* device instance $7 r0 *1 1.62,0.56 sky130_fd_pr__nfet_01v8
XM$7 VGND \$2 X sky130_gnd sky130_fd_pr__nfet_01v8 L=150000 W=650000
+ AS=111800000000 AD=126750000000 PS=1040000 PD=1040000
* device instance $8 r0 *1 2.16,0.56 sky130_fd_pr__nfet_01v8
XM$8 X \$2 VGND sky130_gnd sky130_fd_pr__nfet_01v8 L=150000 W=650000
+ AS=126750000000 AD=247000000000 PS=1040000 PD=2060000
.ENDS sky130_fd_sc_hd__and2_2

* cell sky130_fd_sc_hd__a22o_2
* pin VGND
* pin B2
* pin B1
* pin A1
* pin A2
* pin X
* pin VPWR
* pin VPB
* pin sky130_gnd
.SUBCKT sky130_fd_sc_hd__a22o_2 VGND B2 B1 A1 A2 X VPWR VPB sky130_gnd
* device instance $1 r0 *1 1.83,1.985 sky130_fd_pr__pfet_01v8_hvt
XM$1 VPWR A1 \$11 VPB sky130_fd_pr__pfet_01v8_hvt L=150000 W=1000000
+ AS=260000000000 AD=165000000000 PS=2520000 PD=1330000
* device instance $2 r0 *1 2.31,1.985 sky130_fd_pr__pfet_01v8_hvt
XM$2 \$11 A2 VPWR VPB sky130_fd_pr__pfet_01v8_hvt L=150000 W=1000000
+ AS=165000000000 AD=157500000000 PS=1330000 PD=1315000
* device instance $3 r0 *1 2.775,1.985 sky130_fd_pr__pfet_01v8_hvt
XM$3 VPWR \$5 X VPB sky130_fd_pr__pfet_01v8_hvt L=150000 W=1000000
+ AS=157500000000 AD=135000000000 PS=1315000 PD=1270000
* device instance $4 r0 *1 3.195,1.985 sky130_fd_pr__pfet_01v8_hvt
XM$4 X \$5 VPWR VPB sky130_fd_pr__pfet_01v8_hvt L=150000 W=1000000
+ AS=135000000000 AD=270000000000 PS=1270000 PD=2540000
* device instance $5 r0 *1 0.47,1.985 sky130_fd_pr__pfet_01v8_hvt
XM$5 \$5 B2 \$11 VPB sky130_fd_pr__pfet_01v8_hvt L=150000 W=1000000
+ AS=260000000000 AD=135000000000 PS=2520000 PD=1270000
* device instance $6 r0 *1 0.89,1.985 sky130_fd_pr__pfet_01v8_hvt
XM$6 \$11 B1 \$5 VPB sky130_fd_pr__pfet_01v8_hvt L=150000 W=1000000
+ AS=135000000000 AD=260000000000 PS=1270000 PD=2520000
* device instance $7 r0 *1 1.83,0.56 sky130_fd_pr__nfet_01v8
XM$7 \$5 A1 \$10 sky130_gnd sky130_fd_pr__nfet_01v8 L=150000 W=650000
+ AS=169000000000 AD=107250000000 PS=1820000 PD=980000
* device instance $8 r0 *1 2.31,0.56 sky130_fd_pr__nfet_01v8
XM$8 \$10 A2 VGND sky130_gnd sky130_fd_pr__nfet_01v8 L=150000 W=650000
+ AS=107250000000 AD=102375000000 PS=980000 PD=965000
* device instance $9 r0 *1 2.775,0.56 sky130_fd_pr__nfet_01v8
XM$9 VGND \$5 X sky130_gnd sky130_fd_pr__nfet_01v8 L=150000 W=650000
+ AS=102375000000 AD=87750000000 PS=965000 PD=920000
* device instance $10 r0 *1 3.195,0.56 sky130_fd_pr__nfet_01v8
XM$10 X \$5 VGND sky130_gnd sky130_fd_pr__nfet_01v8 L=150000 W=650000
+ AS=87750000000 AD=175500000000 PS=920000 PD=1840000
* device instance $11 r0 *1 0.47,0.56 sky130_fd_pr__nfet_01v8
XM$11 VGND B2 \$9 sky130_gnd sky130_fd_pr__nfet_01v8 L=150000 W=650000
+ AS=169000000000 AD=74750000000 PS=1820000 PD=880000
* device instance $12 r0 *1 0.85,0.56 sky130_fd_pr__nfet_01v8
XM$12 \$9 B1 \$5 sky130_gnd sky130_fd_pr__nfet_01v8 L=150000 W=650000
+ AS=74750000000 AD=169000000000 PS=880000 PD=1820000
.ENDS sky130_fd_sc_hd__a22o_2

* cell sky130_fd_sc_hd__nand2_2
* pin VPB
* pin VPWR
* pin Y
* pin B
* pin VGND
* pin A
* pin sky130_gnd
.SUBCKT sky130_fd_sc_hd__nand2_2 VPB VPWR Y B VGND A sky130_gnd
* device instance $1 r0 *1 0.47,1.985 sky130_fd_pr__pfet_01v8_hvt
XM$1 VPWR B Y VPB sky130_fd_pr__pfet_01v8_hvt L=150000 W=1000000
+ AS=260000000000 AD=135000000000 PS=2520000 PD=1270000
* device instance $2 r0 *1 0.89,1.985 sky130_fd_pr__pfet_01v8_hvt
XM$2 Y B VPWR VPB sky130_fd_pr__pfet_01v8_hvt L=150000 W=1000000
+ AS=135000000000 AD=135000000000 PS=1270000 PD=1270000
* device instance $3 r0 *1 1.31,1.985 sky130_fd_pr__pfet_01v8_hvt
XM$3 VPWR A Y VPB sky130_fd_pr__pfet_01v8_hvt L=150000 W=1000000
+ AS=135000000000 AD=135000000000 PS=1270000 PD=1270000
* device instance $4 r0 *1 1.73,1.985 sky130_fd_pr__pfet_01v8_hvt
XM$4 Y A VPWR VPB sky130_fd_pr__pfet_01v8_hvt L=150000 W=1000000
+ AS=135000000000 AD=260000000000 PS=1270000 PD=2520000
* device instance $5 r0 *1 0.47,0.56 sky130_fd_pr__nfet_01v8
XM$5 \$3 B VGND sky130_gnd sky130_fd_pr__nfet_01v8 L=150000 W=650000
+ AS=169000000000 AD=87750000000 PS=1820000 PD=920000
* device instance $6 r0 *1 0.89,0.56 sky130_fd_pr__nfet_01v8
XM$6 VGND B \$3 sky130_gnd sky130_fd_pr__nfet_01v8 L=150000 W=650000
+ AS=87750000000 AD=87750000000 PS=920000 PD=920000
* device instance $7 r0 *1 1.31,0.56 sky130_fd_pr__nfet_01v8
XM$7 \$3 A Y sky130_gnd sky130_fd_pr__nfet_01v8 L=150000 W=650000
+ AS=87750000000 AD=87750000000 PS=920000 PD=920000
* device instance $8 r0 *1 1.73,0.56 sky130_fd_pr__nfet_01v8
XM$8 Y A \$3 sky130_gnd sky130_fd_pr__nfet_01v8 L=150000 W=650000
+ AS=87750000000 AD=169000000000 PS=920000 PD=1820000
.ENDS sky130_fd_sc_hd__nand2_2

* cell sky130_fd_sc_hd__a21oi_2
* pin VPB
* pin VPWR
* pin A1
* pin Y
* pin A2
* pin VGND
* pin B1
* pin sky130_gnd
.SUBCKT sky130_fd_sc_hd__a21oi_2 VPB VPWR A1 Y A2 VGND B1 sky130_gnd
* device instance $1 r0 *1 0.49,1.985 sky130_fd_pr__pfet_01v8_hvt
XM$1 \$4 A2 VPWR VPB sky130_fd_pr__pfet_01v8_hvt L=150000 W=1000000
+ AS=280000000000 AD=140000000000 PS=2560000 PD=1280000
* device instance $2 r0 *1 0.92,1.985 sky130_fd_pr__pfet_01v8_hvt
XM$2 VPWR A1 \$4 VPB sky130_fd_pr__pfet_01v8_hvt L=150000 W=1000000
+ AS=140000000000 AD=140000000000 PS=1280000 PD=1280000
* device instance $3 r0 *1 1.35,1.985 sky130_fd_pr__pfet_01v8_hvt
XM$3 \$4 A1 VPWR VPB sky130_fd_pr__pfet_01v8_hvt L=150000 W=1000000
+ AS=140000000000 AD=135000000000 PS=1280000 PD=1270000
* device instance $4 r0 *1 1.77,1.985 sky130_fd_pr__pfet_01v8_hvt
XM$4 VPWR A2 \$4 VPB sky130_fd_pr__pfet_01v8_hvt L=150000 W=1000000
+ AS=135000000000 AD=135000000000 PS=1270000 PD=1270000
* device instance $5 r0 *1 2.19,1.985 sky130_fd_pr__pfet_01v8_hvt
XM$5 \$4 B1 Y VPB sky130_fd_pr__pfet_01v8_hvt L=150000 W=1000000
+ AS=135000000000 AD=135000000000 PS=1270000 PD=1270000
* device instance $6 r0 *1 2.61,1.985 sky130_fd_pr__pfet_01v8_hvt
XM$6 Y B1 \$4 VPB sky130_fd_pr__pfet_01v8_hvt L=150000 W=1000000
+ AS=135000000000 AD=360000000000 PS=1270000 PD=2720000
* device instance $7 r0 *1 0.495,0.56 sky130_fd_pr__nfet_01v8
XM$7 VGND A2 \$10 sky130_gnd sky130_fd_pr__nfet_01v8 L=150000 W=650000
+ AS=185250000000 AD=89375000000 PS=1870000 PD=925000
* device instance $8 r0 *1 0.92,0.56 sky130_fd_pr__nfet_01v8
XM$8 \$10 A1 Y sky130_gnd sky130_fd_pr__nfet_01v8 L=150000 W=650000
+ AS=89375000000 AD=91000000000 PS=925000 PD=930000
* device instance $9 r0 *1 1.35,0.56 sky130_fd_pr__nfet_01v8
XM$9 Y A1 \$11 sky130_gnd sky130_fd_pr__nfet_01v8 L=150000 W=650000
+ AS=91000000000 AD=68250000000 PS=930000 PD=860000
* device instance $10 r0 *1 1.71,0.56 sky130_fd_pr__nfet_01v8
XM$10 \$11 A2 VGND sky130_gnd sky130_fd_pr__nfet_01v8 L=150000 W=650000
+ AS=68250000000 AD=107250000000 PS=860000 PD=980000
* device instance $11 r0 *1 2.19,0.56 sky130_fd_pr__nfet_01v8
XM$11 VGND B1 Y sky130_gnd sky130_fd_pr__nfet_01v8 L=150000 W=650000
+ AS=107250000000 AD=87750000000 PS=980000 PD=920000
* device instance $12 r0 *1 2.61,0.56 sky130_fd_pr__nfet_01v8
XM$12 Y B1 VGND sky130_gnd sky130_fd_pr__nfet_01v8 L=150000 W=650000
+ AS=87750000000 AD=260000000000 PS=920000 PD=2100000
.ENDS sky130_fd_sc_hd__a21oi_2

* cell sky130_fd_sc_hd__xor2_2
* pin VGND
* pin A
* pin B
* pin X
* pin VPWR
* pin VPB
* pin sky130_gnd
.SUBCKT sky130_fd_sc_hd__xor2_2 VGND A B X VPWR VPB sky130_gnd
* device instance $1 r0 *1 4.94,1.985 sky130_fd_pr__pfet_01v8_hvt
XM$1 \$8 \$3 X VPB sky130_fd_pr__pfet_01v8_hvt L=150000 W=1000000
+ AS=260000000000 AD=135000000000 PS=2520000 PD=1270000
* device instance $2 r0 *1 5.36,1.985 sky130_fd_pr__pfet_01v8_hvt
XM$2 X \$3 \$8 VPB sky130_fd_pr__pfet_01v8_hvt L=150000 W=1000000
+ AS=135000000000 AD=280000000000 PS=1270000 PD=2560000
* device instance $3 r0 *1 2.685,1.985 sky130_fd_pr__pfet_01v8_hvt
XM$3 \$8 A VPWR VPB sky130_fd_pr__pfet_01v8_hvt L=150000 W=1000000
+ AS=260000000000 AD=135000000000 PS=2520000 PD=1270000
* device instance $4 r0 *1 3.105,1.985 sky130_fd_pr__pfet_01v8_hvt
XM$4 VPWR A \$8 VPB sky130_fd_pr__pfet_01v8_hvt L=150000 W=1000000
+ AS=135000000000 AD=135000000000 PS=1270000 PD=1270000
* device instance $5 r0 *1 3.525,1.985 sky130_fd_pr__pfet_01v8_hvt
XM$5 \$8 B VPWR VPB sky130_fd_pr__pfet_01v8_hvt L=150000 W=1000000
+ AS=135000000000 AD=162500000000 PS=1270000 PD=1325000
* device instance $6 r0 *1 4,1.985 sky130_fd_pr__pfet_01v8_hvt
XM$6 VPWR B \$8 VPB sky130_fd_pr__pfet_01v8_hvt L=150000 W=1000000
+ AS=162500000000 AD=260000000000 PS=1325000 PD=2520000
* device instance $7 r0 *1 0.485,1.985 sky130_fd_pr__pfet_01v8_hvt
XM$7 \$9 A VPWR VPB sky130_fd_pr__pfet_01v8_hvt L=150000 W=1000000
+ AS=275000000000 AD=135000000000 PS=2550000 PD=1270000
* device instance $8 r0 *1 0.905,1.985 sky130_fd_pr__pfet_01v8_hvt
XM$8 VPWR A \$9 VPB sky130_fd_pr__pfet_01v8_hvt L=150000 W=1000000
+ AS=135000000000 AD=135000000000 PS=1270000 PD=1270000
* device instance $9 r0 *1 1.325,1.985 sky130_fd_pr__pfet_01v8_hvt
XM$9 \$9 B \$3 VPB sky130_fd_pr__pfet_01v8_hvt L=150000 W=1000000
+ AS=135000000000 AD=135000000000 PS=1270000 PD=1270000
* device instance $10 r0 *1 1.745,1.985 sky130_fd_pr__pfet_01v8_hvt
XM$10 \$3 B \$9 VPB sky130_fd_pr__pfet_01v8_hvt L=150000 W=1000000
+ AS=135000000000 AD=260000000000 PS=1270000 PD=2520000
* device instance $11 r0 *1 4.94,0.56 sky130_fd_pr__nfet_01v8
XM$11 VGND \$3 X sky130_gnd sky130_fd_pr__nfet_01v8 L=150000 W=650000
+ AS=169000000000 AD=87750000000 PS=1820000 PD=920000
* device instance $12 r0 *1 5.36,0.56 sky130_fd_pr__nfet_01v8
XM$12 X \$3 VGND sky130_gnd sky130_fd_pr__nfet_01v8 L=150000 W=650000
+ AS=87750000000 AD=169000000000 PS=920000 PD=1820000
* device instance $13 r0 *1 2.685,0.56 sky130_fd_pr__nfet_01v8
XM$13 \$6 A VGND sky130_gnd sky130_fd_pr__nfet_01v8 L=150000 W=650000
+ AS=169000000000 AD=87750000000 PS=1820000 PD=920000
* device instance $14 r0 *1 3.105,0.56 sky130_fd_pr__nfet_01v8
XM$14 VGND A \$6 sky130_gnd sky130_fd_pr__nfet_01v8 L=150000 W=650000
+ AS=87750000000 AD=87750000000 PS=920000 PD=920000
* device instance $15 r0 *1 3.525,0.56 sky130_fd_pr__nfet_01v8
XM$15 \$6 B X sky130_gnd sky130_fd_pr__nfet_01v8 L=150000 W=650000
+ AS=87750000000 AD=105625000000 PS=920000 PD=975000
* device instance $16 r0 *1 4,0.56 sky130_fd_pr__nfet_01v8
XM$16 X B \$6 sky130_gnd sky130_fd_pr__nfet_01v8 L=150000 W=650000
+ AS=105625000000 AD=169000000000 PS=975000 PD=1820000
* device instance $17 r0 *1 0.485,0.56 sky130_fd_pr__nfet_01v8
XM$17 VGND A \$3 sky130_gnd sky130_fd_pr__nfet_01v8 L=150000 W=650000
+ AS=178750000000 AD=87750000000 PS=1850000 PD=920000
* device instance $18 r0 *1 0.905,0.56 sky130_fd_pr__nfet_01v8
XM$18 \$3 A VGND sky130_gnd sky130_fd_pr__nfet_01v8 L=150000 W=650000
+ AS=87750000000 AD=87750000000 PS=920000 PD=920000
* device instance $19 r0 *1 1.325,0.56 sky130_fd_pr__nfet_01v8
XM$19 VGND B \$3 sky130_gnd sky130_fd_pr__nfet_01v8 L=150000 W=650000
+ AS=87750000000 AD=87750000000 PS=920000 PD=920000
* device instance $20 r0 *1 1.745,0.56 sky130_fd_pr__nfet_01v8
XM$20 \$3 B VGND sky130_gnd sky130_fd_pr__nfet_01v8 L=150000 W=650000
+ AS=87750000000 AD=169000000000 PS=920000 PD=1820000
.ENDS sky130_fd_sc_hd__xor2_2

* cell sky130_fd_sc_hd__a21o_2
* pin VPB
* pin VPWR
* pin VGND
* pin X
* pin B1
* pin A1
* pin A2
* pin sky130_gnd
.SUBCKT sky130_fd_sc_hd__a21o_2 VPB VPWR VGND X B1 A1 A2 sky130_gnd
* device instance $1 r0 *1 1.855,1.985 sky130_fd_pr__pfet_01v8_hvt
XM$1 \$6 B1 \$2 VPB sky130_fd_pr__pfet_01v8_hvt L=150000 W=1000000
+ AS=265000000000 AD=140000000000 PS=2530000 PD=1280000
* device instance $2 r0 *1 2.285,1.985 sky130_fd_pr__pfet_01v8_hvt
XM$2 \$2 A1 VPWR VPB sky130_fd_pr__pfet_01v8_hvt L=150000 W=1000000
+ AS=140000000000 AD=157500000000 PS=1280000 PD=1315000
* device instance $3 r0 *1 2.75,1.985 sky130_fd_pr__pfet_01v8_hvt
XM$3 VPWR A2 \$2 VPB sky130_fd_pr__pfet_01v8_hvt L=150000 W=1000000
+ AS=157500000000 AD=260000000000 PS=1315000 PD=2520000
* device instance $4 r0 *1 0.475,1.985 sky130_fd_pr__pfet_01v8_hvt
XM$4 VPWR \$6 X VPB sky130_fd_pr__pfet_01v8_hvt L=150000 W=1000000
+ AS=265000000000 AD=140000000000 PS=2530000 PD=1280000
* device instance $5 r0 *1 0.905,1.985 sky130_fd_pr__pfet_01v8_hvt
XM$5 X \$6 VPWR VPB sky130_fd_pr__pfet_01v8_hvt L=150000 W=1000000
+ AS=140000000000 AD=265000000000 PS=1280000 PD=2530000
* device instance $6 r0 *1 0.645,0.56 sky130_fd_pr__nfet_01v8
XM$6 VGND \$6 X sky130_gnd sky130_fd_pr__nfet_01v8 L=150000 W=650000
+ AS=172250000000 AD=91000000000 PS=1830000 PD=930000
* device instance $7 r0 *1 1.075,0.56 sky130_fd_pr__nfet_01v8
XM$7 X \$6 VGND sky130_gnd sky130_fd_pr__nfet_01v8 L=150000 W=650000
+ AS=91000000000 AD=110500000000 PS=930000 PD=990000
* device instance $8 r0 *1 1.565,0.56 sky130_fd_pr__nfet_01v8
XM$8 VGND B1 \$6 sky130_gnd sky130_fd_pr__nfet_01v8 L=150000 W=650000
+ AS=110500000000 AD=162500000000 PS=990000 PD=1150000
* device instance $9 r0 *1 2.215,0.56 sky130_fd_pr__nfet_01v8
XM$9 \$6 A1 \$11 sky130_gnd sky130_fd_pr__nfet_01v8 L=150000 W=650000
+ AS=162500000000 AD=123500000000 PS=1150000 PD=1030000
* device instance $10 r0 *1 2.745,0.56 sky130_fd_pr__nfet_01v8
XM$10 \$11 A2 VGND sky130_gnd sky130_fd_pr__nfet_01v8 L=150000 W=650000
+ AS=123500000000 AD=172250000000 PS=1030000 PD=1830000
.ENDS sky130_fd_sc_hd__a21o_2

* cell sky130_fd_sc_hd__or4_2
* pin VPB
* pin VGND
* pin C
* pin B
* pin A
* pin VPWR
* pin X
* pin D
* pin sky130_gnd
.SUBCKT sky130_fd_sc_hd__or4_2 VPB VGND C B A VPWR X D sky130_gnd
* device instance $1 r0 *1 0.47,1.695 sky130_fd_pr__pfet_01v8_hvt
XM$1 \$5 D \$13 VPB sky130_fd_pr__pfet_01v8_hvt L=150000 W=420000
+ AS=109200000000 AD=69300000000 PS=1360000 PD=750000
* device instance $2 r0 *1 0.95,1.695 sky130_fd_pr__pfet_01v8_hvt
XM$2 \$13 C \$12 VPB sky130_fd_pr__pfet_01v8_hvt L=150000 W=420000
+ AS=69300000000 AD=44100000000 PS=750000 PD=630000
* device instance $3 r0 *1 1.31,1.695 sky130_fd_pr__pfet_01v8_hvt
XM$3 \$12 B \$11 VPB sky130_fd_pr__pfet_01v8_hvt L=150000 W=420000
+ AS=44100000000 AD=69300000000 PS=630000 PD=750000
* device instance $4 r0 *1 1.79,1.695 sky130_fd_pr__pfet_01v8_hvt
XM$4 \$11 A VPWR VPB sky130_fd_pr__pfet_01v8_hvt L=150000 W=420000
+ AS=69300000000 AD=148250000000 PS=750000 PD=1340000
* device instance $5 r0 *1 2.28,1.985 sky130_fd_pr__pfet_01v8_hvt
XM$5 VPWR \$5 X VPB sky130_fd_pr__pfet_01v8_hvt L=150000 W=1000000
+ AS=148250000000 AD=135000000000 PS=1340000 PD=1270000
* device instance $6 r0 *1 2.7,1.985 sky130_fd_pr__pfet_01v8_hvt
XM$6 X \$5 VPWR VPB sky130_fd_pr__pfet_01v8_hvt L=150000 W=1000000
+ AS=135000000000 AD=305000000000 PS=1270000 PD=2610000
* device instance $7 r0 *1 0.47,0.475 sky130_fd_pr__nfet_01v8
XM$7 VGND D \$5 sky130_gnd sky130_fd_pr__nfet_01v8 L=150000 W=420000
+ AS=109200000000 AD=69300000000 PS=1360000 PD=750000
* device instance $8 r0 *1 0.95,0.475 sky130_fd_pr__nfet_01v8
XM$8 \$5 C VGND sky130_gnd sky130_fd_pr__nfet_01v8 L=150000 W=420000
+ AS=69300000000 AD=56700000000 PS=750000 PD=690000
* device instance $9 r0 *1 1.37,0.475 sky130_fd_pr__nfet_01v8
XM$9 VGND B \$5 sky130_gnd sky130_fd_pr__nfet_01v8 L=150000 W=420000
+ AS=56700000000 AD=56700000000 PS=690000 PD=690000
* device instance $10 r0 *1 1.79,0.475 sky130_fd_pr__nfet_01v8
XM$10 VGND A \$5 sky130_gnd sky130_fd_pr__nfet_01v8 L=150000 W=420000
+ AS=101875000000 AD=56700000000 PS=990000 PD=690000
* device instance $11 r0 *1 2.28,0.56 sky130_fd_pr__nfet_01v8
XM$11 VGND \$5 X sky130_gnd sky130_fd_pr__nfet_01v8 L=150000 W=650000
+ AS=101875000000 AD=87750000000 PS=990000 PD=920000
* device instance $12 r0 *1 2.7,0.56 sky130_fd_pr__nfet_01v8
XM$12 X \$5 VGND sky130_gnd sky130_fd_pr__nfet_01v8 L=150000 W=650000
+ AS=87750000000 AD=198250000000 PS=920000 PD=1910000
.ENDS sky130_fd_sc_hd__or4_2

* cell sky130_fd_sc_hd__or2_2
* pin VPB
* pin X
* pin VPWR
* pin VGND
* pin B
* pin A
* pin sky130_gnd
.SUBCKT sky130_fd_sc_hd__or2_2 VPB X VPWR VGND B A sky130_gnd
* device instance $1 r0 *1 0.53,1.695 sky130_fd_pr__pfet_01v8_hvt
XM$1 \$3 B \$9 VPB sky130_fd_pr__pfet_01v8_hvt L=150000 W=420000
+ AS=109200000000 AD=44100000000 PS=1360000 PD=630000
* device instance $2 r0 *1 0.89,1.695 sky130_fd_pr__pfet_01v8_hvt
XM$2 \$9 A VPWR VPB sky130_fd_pr__pfet_01v8_hvt L=150000 W=420000
+ AS=44100000000 AD=155750000000 PS=630000 PD=1355000
* device instance $3 r0 *1 1.395,1.985 sky130_fd_pr__pfet_01v8_hvt
XM$3 VPWR \$3 X VPB sky130_fd_pr__pfet_01v8_hvt L=150000 W=1000000
+ AS=155750000000 AD=135000000000 PS=1355000 PD=1270000
* device instance $4 r0 *1 1.815,1.985 sky130_fd_pr__pfet_01v8_hvt
XM$4 X \$3 VPWR VPB sky130_fd_pr__pfet_01v8_hvt L=150000 W=1000000
+ AS=135000000000 AD=260000000000 PS=1270000 PD=2520000
* device instance $5 r0 *1 0.47,0.445 sky130_fd_pr__nfet_01v8
XM$5 VGND B \$3 sky130_gnd sky130_fd_pr__nfet_01v8 L=150000 W=420000
+ AS=109200000000 AD=56700000000 PS=1360000 PD=690000
* device instance $6 r0 *1 0.89,0.445 sky130_fd_pr__nfet_01v8
XM$6 \$3 A VGND sky130_gnd sky130_fd_pr__nfet_01v8 L=150000 W=420000
+ AS=56700000000 AD=106750000000 PS=690000 PD=1005000
* device instance $7 r0 *1 1.395,0.56 sky130_fd_pr__nfet_01v8
XM$7 VGND \$3 X sky130_gnd sky130_fd_pr__nfet_01v8 L=150000 W=650000
+ AS=106750000000 AD=87750000000 PS=1005000 PD=920000
* device instance $8 r0 *1 1.815,0.56 sky130_fd_pr__nfet_01v8
XM$8 X \$3 VGND sky130_gnd sky130_fd_pr__nfet_01v8 L=150000 W=650000
+ AS=87750000000 AD=169000000000 PS=920000 PD=1820000
.ENDS sky130_fd_sc_hd__or2_2

* cell VIA_via3_4_2000_480_1_5_400_400
* pin
.SUBCKT VIA_via3_4_2000_480_1_5_400_400 \$1
.ENDS VIA_via3_4_2000_480_1_5_400_400

* cell VIA_via4_5_2000_480_1_5_400_400
* pin
.SUBCKT VIA_via4_5_2000_480_1_5_400_400 \$1
.ENDS VIA_via4_5_2000_480_1_5_400_400

* cell VIA_via2_3_2000_480_1_6_320_320
* pin
.SUBCKT VIA_via2_3_2000_480_1_6_320_320 \$1
.ENDS VIA_via2_3_2000_480_1_6_320_320

* cell VIA_L1M1_PR_MR
* pin
.SUBCKT VIA_L1M1_PR_MR \$1
.ENDS VIA_L1M1_PR_MR

* cell sky130_fd_sc_hd__o21a_2
* pin VPB
* pin VGND
* pin VPWR
* pin X
* pin B1
* pin A2
* pin A1
* pin sky130_gnd
.SUBCKT sky130_fd_sc_hd__o21a_2 VPB VGND VPWR X B1 A2 A1 sky130_gnd
* device instance $1 r0 *1 0.47,1.985 sky130_fd_pr__pfet_01v8_hvt
XM$1 VPWR \$5 X VPB sky130_fd_pr__pfet_01v8_hvt L=150000 W=1000000
+ AS=260000000000 AD=137500000000 PS=2520000 PD=1275000
* device instance $2 r0 *1 0.895,1.985 sky130_fd_pr__pfet_01v8_hvt
XM$2 X \$5 VPWR VPB sky130_fd_pr__pfet_01v8_hvt L=150000 W=1000000
+ AS=137500000000 AD=400000000000 PS=1275000 PD=1800000
* device instance $3 r0 *1 1.845,1.985 sky130_fd_pr__pfet_01v8_hvt
XM$3 VPWR B1 \$5 VPB sky130_fd_pr__pfet_01v8_hvt L=150000 W=1000000
+ AS=400000000000 AD=140000000000 PS=1800000 PD=1280000
* device instance $4 r0 *1 2.275,1.985 sky130_fd_pr__pfet_01v8_hvt
XM$4 \$5 A2 \$11 VPB sky130_fd_pr__pfet_01v8_hvt L=150000 W=1000000
+ AS=140000000000 AD=160000000000 PS=1280000 PD=1320000
* device instance $5 r0 *1 2.745,1.985 sky130_fd_pr__pfet_01v8_hvt
XM$5 \$11 A1 VPWR VPB sky130_fd_pr__pfet_01v8_hvt L=150000 W=1000000
+ AS=160000000000 AD=265000000000 PS=1320000 PD=2530000
* device instance $6 r0 *1 1.845,0.56 sky130_fd_pr__nfet_01v8
XM$6 \$5 B1 \$7 sky130_gnd sky130_fd_pr__nfet_01v8 L=150000 W=650000
+ AS=172250000000 AD=91000000000 PS=1830000 PD=930000
* device instance $7 r0 *1 2.275,0.56 sky130_fd_pr__nfet_01v8
XM$7 \$7 A2 VGND sky130_gnd sky130_fd_pr__nfet_01v8 L=150000 W=650000
+ AS=91000000000 AD=104000000000 PS=930000 PD=970000
* device instance $8 r0 *1 2.745,0.56 sky130_fd_pr__nfet_01v8
XM$8 VGND A1 \$7 sky130_gnd sky130_fd_pr__nfet_01v8 L=150000 W=650000
+ AS=104000000000 AD=172250000000 PS=970000 PD=1830000
* device instance $9 r0 *1 0.47,0.56 sky130_fd_pr__nfet_01v8
XM$9 VGND \$5 X sky130_gnd sky130_fd_pr__nfet_01v8 L=150000 W=650000
+ AS=169000000000 AD=89375000000 PS=1820000 PD=925000
* device instance $10 r0 *1 0.895,0.56 sky130_fd_pr__nfet_01v8
XM$10 X \$5 VGND sky130_gnd sky130_fd_pr__nfet_01v8 L=150000 W=650000
+ AS=89375000000 AD=172250000000 PS=925000 PD=1830000
.ENDS sky130_fd_sc_hd__o21a_2

* cell sky130_fd_sc_hd__a31o_2
* pin VPB
* pin X
* pin VPWR
* pin A3
* pin A2
* pin A1
* pin VGND
* pin B1
* pin sky130_gnd
.SUBCKT sky130_fd_sc_hd__a31o_2 VPB X VPWR A3 A2 A1 VGND B1 sky130_gnd
* device instance $1 r0 *1 0.47,1.985 sky130_fd_pr__pfet_01v8_hvt
XM$1 VPWR \$8 X VPB sky130_fd_pr__pfet_01v8_hvt L=150000 W=1000000
+ AS=260000000000 AD=135000000000 PS=2520000 PD=1270000
* device instance $2 r0 *1 0.89,1.985 sky130_fd_pr__pfet_01v8_hvt
XM$2 X \$8 VPWR VPB sky130_fd_pr__pfet_01v8_hvt L=150000 W=1000000
+ AS=135000000000 AD=135000000000 PS=1270000 PD=1270000
* device instance $3 r0 *1 1.31,1.985 sky130_fd_pr__pfet_01v8_hvt
XM$3 VPWR A3 \$5 VPB sky130_fd_pr__pfet_01v8_hvt L=150000 W=1000000
+ AS=135000000000 AD=135000000000 PS=1270000 PD=1270000
* device instance $4 r0 *1 1.73,1.985 sky130_fd_pr__pfet_01v8_hvt
XM$4 \$5 A2 VPWR VPB sky130_fd_pr__pfet_01v8_hvt L=150000 W=1000000
+ AS=135000000000 AD=165000000000 PS=1270000 PD=1330000
* device instance $5 r0 *1 2.21,1.985 sky130_fd_pr__pfet_01v8_hvt
XM$5 VPWR A1 \$5 VPB sky130_fd_pr__pfet_01v8_hvt L=150000 W=1000000
+ AS=165000000000 AD=165000000000 PS=1330000 PD=1330000
* device instance $6 r0 *1 2.69,1.985 sky130_fd_pr__pfet_01v8_hvt
XM$6 \$5 B1 \$8 VPB sky130_fd_pr__pfet_01v8_hvt L=150000 W=1000000
+ AS=165000000000 AD=320000000000 PS=1330000 PD=2640000
* device instance $7 r0 *1 0.47,0.56 sky130_fd_pr__nfet_01v8
XM$7 VGND \$8 X sky130_gnd sky130_fd_pr__nfet_01v8 L=150000 W=650000
+ AS=169000000000 AD=87750000000 PS=1820000 PD=920000
* device instance $8 r0 *1 0.89,0.56 sky130_fd_pr__nfet_01v8
XM$8 X \$8 VGND sky130_gnd sky130_fd_pr__nfet_01v8 L=150000 W=650000
+ AS=87750000000 AD=87750000000 PS=920000 PD=920000
* device instance $9 r0 *1 1.31,0.56 sky130_fd_pr__nfet_01v8
XM$9 VGND A3 \$13 sky130_gnd sky130_fd_pr__nfet_01v8 L=150000 W=650000
+ AS=87750000000 AD=87750000000 PS=920000 PD=920000
* device instance $10 r0 *1 1.73,0.56 sky130_fd_pr__nfet_01v8
XM$10 \$13 A2 \$12 sky130_gnd sky130_fd_pr__nfet_01v8 L=150000 W=650000
+ AS=87750000000 AD=107250000000 PS=920000 PD=980000
* device instance $11 r0 *1 2.21,0.56 sky130_fd_pr__nfet_01v8
XM$11 \$12 A1 \$8 sky130_gnd sky130_fd_pr__nfet_01v8 L=150000 W=650000
+ AS=107250000000 AD=126750000000 PS=980000 PD=1040000
* device instance $12 r0 *1 2.75,0.56 sky130_fd_pr__nfet_01v8
XM$12 \$8 B1 VGND sky130_gnd sky130_fd_pr__nfet_01v8 L=150000 W=650000
+ AS=126750000000 AD=169000000000 PS=1040000 PD=1820000
.ENDS sky130_fd_sc_hd__a31o_2

* cell sky130_fd_sc_hd__a211oi_2
* pin VGND
* pin Y
* pin C1
* pin B1
* pin A1
* pin A2
* pin VPWR
* pin VPB
* pin sky130_gnd
.SUBCKT sky130_fd_sc_hd__a211oi_2 VGND Y C1 B1 A1 A2 VPWR VPB sky130_gnd
* device instance $1 r0 *1 2.765,1.985 sky130_fd_pr__pfet_01v8_hvt
XM$1 VPWR A1 \$10 VPB sky130_fd_pr__pfet_01v8_hvt L=150000 W=1000000
+ AS=265000000000 AD=140000000000 PS=2530000 PD=1280000
* device instance $2 r0 *1 3.195,1.985 sky130_fd_pr__pfet_01v8_hvt
XM$2 \$10 A1 VPWR VPB sky130_fd_pr__pfet_01v8_hvt L=150000 W=1000000
+ AS=140000000000 AD=140000000000 PS=1280000 PD=1280000
* device instance $3 r0 *1 3.625,1.985 sky130_fd_pr__pfet_01v8_hvt
XM$3 VPWR A2 \$10 VPB sky130_fd_pr__pfet_01v8_hvt L=150000 W=1000000
+ AS=140000000000 AD=140000000000 PS=1280000 PD=1280000
* device instance $4 r0 *1 4.055,1.985 sky130_fd_pr__pfet_01v8_hvt
XM$4 \$10 A2 VPWR VPB sky130_fd_pr__pfet_01v8_hvt L=150000 W=1000000
+ AS=140000000000 AD=265000000000 PS=1280000 PD=2530000
* device instance $5 r0 *1 0.525,1.985 sky130_fd_pr__pfet_01v8_hvt
XM$5 \$9 C1 Y VPB sky130_fd_pr__pfet_01v8_hvt L=150000 W=1000000
+ AS=265000000000 AD=140000000000 PS=2530000 PD=1280000
* device instance $6 r0 *1 0.955,1.985 sky130_fd_pr__pfet_01v8_hvt
XM$6 Y C1 \$9 VPB sky130_fd_pr__pfet_01v8_hvt L=150000 W=1000000
+ AS=140000000000 AD=140000000000 PS=1280000 PD=1280000
* device instance $7 r0 *1 1.385,1.985 sky130_fd_pr__pfet_01v8_hvt
XM$7 \$9 B1 \$10 VPB sky130_fd_pr__pfet_01v8_hvt L=150000 W=1000000
+ AS=140000000000 AD=140000000000 PS=1280000 PD=1280000
* device instance $8 r0 *1 1.815,1.985 sky130_fd_pr__pfet_01v8_hvt
XM$8 \$10 B1 \$9 VPB sky130_fd_pr__pfet_01v8_hvt L=150000 W=1000000
+ AS=140000000000 AD=265000000000 PS=1280000 PD=2530000
* device instance $9 r0 *1 2.765,0.56 sky130_fd_pr__nfet_01v8
XM$9 \$4 A1 Y sky130_gnd sky130_fd_pr__nfet_01v8 L=150000 W=650000
+ AS=172250000000 AD=91000000000 PS=1830000 PD=930000
* device instance $10 r0 *1 3.195,0.56 sky130_fd_pr__nfet_01v8
XM$10 Y A1 \$4 sky130_gnd sky130_fd_pr__nfet_01v8 L=150000 W=650000
+ AS=91000000000 AD=91000000000 PS=930000 PD=930000
* device instance $11 r0 *1 3.625,0.56 sky130_fd_pr__nfet_01v8
XM$11 \$4 A2 VGND sky130_gnd sky130_fd_pr__nfet_01v8 L=150000 W=650000
+ AS=91000000000 AD=91000000000 PS=930000 PD=930000
* device instance $12 r0 *1 4.055,0.56 sky130_fd_pr__nfet_01v8
XM$12 VGND A2 \$4 sky130_gnd sky130_fd_pr__nfet_01v8 L=150000 W=650000
+ AS=91000000000 AD=172250000000 PS=930000 PD=1830000
* device instance $13 r0 *1 0.525,0.56 sky130_fd_pr__nfet_01v8
XM$13 VGND C1 Y sky130_gnd sky130_fd_pr__nfet_01v8 L=150000 W=650000
+ AS=172250000000 AD=91000000000 PS=1830000 PD=930000
* device instance $14 r0 *1 0.955,0.56 sky130_fd_pr__nfet_01v8
XM$14 Y C1 VGND sky130_gnd sky130_fd_pr__nfet_01v8 L=150000 W=650000
+ AS=91000000000 AD=91000000000 PS=930000 PD=930000
* device instance $15 r0 *1 1.385,0.56 sky130_fd_pr__nfet_01v8
XM$15 VGND B1 Y sky130_gnd sky130_fd_pr__nfet_01v8 L=150000 W=650000
+ AS=91000000000 AD=91000000000 PS=930000 PD=930000
* device instance $16 r0 *1 1.815,0.56 sky130_fd_pr__nfet_01v8
XM$16 Y B1 VGND sky130_gnd sky130_fd_pr__nfet_01v8 L=150000 W=650000
+ AS=91000000000 AD=172250000000 PS=930000 PD=1830000
.ENDS sky130_fd_sc_hd__a211oi_2

* cell sky130_fd_sc_hd__a211o_2
* pin VPB
* pin VPWR
* pin VGND
* pin X
* pin A2
* pin C1
* pin A1
* pin B1
* pin sky130_gnd
.SUBCKT sky130_fd_sc_hd__a211o_2 VPB VPWR VGND X A2 C1 A1 B1 sky130_gnd
* device instance $1 r0 *1 1.83,1.985 sky130_fd_pr__pfet_01v8_hvt
XM$1 \$7 A2 VPWR VPB sky130_fd_pr__pfet_01v8_hvt L=150000 W=1000000
+ AS=260000000000 AD=195000000000 PS=2520000 PD=1390000
* device instance $2 r0 *1 2.37,1.985 sky130_fd_pr__pfet_01v8_hvt
XM$2 VPWR A1 \$7 VPB sky130_fd_pr__pfet_01v8_hvt L=150000 W=1000000
+ AS=195000000000 AD=165000000000 PS=1390000 PD=1330000
* device instance $3 r0 *1 2.85,1.985 sky130_fd_pr__pfet_01v8_hvt
XM$3 \$7 B1 \$13 VPB sky130_fd_pr__pfet_01v8_hvt L=150000 W=1000000
+ AS=165000000000 AD=105000000000 PS=1330000 PD=1210000
* device instance $4 r0 *1 3.21,1.985 sky130_fd_pr__pfet_01v8_hvt
XM$4 \$13 C1 \$9 VPB sky130_fd_pr__pfet_01v8_hvt L=150000 W=1000000
+ AS=105000000000 AD=260000000000 PS=1210000 PD=2520000
* device instance $5 r0 *1 0.47,1.985 sky130_fd_pr__pfet_01v8_hvt
XM$5 VPWR \$9 X VPB sky130_fd_pr__pfet_01v8_hvt L=150000 W=1000000
+ AS=260000000000 AD=135000000000 PS=2520000 PD=1270000
* device instance $6 r0 *1 0.89,1.985 sky130_fd_pr__pfet_01v8_hvt
XM$6 X \$9 VPWR VPB sky130_fd_pr__pfet_01v8_hvt L=150000 W=1000000
+ AS=135000000000 AD=260000000000 PS=1270000 PD=2520000
* device instance $7 r0 *1 0.47,0.56 sky130_fd_pr__nfet_01v8
XM$7 VGND \$9 X sky130_gnd sky130_fd_pr__nfet_01v8 L=150000 W=650000
+ AS=169000000000 AD=91000000000 PS=1820000 PD=930000
* device instance $8 r0 *1 0.9,0.56 sky130_fd_pr__nfet_01v8
XM$8 X \$9 VGND sky130_gnd sky130_fd_pr__nfet_01v8 L=150000 W=650000
+ AS=91000000000 AD=199875000000 PS=930000 PD=1265000
* device instance $9 r0 *1 1.665,0.56 sky130_fd_pr__nfet_01v8
XM$9 VGND A2 \$12 sky130_gnd sky130_fd_pr__nfet_01v8 L=150000 W=650000
+ AS=199875000000 AD=133250000000 PS=1265000 PD=1060000
* device instance $10 r0 *1 2.225,0.56 sky130_fd_pr__nfet_01v8
XM$10 \$12 A1 \$9 sky130_gnd sky130_fd_pr__nfet_01v8 L=150000 W=650000
+ AS=133250000000 AD=115375000000 PS=1060000 PD=1005000
* device instance $11 r0 *1 2.73,0.56 sky130_fd_pr__nfet_01v8
XM$11 \$9 B1 VGND sky130_gnd sky130_fd_pr__nfet_01v8 L=150000 W=650000
+ AS=115375000000 AD=107250000000 PS=1005000 PD=980000
* device instance $12 r0 *1 3.21,0.56 sky130_fd_pr__nfet_01v8
XM$12 VGND C1 \$9 sky130_gnd sky130_fd_pr__nfet_01v8 L=150000 W=650000
+ AS=107250000000 AD=169000000000 PS=980000 PD=1820000
.ENDS sky130_fd_sc_hd__a211o_2

* cell sky130_fd_sc_hd__clkbuf_8
* pin VGND
* pin A
* pin X
* pin VPWR
* pin VPB
* pin sky130_gnd
.SUBCKT sky130_fd_sc_hd__clkbuf_8 VGND A X VPWR VPB sky130_gnd
* device instance $1 r0 *1 0.475,1.985 sky130_fd_pr__pfet_01v8_hvt
XM$1 VPWR A \$2 VPB sky130_fd_pr__pfet_01v8_hvt L=150000 W=1000000
+ AS=265000000000 AD=140000000000 PS=2530000 PD=1280000
* device instance $2 r0 *1 0.905,1.985 sky130_fd_pr__pfet_01v8_hvt
XM$2 \$2 A VPWR VPB sky130_fd_pr__pfet_01v8_hvt L=150000 W=1000000
+ AS=140000000000 AD=140000000000 PS=1280000 PD=1280000
* device instance $3 r0 *1 1.335,1.985 sky130_fd_pr__pfet_01v8_hvt
XM$3 VPWR \$2 X VPB sky130_fd_pr__pfet_01v8_hvt L=150000 W=1000000
+ AS=140000000000 AD=140000000000 PS=1280000 PD=1280000
* device instance $4 r0 *1 1.765,1.985 sky130_fd_pr__pfet_01v8_hvt
XM$4 X \$2 VPWR VPB sky130_fd_pr__pfet_01v8_hvt L=150000 W=1000000
+ AS=140000000000 AD=140000000000 PS=1280000 PD=1280000
* device instance $5 r0 *1 2.195,1.985 sky130_fd_pr__pfet_01v8_hvt
XM$5 VPWR \$2 X VPB sky130_fd_pr__pfet_01v8_hvt L=150000 W=1000000
+ AS=140000000000 AD=140000000000 PS=1280000 PD=1280000
* device instance $6 r0 *1 2.625,1.985 sky130_fd_pr__pfet_01v8_hvt
XM$6 X \$2 VPWR VPB sky130_fd_pr__pfet_01v8_hvt L=150000 W=1000000
+ AS=140000000000 AD=140000000000 PS=1280000 PD=1280000
* device instance $7 r0 *1 3.055,1.985 sky130_fd_pr__pfet_01v8_hvt
XM$7 VPWR \$2 X VPB sky130_fd_pr__pfet_01v8_hvt L=150000 W=1000000
+ AS=140000000000 AD=140000000000 PS=1280000 PD=1280000
* device instance $8 r0 *1 3.485,1.985 sky130_fd_pr__pfet_01v8_hvt
XM$8 X \$2 VPWR VPB sky130_fd_pr__pfet_01v8_hvt L=150000 W=1000000
+ AS=140000000000 AD=140000000000 PS=1280000 PD=1280000
* device instance $9 r0 *1 3.915,1.985 sky130_fd_pr__pfet_01v8_hvt
XM$9 VPWR \$2 X VPB sky130_fd_pr__pfet_01v8_hvt L=150000 W=1000000
+ AS=140000000000 AD=140000000000 PS=1280000 PD=1280000
* device instance $10 r0 *1 4.345,1.985 sky130_fd_pr__pfet_01v8_hvt
XM$10 X \$2 VPWR VPB sky130_fd_pr__pfet_01v8_hvt L=150000 W=1000000
+ AS=140000000000 AD=265000000000 PS=1280000 PD=2530000
* device instance $11 r0 *1 0.475,0.445 sky130_fd_pr__nfet_01v8
XM$11 VGND A \$2 sky130_gnd sky130_fd_pr__nfet_01v8 L=150000 W=420000
+ AS=111300000000 AD=58800000000 PS=1370000 PD=700000
* device instance $12 r0 *1 0.905,0.445 sky130_fd_pr__nfet_01v8
XM$12 \$2 A VGND sky130_gnd sky130_fd_pr__nfet_01v8 L=150000 W=420000
+ AS=58800000000 AD=58800000000 PS=700000 PD=700000
* device instance $13 r0 *1 1.335,0.445 sky130_fd_pr__nfet_01v8
XM$13 VGND \$2 X sky130_gnd sky130_fd_pr__nfet_01v8 L=150000 W=420000
+ AS=58800000000 AD=58800000000 PS=700000 PD=700000
* device instance $14 r0 *1 1.765,0.445 sky130_fd_pr__nfet_01v8
XM$14 X \$2 VGND sky130_gnd sky130_fd_pr__nfet_01v8 L=150000 W=420000
+ AS=58800000000 AD=58800000000 PS=700000 PD=700000
* device instance $15 r0 *1 2.195,0.445 sky130_fd_pr__nfet_01v8
XM$15 VGND \$2 X sky130_gnd sky130_fd_pr__nfet_01v8 L=150000 W=420000
+ AS=58800000000 AD=58800000000 PS=700000 PD=700000
* device instance $16 r0 *1 2.625,0.445 sky130_fd_pr__nfet_01v8
XM$16 X \$2 VGND sky130_gnd sky130_fd_pr__nfet_01v8 L=150000 W=420000
+ AS=58800000000 AD=58800000000 PS=700000 PD=700000
* device instance $17 r0 *1 3.055,0.445 sky130_fd_pr__nfet_01v8
XM$17 VGND \$2 X sky130_gnd sky130_fd_pr__nfet_01v8 L=150000 W=420000
+ AS=58800000000 AD=58800000000 PS=700000 PD=700000
* device instance $18 r0 *1 3.485,0.445 sky130_fd_pr__nfet_01v8
XM$18 X \$2 VGND sky130_gnd sky130_fd_pr__nfet_01v8 L=150000 W=420000
+ AS=58800000000 AD=58800000000 PS=700000 PD=700000
* device instance $19 r0 *1 3.915,0.445 sky130_fd_pr__nfet_01v8
XM$19 VGND \$2 X sky130_gnd sky130_fd_pr__nfet_01v8 L=150000 W=420000
+ AS=58800000000 AD=58800000000 PS=700000 PD=700000
* device instance $20 r0 *1 4.345,0.445 sky130_fd_pr__nfet_01v8
XM$20 X \$2 VGND sky130_gnd sky130_fd_pr__nfet_01v8 L=150000 W=420000
+ AS=58800000000 AD=113400000000 PS=700000 PD=1380000
.ENDS sky130_fd_sc_hd__clkbuf_8

* cell sky130_fd_sc_hd__clkbuf_4
* pin VPB
* pin VGND
* pin VPWR
* pin A
* pin sky130_gnd
.SUBCKT sky130_fd_sc_hd__clkbuf_4 VPB VGND VPWR A sky130_gnd
* device instance $1 r0 *1 0.475,1.985 sky130_fd_pr__pfet_01v8_hvt
XM$1 \$3 A VPWR VPB sky130_fd_pr__pfet_01v8_hvt L=150000 W=1000000
+ AS=265000000000 AD=165000000000 PS=2530000 PD=1330000
* device instance $2 r0 *1 0.955,1.985 sky130_fd_pr__pfet_01v8_hvt
XM$2 VPWR \$3 X VPB sky130_fd_pr__pfet_01v8_hvt L=150000 W=1000000
+ AS=165000000000 AD=140000000000 PS=1330000 PD=1280000
* device instance $3 r0 *1 1.385,1.985 sky130_fd_pr__pfet_01v8_hvt
XM$3 X \$3 VPWR VPB sky130_fd_pr__pfet_01v8_hvt L=150000 W=1000000
+ AS=140000000000 AD=140000000000 PS=1280000 PD=1280000
* device instance $4 r0 *1 1.815,1.985 sky130_fd_pr__pfet_01v8_hvt
XM$4 VPWR \$3 X VPB sky130_fd_pr__pfet_01v8_hvt L=150000 W=1000000
+ AS=140000000000 AD=140000000000 PS=1280000 PD=1280000
* device instance $5 r0 *1 2.245,1.985 sky130_fd_pr__pfet_01v8_hvt
XM$5 X \$3 VPWR VPB sky130_fd_pr__pfet_01v8_hvt L=150000 W=1000000
+ AS=140000000000 AD=300000000000 PS=1280000 PD=2600000
* device instance $6 r0 *1 0.475,0.445 sky130_fd_pr__nfet_01v8
XM$6 \$3 A VGND sky130_gnd sky130_fd_pr__nfet_01v8 L=150000 W=420000
+ AS=111300000000 AD=70350000000 PS=1370000 PD=755000
* device instance $7 r0 *1 0.96,0.445 sky130_fd_pr__nfet_01v8
XM$7 VGND \$3 X sky130_gnd sky130_fd_pr__nfet_01v8 L=150000 W=420000
+ AS=70350000000 AD=58800000000 PS=755000 PD=700000
* device instance $8 r0 *1 1.39,0.445 sky130_fd_pr__nfet_01v8
XM$8 X \$3 VGND sky130_gnd sky130_fd_pr__nfet_01v8 L=150000 W=420000
+ AS=58800000000 AD=58800000000 PS=700000 PD=700000
* device instance $9 r0 *1 1.82,0.445 sky130_fd_pr__nfet_01v8
XM$9 VGND \$3 X sky130_gnd sky130_fd_pr__nfet_01v8 L=150000 W=420000
+ AS=58800000000 AD=58800000000 PS=700000 PD=700000
* device instance $10 r0 *1 2.25,0.445 sky130_fd_pr__nfet_01v8
XM$10 X \$3 VGND sky130_gnd sky130_fd_pr__nfet_01v8 L=150000 W=420000
+ AS=58800000000 AD=121800000000 PS=700000 PD=1420000
.ENDS sky130_fd_sc_hd__clkbuf_4

* cell sky130_fd_sc_hd__decap_3
* pin VPB
* pin VGND
* pin VPWR
* pin sky130_gnd
.SUBCKT sky130_fd_sc_hd__decap_3 VPB VGND VPWR sky130_gnd
* device instance $1 r0 *1 0.69,2.05 sky130_fd_pr__pfet_01v8_hvt
XM$1 VPWR VGND VPWR VPB sky130_fd_pr__pfet_01v8_hvt L=590000 W=870000
+ AS=226200000000 AD=226200000000 PS=2260000 PD=2260000
* device instance $2 r0 *1 0.69,0.51 sky130_fd_pr__nfet_01v8
XM$2 VGND VPWR VGND sky130_gnd sky130_fd_pr__nfet_01v8 L=590000 W=550000
+ AS=143000000000 AD=143000000000 PS=1620000 PD=1620000
.ENDS sky130_fd_sc_hd__decap_3

* cell VIA_M1M2_PR
* pin
.SUBCKT VIA_M1M2_PR \$1
.ENDS VIA_M1M2_PR

* cell VIA_via5_6_2000_2000_1_1_1600_1600
* pin
.SUBCKT VIA_via5_6_2000_2000_1_1_1600_1600 \$1
.ENDS VIA_via5_6_2000_2000_1_1_1600_1600

* cell sky130_fd_sc_hd__tapvpwrvgnd_1
* pin VPWR
* pin VGND
.SUBCKT sky130_fd_sc_hd__tapvpwrvgnd_1 VPWR VGND
.ENDS sky130_fd_sc_hd__tapvpwrvgnd_1
