* Extracted by KLayout with SKY130 LVS runset on : 04/09/2026 17:27

* cell puzzle
* pin I
* pin O[0]
* pin O[1]
* pin O[2]
* pin O[3]
* pin O[4]
* pin O[5]
* pin O[6]
* pin O[7]
* pin Q00
* pin VGND
* pin VPWR
* pin clk
* pin enable
* pin or4b_85_c
* pin rst_n
* pin select
* pin success
.SUBCKT puzzle I O[0] O[1] O[2] O[3] O[4] O[5] O[6] O[7] Q00 VGND VPWR clk
+ enable or4b_85_c rst_n select success
* cell instance $1 r0 *1 181.7,16.32
X$1 VPWR VGND VPWR \$148 \$16 \$1 \$31 VGND sky130_fd_sc_hd__o21a_2
* cell instance $7 r0 *1 165.14,10.88
X$7 VPWR VPWR \$89 \$23 \$1 VGND VGND sky130_fd_sc_hd__and2_2
* cell instance $9 r180 *1 176.64,255.68
X$9 VGND \$1363 \$3673 \$3986 VPWR VPWR VGND sky130_fd_sc_hd__dfxtp_2
* cell instance $10 r180 *1 175.72,250.24
X$10 VGND \$1413 \$3673 \$3914 VPWR VPWR VGND sky130_fd_sc_hd__dfxtp_2
* cell instance $11 r0 *1 169.74,250.24
X$11 VGND \$1362 \$3182 \$4002 VPWR VPWR VGND sky130_fd_sc_hd__dfxtp_2
* cell instance $12 m0 *1 172.96,201.28
X$12 VGND rst_n \$2667 \$3182 \$3185 VPWR VPWR VGND sky130_fd_sc_hd__dfstp_2
* cell instance $13 m0 *1 166.98,190.4
X$13 VGND rst_n \$2823 \$2734 \$2999 VPWR VPWR VGND sky130_fd_sc_hd__dfstp_2
* cell instance $14 r0 *1 167.9,190.4
X$14 VGND rst_n \$2760 \$2734 \$2930 VPWR VPWR VGND sky130_fd_sc_hd__dfstp_2
* cell instance $18 m90 *1 172.5,217.6
X$18 VGND \$3548 \$3435 \$3490 \$3385 VPWR VPWR VGND sky130_fd_sc_hd__nor3b_2
* cell instance $19 m90 *1 177.56,168.64
X$19 VGND \$2581 select \$2590 \$2566 VPWR VPWR VGND sky130_fd_sc_hd__nor3b_2
* cell instance $20 r180 *1 172.5,217.6
X$20 VGND \$3294 \$3435 \$3385 \$3490 VPWR VPWR VGND sky130_fd_sc_hd__nor3b_2
* cell instance $21 r0 *1 168.82,212.16
X$21 VGND \$3288 \$3385 \$3490 \$3435 VPWR VPWR VGND sky130_fd_sc_hd__nor3b_2
* cell instance $22 r0 *1 164.22,244.8
X$22 VGND \$3435 \$737 or4b_85_c \$3941 \$3967 VPWR VPWR VGND
+ sky130_fd_sc_hd__a211oi_2
* cell instance $23 r0 *1 34.04,152.32
X$23 VGND \$2325 \$2174 \$2406 select \$1558 VPWR VPWR VGND
+ sky130_fd_sc_hd__a211oi_2
* cell instance $24 r180 *1 129.26,255.68
X$24 VGND \$425 \$340 \$4034 \$864 \$27 VPWR VPWR VGND sky130_fd_sc_hd__and4b_2
* cell instance $25 r0 *1 168.82,277.44
X$25 VGND \$3143 \$375 \$4252 \$3846 \$2454 VPWR VPWR VGND
+ sky130_fd_sc_hd__and4b_2
* cell instance $26 r0 *1 115,125.12
X$26 VGND \$984 \$760 \$1961 \$1050 \$899 VPWR VPWR VGND
+ sky130_fd_sc_hd__and4b_2
* cell instance $27 r180 *1 168.82,255.68
X$27 VGND \$3842 \$1362 \$1363 \$1413 VPWR VPWR VGND sky130_fd_sc_hd__nand3_2
* cell instance $28 m0 *1 166.52,136
X$28 VPWR VPWR \$2029 VGND \$1362 \$1527 \$2113 VGND sky130_fd_sc_hd__and3b_2
* cell instance $29 r180 *1 173.88,136
X$29 VPWR VPWR \$1362 VGND \$1363 \$1527 \$2083 VGND sky130_fd_sc_hd__and3b_2
* cell instance $30 r0 *1 161,174.08
X$30 VPWR VPWR \$2566 VGND \$2683 select \$2708 VGND sky130_fd_sc_hd__and3b_2
* cell instance $31 m90 *1 175.26,223.04
X$31 VGND \$3606 \$3456 \$3787 \$3430 \$3532 VPWR VPWR VGND
+ sky130_fd_sc_hd__o31a_2
* cell instance $32 m90 *1 171.58,223.04
X$32 VGND \$3853 \$3456 \$3731 \$3336 \$3293 VPWR VPWR VGND
+ sky130_fd_sc_hd__o31a_2
* cell instance $33 m0 *1 172.5,223.04
X$33 VGND \$3607 \$3456 \$3705 \$3413 \$3593 VPWR VPWR VGND
+ sky130_fd_sc_hd__o31a_2
* cell instance $34 m0 *1 176.18,217.6
X$34 VGND \$3512 \$3456 \$3516 \$3315 \$3407 VPWR VPWR VGND
+ sky130_fd_sc_hd__o31a_2
* cell instance $35 r180 *1 168.82,179.52
X$35 VGND \$2774 \$1362 \$2657 \$2634 \$2714 VPWR VPWR VGND
+ sky130_fd_sc_hd__o31a_2
* cell instance $36 r180 *1 177.56,228.48
X$36 VGND \$3702 \$3456 \$3703 \$3447 \$3351 VPWR VPWR VGND
+ sky130_fd_sc_hd__o31a_2
* cell instance $37 r180 *1 172.5,223.04
X$37 VGND \$3609 \$3456 \$3724 \$3539 \$3489 VPWR VPWR VGND
+ sky130_fd_sc_hd__o31a_2
* cell instance $38 r0 *1 172.5,217.6
X$38 VGND \$3494 \$3456 \$3497 \$3313 \$3414 VPWR VPWR VGND
+ sky130_fd_sc_hd__o31a_2
* cell instance $39 r0 *1 178.02,217.6
X$39 VGND \$3501 \$3456 \$3503 \$3325 \$3505 VPWR VPWR VGND
+ sky130_fd_sc_hd__o31a_2
* cell instance $40 r180 *1 174.8,146.88
X$40 VGND \$2251 \$2238 \$2324 \$2404 \$2236 VPWR \$I13963 VGND
+ sky130_fd_sc_hd__o31a_2
* cell instance $41 m0 *1 168.36,157.76
X$41 VPWR VPWR VGND sky130_fd_sc_hd__conb_1
* cell instance $42 m0 *1 168.82,108.8
X$42 \$I13928 VPWR VGND sky130_fd_sc_hd__conb_1
* cell instance $43 r0 *1 170.66,141.44
X$43 \$I13963 VPWR VGND sky130_fd_sc_hd__conb_1
* cell instance $44 r0 *1 77.28,97.92
X$44 VPWR VPWR VGND sky130_fd_sc_hd__conb_1
* cell instance $45 r0 *1 170.2,125.12
X$45 VPWR VPWR VGND sky130_fd_sc_hd__conb_1
* cell instance $46 m90 *1 93.84,108.8
X$46 VGND \$1271 \$1875 VPWR VPWR VGND sky130_fd_sc_hd__clkbuf_8
* cell instance $47 m90 *1 122.36,250.24
X$47 VGND \$1271 \$3876 VPWR VPWR VGND sky130_fd_sc_hd__clkbuf_8
* cell instance $48 m90 *1 91.08,76.16
X$48 VGND \$1271 \$784 VPWR VPWR VGND sky130_fd_sc_hd__clkbuf_8
* cell instance $49 m90 *1 65.32,146.88
X$49 VGND \$1271 \$2217 VPWR VPWR VGND sky130_fd_sc_hd__clkbuf_8
* cell instance $50 m0 *1 119.6,250.24
X$50 VGND \$1271 \$3881 VPWR VPWR VGND sky130_fd_sc_hd__clkbuf_8
* cell instance $51 m0 *1 72.68,152.32
X$51 VGND \$1271 \$2289 VPWR VPWR VGND sky130_fd_sc_hd__clkbuf_8
* cell instance $52 m0 *1 108.1,206.72
X$52 VGND \$1271 \$3272 VPWR VPWR VGND sky130_fd_sc_hd__clkbuf_8
* cell instance $53 m0 *1 100.74,201.28
X$53 VGND \$1271 \$2295 VPWR VPWR VGND sky130_fd_sc_hd__clkbuf_8
* cell instance $54 m0 *1 118.68,87.04
X$54 VGND \$1271 \$983 VPWR VPWR VGND sky130_fd_sc_hd__clkbuf_8
* cell instance $55 m0 *1 73.14,108.8
X$55 VGND \$1271 \$1649 VPWR VPWR VGND sky130_fd_sc_hd__clkbuf_8
* cell instance $56 r180 *1 126.04,92.48
X$56 VGND \$1271 \$1460 VPWR VPWR VGND sky130_fd_sc_hd__clkbuf_8
* cell instance $57 r0 *1 156.86,179.52
X$57 VGND \$1271 \$2734 VPWR VPWR VGND sky130_fd_sc_hd__clkbuf_8
* cell instance $58 m90 *1 156.86,179.52
X$58 VPWR \$2791 \$1362 \$1413 VGND VPWR \$1363 VGND sky130_fd_sc_hd__or3b_2
* cell instance $59 m0 *1 156.86,228.48
X$59 VGND \$1271 \$3673 VPWR \$I13875 VGND sky130_fd_sc_hd__clkbuf_8
* cell instance $60 r180 *1 151.34,179.52
X$60 VGND \$1271 \$2156 VPWR \$I13868 VGND sky130_fd_sc_hd__clkbuf_8
* cell instance $61 r0 *1 146.28,223.04
X$61 VGND \$1271 \$3182 VPWR \$I13866 VGND sky130_fd_sc_hd__clkbuf_8
* cell instance $62 m90 *1 77.74,141.44
X$62 VPWR VGND VPWR \$2289 VGND sky130_fd_sc_hd__clkbuf_4
* cell instance $63 m90 *1 159.62,223.04
X$63 \$I13875 VGND VPWR \$3673 VGND sky130_fd_sc_hd__clkbuf_4
* cell instance $64 m90 *1 112.24,206.72
X$64 VPWR VGND VPWR \$3272 VGND sky130_fd_sc_hd__clkbuf_4
* cell instance $65 m0 *1 84.64,114.24
X$65 VPWR VGND VPWR \$1875 VGND sky130_fd_sc_hd__clkbuf_4
* cell instance $66 m0 *1 126.04,92.48
X$66 VPWR VGND VPWR \$1460 VGND sky130_fd_sc_hd__clkbuf_4
* cell instance $67 m0 *1 127.88,250.24
X$67 VPWR VGND VPWR \$3881 VGND sky130_fd_sc_hd__clkbuf_4
* cell instance $68 m0 *1 123.74,87.04
X$68 VPWR VGND VPWR \$983 VGND sky130_fd_sc_hd__clkbuf_4
* cell instance $69 m0 *1 70.38,108.8
X$69 VPWR VGND VPWR \$1649 VGND sky130_fd_sc_hd__clkbuf_4
* cell instance $70 r180 *1 158.24,179.52
X$70 VPWR VGND VPWR \$2734 VGND sky130_fd_sc_hd__clkbuf_4
* cell instance $71 r0 *1 83.26,76.16
X$71 VPWR VGND VPWR \$784 VGND sky130_fd_sc_hd__clkbuf_4
* cell instance $72 r0 *1 146.28,174.08
X$72 \$I13868 VGND VPWR \$2156 VGND sky130_fd_sc_hd__clkbuf_4
* cell instance $73 r0 *1 114.54,250.24
X$73 VPWR VGND VPWR \$3876 VGND sky130_fd_sc_hd__clkbuf_4
* cell instance $74 r0 *1 57.5,146.88
X$74 VPWR VGND VPWR \$2217 VGND sky130_fd_sc_hd__clkbuf_4
* cell instance $75 r0 *1 100.74,195.84
X$75 VPWR VGND VPWR \$2295 VGND sky130_fd_sc_hd__clkbuf_4
* cell instance $93 m0 *1 115.92,195.84
X$93 VGND \$2988 \$27 \$340 \$864 \$425 VPWR \$I13591 VGND
+ sky130_fd_sc_hd__nor4_2
* cell instance $147 m90 *1 115.92,76.16
X$147 VGND \$1287 \$1288 select I VPWR \$1261 VPWR VGND sky130_fd_sc_hd__nand4_2
* cell instance $148 m90 *1 116.84,233.92
X$148 VGND \$3767 \$3765 select I VPWR \$3805 VPWR VGND sky130_fd_sc_hd__nand4_2
* cell instance $149 m90 *1 115.92,255.68
X$149 VGND \$4034 \$4033 select I VPWR \$4124 VPWR VGND sky130_fd_sc_hd__nand4_2
* cell instance $150 m90 *1 116.38,277.44
X$150 VGND \$4242 \$4197 select I VPWR \$4238 VPWR VGND sky130_fd_sc_hd__nand4_2
* cell instance $151 m0 *1 115,92.48
X$151 VGND \$1439 \$1454 select I VPWR \$1582 VPWR VGND sky130_fd_sc_hd__nand4_2
* cell instance $152 m0 *1 113.62,136
X$152 VGND \$2019 \$2017 select I VPWR \$2076 VPWR VGND sky130_fd_sc_hd__nand4_2
* cell instance $153 r180 *1 118.22,146.88
X$153 VGND \$2146 \$2211 select I VPWR \$2294 VPWR VGND sky130_fd_sc_hd__nand4_2
* cell instance $154 r180 *1 118.22,108.8
X$154 VGND \$1740 \$1742 select I VPWR \$1743 VPWR VGND sky130_fd_sc_hd__nand4_2
* cell instance $155 r180 *1 120.52,223.04
X$155 VGND \$3568 \$3481 select I VPWR \$3530 VPWR VGND sky130_fd_sc_hd__nand4_2
* cell instance $156 r180 *1 120.52,255.68
X$156 VGND \$3960 \$3896 select I VPWR \$3898 VPWR VGND sky130_fd_sc_hd__nand4_2
* cell instance $157 r180 *1 113.16,288.32
X$157 VGND \$4294 \$4285 select I VPWR \$4352 VPWR VGND sky130_fd_sc_hd__nand4_2
* cell instance $158 r180 *1 180.32,250.24
X$158 VGND \$1413 \$1363 \$1362 \$1527 VPWR \$3850 VPWR VGND
+ sky130_fd_sc_hd__nand4_2
* cell instance $159 m90 *1 119.6,119.68
X$159 VGND \$1961 \$1960 select I VPWR \$1958 \$I13390 VGND
+ sky130_fd_sc_hd__nand4_2
* cell instance $160 m90 *1 120.52,190.4
X$160 VGND \$2988 \$2905 select I VPWR \$2899 \$I13591 VGND
+ sky130_fd_sc_hd__nand4_2
* cell instance $161 m90 *1 177.1,54.4
X$161 \$I13345 VPWR \$31 VGND \$37 \$150 \$49 VGND sky130_fd_sc_hd__o21ai_2
* cell instance $162 m90 *1 181.24,168.64
X$162 VPWR VPWR I VGND \$2566 \$2565 \$2589 VGND sky130_fd_sc_hd__o21ai_2
* cell instance $163 m90 *1 176.18,136
X$163 \$I13343 VPWR \$1363 VGND \$1362 \$2168 \$1527 VGND
+ sky130_fd_sc_hd__o21ai_2
* cell instance $164 m0 *1 178.94,174.08
X$164 VPWR VPWR \$2670 VGND \$2564 \$2761 \$2678 VGND sky130_fd_sc_hd__o21ai_2
* cell instance $165 r180 *1 179.86,54.4
X$165 VPWR VPWR \$572 VGND \$676 \$1074 \$205 VGND sky130_fd_sc_hd__o21ai_2
* cell instance $166 m0 *1 165.14,223.04
X$166 VPWR \$3490 \$3581 VGND \$3435 VPWR \$3385 VGND sky130_fd_sc_hd__nor3_2
* cell instance $167 r180 *1 171.12,114.24
X$167 VPWR \$1362 \$1842 VGND \$1413 VPWR \$1363 VGND sky130_fd_sc_hd__nor3_2
* cell instance $168 r180 *1 178.02,97.92
X$168 VPWR \$1428 \$1425 VGND \$1362 VPWR \$1468 VGND sky130_fd_sc_hd__nor3_2
* cell instance $169 r180 *1 72.68,152.32
X$169 VGND \$2286 \$2224 VPWR \$1733 \$2135 \$2420 VPWR VPWR VGND
+ sky130_fd_sc_hd__a221o_2
* cell instance $170 m0 *1 184.46,184.96
X$170 VGND \$2766 \$2590 \$2576 select \$2760 \$3089 VPWR VPWR VGND
+ sky130_fd_sc_hd__a221o_2
* cell instance $171 r180 *1 164.68,195.84
X$171 VGND \$3070 \$2766 \$3067 select \$2667 \$3063 VPWR VPWR VGND
+ sky130_fd_sc_hd__a221o_2
* cell instance $172 r0 *1 184,190.4
X$172 VGND \$2948 \$2826 \$2766 select \$2673 \$2840 VPWR VPWR VGND
+ sky130_fd_sc_hd__a221o_2
* cell instance $173 r0 *1 184,179.52
X$173 VGND \$2682 \$2766 \$2741 select \$2738 \$2750 VPWR VPWR VGND
+ sky130_fd_sc_hd__a221o_2
* cell instance $174 m0 *1 171.12,114.24
X$174 VGND \$1831 \$1413 \$1363 \$1362 \$1527 VPWR VPWR VGND
+ sky130_fd_sc_hd__nor4b_2
* cell instance $175 m90 *1 172.96,168.64
X$175 VGND \$2690 \$2670 \$2625 \$2700 \$2564 \$2619 VPWR VPWR VGND
+ sky130_fd_sc_hd__o32a_2
* cell instance $176 r180 *1 164.68,190.4
X$176 VGND \$2930 \$2755 \$2708 \$3252 \$2760 \$2922 VPWR VPWR VGND
+ sky130_fd_sc_hd__o32a_2
* cell instance $177 r180 *1 181.24,43.52
X$177 VGND \$811 \$49 \$520 \$65 \$380 \$389 VPWR VPWR VGND
+ sky130_fd_sc_hd__o32a_2
* cell instance $178 m90 *1 90.62,54.4
X$178 VGND rst_n \$1126 \$729 \$1026 VPWR VPWR VGND sky130_fd_sc_hd__dfrtp_2
* cell instance $179 m90 *1 126.04,244.8
X$179 VGND rst_n \$3896 \$3881 \$3945 VPWR VPWR VGND sky130_fd_sc_hd__dfrtp_2
* cell instance $180 m90 *1 122.82,212.16
X$180 VGND rst_n \$3362 \$3182 \$3366 VPWR VPWR VGND sky130_fd_sc_hd__dfrtp_2
* cell instance $181 m90 *1 90.62,38.08
X$181 VGND rst_n \$689 \$729 \$686 VPWR VPWR VGND sky130_fd_sc_hd__dfrtp_2
* cell instance $182 r180 *1 93.38,43.52
X$182 VGND \$737 \$689 \$688 \$609 \$730 VPWR VPWR VGND sky130_fd_sc_hd__nor4b_2
* cell instance $183 m90 *1 124.66,108.8
X$183 VGND rst_n \$1742 \$1460 \$1769 VPWR \$I12730 VGND
+ sky130_fd_sc_hd__dfrtp_2
* cell instance $184 m90 *1 85.1,146.88
X$184 VGND rst_n \$2222 \$2289 \$2267 VPWR VPWR VGND sky130_fd_sc_hd__dfrtp_2
* cell instance $185 m90 *1 91.54,157.76
X$185 VGND rst_n Q00 \$2295 \$2527 VPWR VPWR VGND sky130_fd_sc_hd__dfrtp_2
* cell instance $186 m90 *1 41.86,92.48
X$186 VGND rst_n \$347 \$784 \$1537 VPWR VPWR VGND sky130_fd_sc_hd__dfrtp_2
* cell instance $187 m90 *1 39.56,201.28
X$187 VGND rst_n \$3143 \$2295 \$3200 VPWR VPWR VGND sky130_fd_sc_hd__dfrtp_2
* cell instance $188 m90 *1 123.74,136
X$188 VGND rst_n \$2020 \$2156 \$2141 VPWR VPWR VGND sky130_fd_sc_hd__dfrtp_2
* cell instance $189 m90 *1 42.78,103.36
X$189 VGND rst_n \$416 \$1649 \$1765 VPWR VPWR VGND sky130_fd_sc_hd__dfrtp_2
* cell instance $190 m90 *1 91.54,136
X$190 VGND rst_n \$2185 \$1875 \$2136 VPWR VPWR VGND sky130_fd_sc_hd__dfrtp_2
* cell instance $191 m90 *1 124.66,70.72
X$191 VGND rst_n \$1220 \$983 \$1243 VPWR VPWR VGND sky130_fd_sc_hd__dfrtp_2
* cell instance $192 m0 *1 114.08,184.96
X$192 VGND rst_n \$2868 \$2295 \$2809 VPWR \$I12721 VGND
+ sky130_fd_sc_hd__dfrtp_2
* cell instance $193 m0 *1 74.98,146.88
X$193 VGND rst_n \$2265 \$2217 \$2423 VPWR VPWR VGND sky130_fd_sc_hd__dfrtp_2
* cell instance $194 m0 *1 87.86,152.32
X$194 VGND rst_n \$2266 \$2289 \$2438 VPWR VPWR VGND sky130_fd_sc_hd__dfrtp_2
* cell instance $195 m0 *1 123.28,97.92
X$195 VGND rst_n \$1618 \$1460 \$1764 VPWR VPWR VGND sky130_fd_sc_hd__dfrtp_2
* cell instance $196 m0 *1 168.82,179.52
X$196 VGND rst_n \$2738 \$2156 \$2782 VPWR VPWR VGND sky130_fd_sc_hd__dfrtp_2
* cell instance $197 m0 *1 174.8,184.96
X$197 VGND rst_n \$2826 \$2734 \$2840 VPWR VPWR VGND sky130_fd_sc_hd__dfrtp_2
* cell instance $198 m0 *1 114.08,125.12
X$198 VGND rst_n \$1960 \$1875 \$2002 VPWR \$I13390 VGND
+ sky130_fd_sc_hd__dfrtp_2
* cell instance $199 m0 *1 114.08,65.28
X$199 VGND rst_n \$1140 \$729 \$1224 VPWR VPWR VGND sky130_fd_sc_hd__dfrtp_2
* cell instance $200 m0 *1 75.9,48.96
X$200 VGND rst_n \$929 \$784 \$975 VPWR VPWR VGND sky130_fd_sc_hd__dfrtp_2
* cell instance $201 m0 *1 113.62,261.12
X$201 VGND rst_n \$4089 \$3876 \$4127 VPWR VPWR VGND sky130_fd_sc_hd__dfrtp_2
* cell instance $202 m0 *1 115.92,212.16
X$202 VGND rst_n \$3368 \$3272 \$3429 VPWR VPWR VGND sky130_fd_sc_hd__dfrtp_2
* cell instance $203 m0 *1 118.22,48.96
X$203 VGND rst_n \$878 \$983 \$882 VPWR VPWR VGND sky130_fd_sc_hd__dfrtp_2
* cell instance $204 m0 *1 114.08,244.8
X$204 VGND rst_n \$3892 \$3876 \$3891 VPWR VPWR VGND sky130_fd_sc_hd__dfrtp_2
* cell instance $205 m0 *1 26.22,152.32
X$205 VGND rst_n \$340 \$2217 \$2491 VPWR VPWR VGND sky130_fd_sc_hd__dfrtp_2
* cell instance $206 m0 *1 115,76.16
X$206 VGND rst_n \$1288 \$729 \$1303 VPWR VPWR VGND sky130_fd_sc_hd__dfrtp_2
* cell instance $207 m0 *1 113.62,233.92
X$207 VGND rst_n \$3713 \$3272 \$3716 VPWR VPWR VGND sky130_fd_sc_hd__dfrtp_2
* cell instance $208 m0 *1 115.92,282.88
X$208 VGND rst_n \$4168 \$3876 \$4173 VPWR VPWR VGND sky130_fd_sc_hd__dfrtp_2
* cell instance $209 m0 *1 172.04,282.88
X$209 VGND rst_n success \$3673 \$4257 VPWR VPWR VGND sky130_fd_sc_hd__dfrtp_2
* cell instance $210 m0 *1 114.08,217.6
X$210 VGND rst_n \$3474 \$3272 \$3533 VPWR VPWR VGND sky130_fd_sc_hd__dfrtp_2
* cell instance $211 m0 *1 77.74,157.76
X$211 VGND rst_n \$2457 \$2217 \$2521 VPWR VPWR VGND sky130_fd_sc_hd__dfrtp_2
* cell instance $212 r180 *1 123.28,206.72
X$212 VGND rst_n \$3162 \$3182 \$3245 VPWR VPWR VGND sky130_fd_sc_hd__dfrtp_2
* cell instance $213 r180 *1 123.28,97.92
X$213 VGND rst_n \$1555 \$1460 \$1556 VPWR VPWR VGND sky130_fd_sc_hd__dfrtp_2
* cell instance $214 r180 *1 127.88,108.8
X$214 VGND rst_n \$1781 \$1460 \$1937 VPWR VPWR VGND sky130_fd_sc_hd__dfrtp_2
* cell instance $215 r180 *1 124.66,141.44
X$215 VGND rst_n \$2017 \$2156 \$2125 VPWR VPWR VGND sky130_fd_sc_hd__dfrtp_2
* cell instance $216 r180 *1 183.54,195.84
X$216 VGND rst_n \$2673 \$2734 \$3102 VPWR VPWR VGND sky130_fd_sc_hd__dfrtp_2
* cell instance $217 r180 *1 123.28,239.36
X$217 VGND rst_n \$3756 \$3881 \$3762 VPWR VPWR VGND sky130_fd_sc_hd__dfrtp_2
* cell instance $218 r180 *1 35.88,146.88
X$218 VGND rst_n \$425 \$2217 \$2247 VPWR VPWR VGND sky130_fd_sc_hd__dfrtp_2
* cell instance $219 r180 *1 123.28,81.6
X$219 VGND rst_n \$1272 \$983 \$1299 VPWR VPWR VGND sky130_fd_sc_hd__dfrtp_2
* cell instance $220 r180 *1 87.4,152.32
X$220 VGND rst_n \$2376 \$2289 \$2437 VPWR VPWR VGND sky130_fd_sc_hd__dfrtp_2
* cell instance $221 r180 *1 124.66,130.56
X$221 VGND rst_n \$2021 \$2156 \$2053 VPWR VPWR VGND sky130_fd_sc_hd__dfrtp_2
* cell instance $222 r180 *1 86.48,43.52
X$222 VGND rst_n \$782 \$784 \$734 VPWR VPWR VGND sky130_fd_sc_hd__dfrtp_2
* cell instance $223 r180 *1 87.4,59.84
X$223 VGND rst_n \$979 \$729 \$1092 VPWR VPWR VGND sky130_fd_sc_hd__dfrtp_2
* cell instance $224 r180 *1 123.28,288.32
X$224 VGND rst_n \$4318 \$3881 \$4287 VPWR VPWR VGND sky130_fd_sc_hd__dfrtp_2
* cell instance $225 r180 *1 123.28,277.44
X$225 VGND rst_n \$4189 \$3881 \$4188 VPWR VPWR VGND sky130_fd_sc_hd__dfrtp_2
* cell instance $226 r180 *1 87.4,136
X$226 VGND rst_n \$2104 \$1875 \$2108 VPWR VPWR VGND sky130_fd_sc_hd__dfrtp_2
* cell instance $227 r180 *1 127.88,136
X$227 VGND rst_n \$2052 \$2156 \$2194 VPWR VPWR VGND sky130_fd_sc_hd__dfrtp_2
* cell instance $228 r180 *1 127.88,146.88
X$228 VGND rst_n \$2229 \$2156 \$2254 VPWR VPWR VGND sky130_fd_sc_hd__dfrtp_2
* cell instance $229 r180 *1 86.48,141.44
X$229 VGND rst_n \$2223 \$1875 \$2190 VPWR VPWR VGND sky130_fd_sc_hd__dfrtp_2
* cell instance $230 r0 *1 116.38,217.6
X$230 VGND rst_n \$3481 \$3272 \$3621 VPWR VPWR VGND sky130_fd_sc_hd__dfrtp_2
* cell instance $231 r0 *1 79.12,108.8
X$231 VGND rst_n \$1729 \$1649 \$1775 VPWR VPWR VGND sky130_fd_sc_hd__dfrtp_2
* cell instance $232 r0 *1 80.96,92.48
X$232 VGND rst_n \$1513 \$1649 \$1620 VPWR VPWR VGND sky130_fd_sc_hd__dfrtp_2
* cell instance $233 r0 *1 115,81.6
X$233 VGND rst_n \$1280 \$729 \$1386 VPWR VPWR VGND sky130_fd_sc_hd__dfrtp_2
* cell instance $234 r0 *1 28.98,157.76
X$234 VGND rst_n \$864 \$2217 \$2537 VPWR VPWR VGND sky130_fd_sc_hd__dfrtp_2
* cell instance $235 m0 *1 28.98,163.2
X$235 VGND \$2577 \$2537 \$864 \$2321 \$1558 select VPWR VPWR VGND
+ sky130_fd_sc_hd__a221oi_2
* cell instance $236 r0 *1 115.92,76.16
X$236 VGND rst_n \$1221 \$983 \$1255 VPWR VPWR VGND sky130_fd_sc_hd__dfrtp_2
* cell instance $237 r0 *1 115.92,114.24
X$237 VGND rst_n \$1879 \$1875 \$1878 VPWR VPWR VGND sky130_fd_sc_hd__dfrtp_2
* cell instance $238 r0 *1 30.82,146.88
X$238 VGND rst_n \$27 \$2217 \$2325 VPWR VPWR VGND sky130_fd_sc_hd__dfrtp_2
* cell instance $239 r0 *1 81.88,97.92
X$239 VGND rst_n \$1652 \$1649 \$1571 VPWR VPWR VGND sky130_fd_sc_hd__dfrtp_2
* cell instance $240 r0 *1 115.92,282.88
X$240 VGND rst_n \$4285 \$3876 \$4290 VPWR VPWR VGND sky130_fd_sc_hd__dfrtp_2
* cell instance $241 r0 *1 115.92,255.68
X$241 VGND rst_n \$4033 \$3881 \$4032 VPWR VPWR VGND sky130_fd_sc_hd__dfrtp_2
* cell instance $242 r0 *1 115.92,206.72
X$242 VGND rst_n \$3151 \$3182 \$3159 VPWR VPWR VGND sky130_fd_sc_hd__dfrtp_2
* cell instance $243 r0 *1 85.1,146.88
X$243 VGND rst_n \$2224 \$2289 \$2352 VPWR VPWR VGND sky130_fd_sc_hd__dfrtp_2
* cell instance $244 r0 *1 84.18,152.32
X$244 VGND rst_n \$2377 \$2289 \$2379 VPWR VPWR VGND sky130_fd_sc_hd__dfrtp_2
* cell instance $245 r0 *1 167.9,195.84
X$245 VGND rst_n \$3067 \$2734 \$3063 VPWR VPWR VGND sky130_fd_sc_hd__dfrtp_2
* cell instance $246 r0 *1 82.8,141.44
X$246 VGND rst_n \$2135 \$1875 \$2138 VPWR VPWR VGND sky130_fd_sc_hd__dfrtp_2
* cell instance $247 r0 *1 76.82,163.2
X$247 VGND rst_n \$2544 \$2295 \$2596 VPWR \$I12667 VGND
+ sky130_fd_sc_hd__dfrtp_2
* cell instance $248 r0 *1 115,97.92
X$248 VGND rst_n \$1454 \$1460 \$1709 VPWR VPWR VGND sky130_fd_sc_hd__dfrtp_2
* cell instance $249 r0 *1 115.92,239.36
X$249 VGND rst_n \$3765 \$3272 \$3877 VPWR VPWR VGND sky130_fd_sc_hd__dfrtp_2
* cell instance $250 r0 *1 115.92,228.48
X$250 VGND rst_n \$3717 \$3272 \$3665 VPWR VPWR VGND sky130_fd_sc_hd__dfrtp_2
* cell instance $251 r0 *1 116.38,277.44
X$251 VGND rst_n \$4197 \$3876 \$4245 VPWR VPWR VGND sky130_fd_sc_hd__dfrtp_2
* cell instance $252 r0 *1 115,48.96
X$252 VGND rst_n \$1048 \$983 \$966 VPWR \$I12662 VGND sky130_fd_sc_hd__dfrtp_2
* cell instance $253 r180 *1 120.52,54.4
X$253 VGND \$1046 \$1048 select I VPWR \$895 \$I12662 VGND
+ sky130_fd_sc_hd__nand4_2
* cell instance $254 r0 *1 115.92,92.48
X$254 VGND rst_n \$1503 \$983 \$1554 VPWR VPWR VGND sky130_fd_sc_hd__dfrtp_2
* cell instance $255 r0 *1 115,146.88
X$255 VGND rst_n \$2211 \$2295 \$2296 VPWR VPWR VGND sky130_fd_sc_hd__dfrtp_2
* cell instance $256 r0 *1 116.38,184.96
X$256 VGND rst_n \$2905 \$2295 \$2983 VPWR VPWR VGND sky130_fd_sc_hd__dfrtp_2
* cell instance $257 r0 *1 82.8,43.52
X$257 VGND rst_n \$688 \$784 \$827 VPWR VPWR VGND sky130_fd_sc_hd__dfrtp_2
* cell instance $258 r0 *1 81.88,48.96
X$258 VGND rst_n \$837 \$784 \$919 VPWR VPWR VGND sky130_fd_sc_hd__dfrtp_2
* cell instance $259 r0 *1 114.08,272
X$259 VGND rst_n \$4196 \$3876 \$4192 VPWR VPWR VGND sky130_fd_sc_hd__dfrtp_2
* cell instance $260 r0 *1 28.98,97.92
X$260 VGND rst_n \$418 \$1649 \$1563 VPWR VPWR VGND sky130_fd_sc_hd__dfrtp_2
* cell instance $261 r0 *1 167.9,272
X$261 VGND rst_n \$3967 \$3673 \$4214 VPWR VPWR VGND sky130_fd_sc_hd__dfrtp_2
* cell instance $262 r0 *1 167.9,282.88
X$262 VGND rst_n \$3846 \$3673 \$4316 VPWR VPWR VGND sky130_fd_sc_hd__dfrtp_2
* cell instance $263 r0 *1 28.98,108.8
X$263 VGND rst_n \$417 \$1649 \$1791 VPWR VPWR VGND sky130_fd_sc_hd__dfrtp_2
* cell instance $264 r0 *1 160.54,38.08
X$264 VGND \$653 \$684 \$601 \$556 \$416 VPWR VPWR VGND sky130_fd_sc_hd__o22ai_2
* cell instance $265 r180 *1 34.96,97.92
X$265 VGND \$1563 \$347 \$1532 \$1566 \$1835 \$1562 VPWR VPWR VGND
+ sky130_fd_sc_hd__o311a_2
* cell instance $266 m0 *1 174.8,119.68
X$266 VPWR VPWR VGND \$1984 \$1976 \$1910 \$1363 \$1831 VGND
+ sky130_fd_sc_hd__a211o_2
* cell instance $267 m0 *1 161,38.08
X$267 VPWR VPWR VGND \$681 \$61 \$147 \$49 \$558 VGND sky130_fd_sc_hd__a211o_2
* cell instance $268 r180 *1 179.86,48.96
X$268 VPWR VPWR VGND \$907 \$956 \$857 \$572 \$180 VGND sky130_fd_sc_hd__a211o_2
* cell instance $269 r180 *1 174.8,184.96
X$269 VPWR VPWR VGND \$2678 \$1362 \$2634 \$1413 \$2656 VGND
+ sky130_fd_sc_hd__a211o_2
* cell instance $270 m90 *1 113.16,212.16
X$270 VPWR VPWR VGND \$3429 \$3368 \$3362 \$3269 VGND sky130_fd_sc_hd__a21o_2
* cell instance $271 m90 *1 120.52,201.28
X$271 VPWR VPWR VGND \$3245 \$3162 \$3151 \$3156 VGND sky130_fd_sc_hd__a21o_2
* cell instance $272 m90 *1 115.92,130.56
X$272 VPWR VPWR VGND \$2053 \$2021 \$2020 \$2072 VGND sky130_fd_sc_hd__a21o_2
* cell instance $273 m90 *1 115.92,92.48
X$273 VPWR VPWR VGND \$1554 \$1503 \$1555 \$1517 VGND sky130_fd_sc_hd__a21o_2
* cell instance $274 m0 *1 26.68,108.8
X$274 VPWR VPWR VGND \$1562 \$418 \$417 \$1754 VGND sky130_fd_sc_hd__a21o_2
* cell instance $275 r180 *1 33.58,108.8
X$275 VGND \$1835 \$417 \$418 \$1754 VPWR VPWR VGND sky130_fd_sc_hd__nand3_2
* cell instance $276 m0 *1 161.46,201.28
X$276 VPWR VPWR VGND \$3252 \$2766 select \$3067 VGND sky130_fd_sc_hd__a21o_2
* cell instance $277 m0 *1 109.94,76.16
X$277 VPWR VPWR VGND \$1299 \$1272 \$1221 \$1223 VGND sky130_fd_sc_hd__a21o_2
* cell instance $278 m0 *1 157.32,195.84
X$278 VPWR VPWR VGND \$2999 \$3131 \$2918 \$3132 VGND sky130_fd_sc_hd__a21o_2
* cell instance $279 m0 *1 166.06,92.48
X$279 VPWR VPWR VGND \$1497 \$1363 \$1466 \$1429 VGND sky130_fd_sc_hd__a21o_2
* cell instance $280 r180 *1 172.96,92.48
X$280 VPWR VPWR \$1466 VGND \$1469 \$1468 \$1490 VGND sky130_fd_sc_hd__and3b_2
* cell instance $281 r180 *1 177.56,92.48
X$281 VGND \$1420 \$1475 \$1473 \$1428 \$1469 VPWR VPWR VGND
+ sky130_fd_sc_hd__a31oi_2
* cell instance $282 m0 *1 109.94,277.44
X$282 VPWR VPWR VGND \$4188 \$4189 \$4168 \$4172 VGND sky130_fd_sc_hd__a21o_2
* cell instance $283 m0 *1 109.94,233.92
X$283 VPWR VPWR VGND \$3665 \$3717 \$3713 \$3661 VGND sky130_fd_sc_hd__a21o_2
* cell instance $284 r180 *1 164.68,43.52
X$284 VPWR VPWR VGND \$792 \$702 \$654 \$606 VGND sky130_fd_sc_hd__a21o_2
* cell instance $285 r180 *1 174.34,108.8
X$285 \$I12478 VPWR VGND \$1826 \$1831 \$1413 \$1823 VGND
+ sky130_fd_sc_hd__a21o_2
* cell instance $286 r180 *1 188.14,43.52
X$286 VPWR VPWR VGND \$804 \$805 \$572 \$711 VGND sky130_fd_sc_hd__a21o_2
* cell instance $287 r180 *1 95.22,48.96
X$287 VPWR VPWR VGND \$549 \$688 \$689 \$836 VGND sky130_fd_sc_hd__a21o_2
* cell instance $288 r180 *1 172.96,54.4
X$288 VPWR VPWR VGND \$589 \$1008 \$423 \$563 VGND sky130_fd_sc_hd__a21o_2
* cell instance $289 r0 *1 111.78,65.28
X$289 VPWR VPWR VGND \$1224 \$1140 \$1220 \$1227 VGND sky130_fd_sc_hd__a21o_2
* cell instance $290 r0 *1 167.9,255.68
X$290 \$I14138 VPWR VGND \$3841 \$1362 \$1363 \$1413 VGND
+ sky130_fd_sc_hd__a21o_2
* cell instance $291 r0 *1 160.54,250.24
X$291 VPWR VPWR or4b_85_c VGND \$4042 \$3967 success VGND
+ sky130_fd_sc_hd__o21ba_2
* cell instance $292 m90 *1 81.88,48.96
X$292 VGND \$1038 \$929 \$837 \$979 \$688 VPWR VPWR VGND
+ sky130_fd_sc_hd__and4bb_2
* cell instance $293 m90 *1 120.52,223.04
X$293 VGND \$3568 \$340 \$27 \$425 \$864 VPWR VPWR VGND
+ sky130_fd_sc_hd__and4bb_2
* cell instance $294 m90 *1 173.42,114.24
X$294 VGND \$1933 \$1413 \$1363 \$1527 \$1362 VPWR VPWR VGND
+ sky130_fd_sc_hd__and4bb_2
* cell instance $295 r0 *1 173.42,114.24
X$295 VGND \$1362 \$1363 \$1910 \$1527 \$1413 VPWR VPWR VGND
+ sky130_fd_sc_hd__and4b_2
* cell instance $296 m0 *1 170.2,119.68
X$296 VGND \$1976 \$1527 \$1362 \$1413 \$1363 VPWR VPWR VGND
+ sky130_fd_sc_hd__a211oi_2
* cell instance $297 m90 *1 115.92,282.88
X$297 VGND \$4242 \$864 \$340 \$425 \$27 VPWR VPWR VGND
+ sky130_fd_sc_hd__and4bb_2
* cell instance $298 m0 *1 115.92,103.36
X$298 VGND \$1740 \$984 \$899 \$1050 \$760 VPWR VPWR VGND
+ sky130_fd_sc_hd__and4bb_2
* cell instance $299 m0 *1 120.52,255.68
X$299 VGND \$3960 \$425 \$27 \$864 \$340 VPWR VPWR VGND
+ sky130_fd_sc_hd__and4bb_2
* cell instance $300 r180 *1 122.82,70.72
X$300 VGND \$1287 \$760 \$899 \$984 \$1050 VPWR VPWR VGND
+ sky130_fd_sc_hd__and4bb_2
* cell instance $301 r0 *1 23.46,152.32
X$301 VGND \$1558 \$864 \$27 \$425 \$340 VPWR VPWR VGND
+ sky130_fd_sc_hd__and4bb_2
* cell instance $302 m0 *1 28.06,157.76
X$302 VGND \$2577 select \$864 \$27 \$340 \$425 VPWR VPWR VGND
+ sky130_fd_sc_hd__a41oi_2
* cell instance $303 r0 *1 115.92,130.56
X$303 VGND \$2019 \$1050 \$760 \$984 \$899 VPWR VPWR VGND
+ sky130_fd_sc_hd__and4bb_2
* cell instance $304 r0 *1 115.92,87.04
X$304 VGND \$1439 \$984 \$760 \$1050 \$899 VPWR VPWR VGND
+ sky130_fd_sc_hd__and4bb_2
* cell instance $305 r0 *1 115.92,141.44
X$305 VGND \$2146 \$1050 \$899 \$984 \$760 VPWR VPWR VGND
+ sky130_fd_sc_hd__and4bb_2
* cell instance $306 r0 *1 116.84,233.92
X$306 VGND \$3767 \$425 \$340 \$864 \$27 VPWR VPWR VGND
+ sky130_fd_sc_hd__and4bb_2
* cell instance $307 r0 *1 126.5,282.88
X$307 VGND \$4294 \$864 \$27 \$425 \$340 VPWR VPWR VGND
+ sky130_fd_sc_hd__and4bb_2
* cell instance $308 m90 *1 74.52,152.32
X$308 VPWR \$2419 VPWR \$2425 \$2421 \$2512 \$3859 VGND VGND
+ sky130_fd_sc_hd__and4_2
* cell instance $309 m0 *1 26.22,103.36
X$309 VPWR select VPWR \$416 \$347 \$1754 \$1558 VGND VGND
+ sky130_fd_sc_hd__and4_2
* cell instance $310 m0 *1 29.9,103.36
X$310 VGND \$417 \$416 \$418 \$1532 VPWR VPWR VGND sky130_fd_sc_hd__nand3b_2
* cell instance $311 r180 *1 77.74,157.76
X$311 VPWR \$2453 VPWR \$2518 \$2519 \$2593 \$3321 VGND VGND
+ sky130_fd_sc_hd__and4_2
* cell instance $312 r180 *1 83.72,21.76
X$312 \$I12292 \$316 VPWR \$195 \$194 \$314 \$233 VGND VGND
+ sky130_fd_sc_hd__and4_2
* cell instance $313 r180 *1 78.2,54.4
X$313 VPWR \$880 VPWR \$836 \$969 \$1037 \$929 VGND VGND sky130_fd_sc_hd__and4_2
* cell instance $314 r0 *1 77.28,38.08
X$314 VPWR \$688 VPWR \$609 \$730 \$692 \$689 VGND VGND sky130_fd_sc_hd__and4_2
* cell instance $315 r0 *1 27.14,146.88
X$315 VPWR \$340 VPWR \$425 select \$2321 \$27 VGND VGND sky130_fd_sc_hd__and4_2
* cell instance $316 m90 *1 113.16,217.6
X$316 VPWR \$3530 VPWR VGND \$3533 \$3474 VGND sky130_fd_sc_hd__nand2b_2
* cell instance $317 m90 *1 111.78,277.44
X$317 VPWR \$4238 VPWR VGND \$4192 \$4196 VGND sky130_fd_sc_hd__nand2b_2
* cell instance $318 m90 *1 116.38,244.8
X$318 VPWR \$3898 VPWR VGND \$3891 \$3892 VGND sky130_fd_sc_hd__nand2b_2
* cell instance $319 m90 *1 123.28,103.36
X$319 VPWR \$1582 VPWR VGND \$1764 \$1618 VGND sky130_fd_sc_hd__nand2b_2
* cell instance $320 m90 *1 115.92,114.24
X$320 VPWR \$1958 VPWR VGND \$1878 \$1879 VGND sky130_fd_sc_hd__nand2b_2
* cell instance $321 m90 *1 177.1,92.48
X$321 VPWR \$1362 VPWR VGND \$1466 \$1413 VGND sky130_fd_sc_hd__nand2b_2
* cell instance $322 m90 *1 116.38,184.96
X$322 VPWR \$2899 VPWR VGND \$2809 \$2868 VGND sky130_fd_sc_hd__nand2b_2
* cell instance $323 m90 *1 120.06,43.52
X$323 VPWR \$895 VPWR VGND \$882 \$878 VGND sky130_fd_sc_hd__nand2b_2
* cell instance $324 m90 *1 117.3,261.12
X$324 \$I12015 \$4124 VPWR VGND \$4127 \$4089 VGND sky130_fd_sc_hd__nand2b_2
* cell instance $325 m0 *1 124.66,141.44
X$325 VPWR \$2076 VPWR VGND \$2194 \$2052 VGND sky130_fd_sc_hd__nand2b_2
* cell instance $326 m0 *1 109.94,81.6
X$326 VPWR \$1261 VPWR VGND \$1386 \$1280 VGND sky130_fd_sc_hd__nand2b_2
* cell instance $327 m0 *1 167.9,206.72
X$327 VPWR \$3058 VPWR VGND \$2681 select VGND sky130_fd_sc_hd__nand2b_2
* cell instance $328 m0 *1 119.14,114.24
X$328 \$I12730 \$1743 VPWR VGND \$1937 \$1781 VGND sky130_fd_sc_hd__nand2b_2
* cell instance $329 m0 *1 119.14,152.32
X$329 VPWR \$2294 VPWR VGND \$2254 \$2229 VGND sky130_fd_sc_hd__nand2b_2
* cell instance $330 r180 *1 177.1,136
X$330 VPWR \$1363 VPWR VGND \$2037 \$1413 VGND sky130_fd_sc_hd__nand2b_2
* cell instance $331 r180 *1 172.04,282.88
X$331 VPWR \$3143 VPWR VGND \$4255 \$3846 VGND sky130_fd_sc_hd__nand2b_2
* cell instance $332 r180 *1 172.96,87.04
X$332 \$I12007 \$1413 VPWR VGND \$1429 \$1362 VGND sky130_fd_sc_hd__nand2b_2
* cell instance $333 m0 *1 172.96,87.04
X$333 VGND \$1426 \$1419 \$1420 \$1425 \$1422 VPWR \$I12007 VGND
+ sky130_fd_sc_hd__o31a_2
* cell instance $334 r180 *1 181.24,97.92
X$334 VPWR \$1527 VPWR VGND \$1473 \$1362 VGND sky130_fd_sc_hd__nand2b_2
* cell instance $335 r0 *1 109.02,233.92
X$335 VPWR \$3805 VPWR VGND \$3762 \$3756 VGND sky130_fd_sc_hd__nand2b_2
* cell instance $336 r0 *1 108.1,282.88
X$336 VPWR \$4352 VPWR VGND \$4287 \$4318 VGND sky130_fd_sc_hd__nand2b_2
* cell instance $337 r0 *1 181.24,92.48
X$337 VPWR \$1362 VPWR VGND \$1475 \$1527 VGND sky130_fd_sc_hd__nand2b_2
* cell instance $338 r0 *1 163.76,43.52
X$338 VPWR \$645 VPWR VGND \$865 \$654 VGND sky130_fd_sc_hd__nand2b_2
* cell instance $339 r0 *1 155.02,190.4
X$339 VPWR \$1413 VPWR VGND \$2914 \$1363 VGND sky130_fd_sc_hd__nand2b_2
* cell instance $340 r180 *1 184.46,27.2
X$340 VGND \$35 \$151 \$37 \$380 \$49 VPWR VPWR VGND sky130_fd_sc_hd__o31ai_2
* cell instance $341 m90 *1 161.92,190.4
X$341 VGND \$2766 \$2823 select \$2826 \$3131 VPWR VPWR VGND
+ sky130_fd_sc_hd__a22o_2
* cell instance $342 m90 *1 156.86,184.96
X$342 VGND \$2738 \$2766 select \$2823 \$2886 VPWR VPWR VGND
+ sky130_fd_sc_hd__a22o_2
* cell instance $343 m90 *1 167.9,223.04
X$343 VGND \$2039 \$3581 \$2323 \$3548 \$3497 VPWR VPWR VGND
+ sky130_fd_sc_hd__a22o_2
* cell instance $344 m90 *1 170.2,201.28
X$344 VGND \$1362 \$2914 \$1413 \$3054 \$3071 VPWR VPWR VGND
+ sky130_fd_sc_hd__a22o_2
* cell instance $345 m90 *1 168.82,212.16
X$345 VGND \$1611 \$3294 \$2701 \$3288 \$3447 VPWR VPWR VGND
+ sky130_fd_sc_hd__a22o_2
* cell instance $346 m0 *1 172.5,217.6
X$346 VGND \$1542 \$3294 \$2744 \$3288 \$3430 VPWR VPWR VGND
+ sky130_fd_sc_hd__a22o_2
* cell instance $347 m0 *1 170.2,233.92
X$347 VGND \$2110 \$3581 \$2475 \$3548 \$3787 VPWR VPWR VGND
+ sky130_fd_sc_hd__a22o_2
* cell instance $348 m0 *1 176.18,223.04
X$348 VGND VGND \$3581 VGND \$3548 \$3516 VPWR VPWR VGND sky130_fd_sc_hd__a22o_2
* cell instance $349 m0 *1 174.34,212.16
X$349 VGND \$1660 \$3294 \$2748 \$3288 \$3313 VPWR VPWR VGND
+ sky130_fd_sc_hd__a22o_2
* cell instance $350 r180 *1 173.88,228.48
X$350 VGND \$2161 \$3581 VGND \$3548 \$3724 VPWR VPWR VGND
+ sky130_fd_sc_hd__a22o_2
* cell instance $351 r180 *1 170.66,212.16
X$351 VGND \$1426 \$3294 \$2872 \$3288 \$3336 VPWR VPWR VGND
+ sky130_fd_sc_hd__a22o_2
* cell instance $352 r180 *1 170.2,228.48
X$352 VGND \$2083 \$3581 \$2331 \$3548 \$3731 VPWR VPWR VGND
+ sky130_fd_sc_hd__a22o_2
* cell instance $353 r180 *1 174.34,212.16
X$353 VGND \$1462 \$3294 \$2830 \$3288 \$3539 VPWR VPWR VGND
+ sky130_fd_sc_hd__a22o_2
* cell instance $354 r180 *1 86.94,163.2
X$354 VGND \$2377 \$1787 \$1705 Q00 \$2286 VPWR VPWR VGND
+ sky130_fd_sc_hd__a22o_2
* cell instance $355 r180 *1 161.92,179.52
X$355 VGND \$2791 \$2625 \$2657 \$2599 \$2796 VPWR VPWR VGND
+ sky130_fd_sc_hd__a22o_2
* cell instance $356 r0 *1 173.42,212.16
X$356 VGND \$1757 \$3294 \$3209 \$3288 \$3413 VPWR VPWR VGND
+ sky130_fd_sc_hd__a22o_2
* cell instance $357 r0 *1 173.88,228.48
X$357 VGND \$2049 \$3581 \$2251 \$3548 \$3703 VPWR VPWR VGND
+ sky130_fd_sc_hd__a22o_2
* cell instance $358 r0 *1 172.5,206.72
X$358 VGND VGND \$3294 \$2671 \$3288 \$3315 VPWR VPWR VGND
+ sky130_fd_sc_hd__a22o_2
* cell instance $359 r0 *1 77.28,103.36
X$359 VGND \$1614 \$1728 \$1700 \$1729 \$1775 VPWR VPWR VGND
+ sky130_fd_sc_hd__a22o_2
* cell instance $360 m90 *1 85.56,103.36
X$360 VGND \$1733 \$864 \$27 \$340 VPWR \$425 VPWR VGND sky130_fd_sc_hd__or4bb_2
* cell instance $361 r0 *1 170.2,228.48
X$361 VGND \$2113 \$3581 \$2319 \$3548 \$3705 VPWR VPWR VGND
+ sky130_fd_sc_hd__a22o_2
* cell instance $362 r0 *1 168.82,206.72
X$362 VGND \$1681 \$3294 \$3334 \$3288 \$3325 VPWR VPWR VGND
+ sky130_fd_sc_hd__a22o_2
* cell instance $363 r0 *1 178.02,223.04
X$363 VGND \$2237 \$3581 \$2503 \$3548 \$3503 VPWR VPWR VGND
+ sky130_fd_sc_hd__a22o_2
* cell instance $364 m90 *1 116.38,217.6
X$364 VPWR \$3481 VPWR \$3474 VGND \$2518 VGND sky130_fd_sc_hd__and2b_2
* cell instance $365 m90 *1 122.82,119.68
X$365 \$I13390 \$1960 VPWR \$1879 VGND \$195 VGND sky130_fd_sc_hd__and2b_2
* cell instance $366 m90 *1 112.7,239.36
X$366 VPWR \$3765 VPWR \$3756 VGND \$3859 VGND sky130_fd_sc_hd__and2b_2
* cell instance $367 m90 *1 108.1,282.88
X$367 VPWR \$4285 VPWR \$4318 VGND \$2417 VGND sky130_fd_sc_hd__and2b_2
* cell instance $368 m90 *1 111.32,76.16
X$368 VPWR \$1288 VPWR \$1280 VGND \$441 VGND sky130_fd_sc_hd__and2b_2
* cell instance $369 m90 *1 161.92,195.84
X$369 VPWR select VPWR \$3058 VGND \$2918 VGND sky130_fd_sc_hd__and2b_2
* cell instance $370 m0 *1 74.52,59.84
X$370 VPWR \$1037 VPWR \$1173 VGND \$975 VGND sky130_fd_sc_hd__and2b_2
* cell instance $371 m0 *1 169.74,168.64
X$371 \$I11849 \$2601 VPWR \$2563 VGND \$2619 VGND sky130_fd_sc_hd__and2b_2
* cell instance $373 m0 *1 167.9,152.32
X$373 VPWR \$1363 VPWR \$1413 VGND \$2324 VGND sky130_fd_sc_hd__and2b_2
* cell instance $374 m0 *1 153.18,190.4
X$374 VPWR \$1413 VPWR \$1363 VGND \$2634 VGND sky130_fd_sc_hd__and2b_2
* cell instance $375 m0 *1 84.18,54.4
X$375 VPWR \$689 VPWR \$1126 VGND \$1095 VGND sky130_fd_sc_hd__and2b_2
* cell instance $376 m0 *1 184.46,179.52
X$376 VPWR \$2683 VPWR \$2576 VGND \$2755 VGND sky130_fd_sc_hd__and2b_2
* cell instance $377 r180 *1 119.14,190.4
X$377 VPWR \$2905 VPWR \$2868 VGND \$2453 VGND sky130_fd_sc_hd__and2b_2
* cell instance $378 r180 *1 119.14,250.24
X$378 VPWR \$3896 VPWR \$3892 VGND \$2421 VGND sky130_fd_sc_hd__and2b_2
* cell instance $379 r180 *1 126.5,277.44
X$379 VPWR \$4197 VPWR \$4196 VGND \$2449 VGND sky130_fd_sc_hd__and2b_2
* cell instance $380 r180 *1 113.16,141.44
X$380 VPWR \$2017 VPWR \$2052 VGND \$1128 VGND sky130_fd_sc_hd__and2b_2
* cell instance $381 r180 *1 119.14,114.24
X$381 \$I12730 \$1742 VPWR \$1781 VGND \$194 VGND sky130_fd_sc_hd__and2b_2
* cell instance $382 r180 *1 113.16,261.12
X$382 VPWR \$4033 VPWR \$4089 VGND \$2425 VGND sky130_fd_sc_hd__and2b_2
* cell instance $383 r180 *1 123.74,103.36
X$383 VPWR \$1454 VPWR \$1618 VGND \$233 VGND sky130_fd_sc_hd__and2b_2
* cell instance $384 r180 *1 174.34,130.56
X$384 VPWR \$1363 VPWR \$1413 VGND \$2029 VGND sky130_fd_sc_hd__and2b_2
* cell instance $385 r180 *1 178.94,152.32
X$385 VPWR \$1362 VPWR \$1363 VGND \$2314 VGND sky130_fd_sc_hd__and2b_2
* cell instance $386 r180 *1 33.12,201.28
X$386 \$I13622 \$3143 VPWR enable VGND select VGND sky130_fd_sc_hd__and2b_2
* cell instance $387 r180 *1 123.74,54.4
X$387 \$I12662 \$1048 VPWR \$878 VGND \$378 VGND sky130_fd_sc_hd__and2b_2
* cell instance $388 r180 *1 119.14,152.32
X$388 VPWR \$2211 VPWR \$2229 VGND \$591 VGND sky130_fd_sc_hd__and2b_2
* cell instance $389 r180 *1 157.78,38.08
X$389 VPWR \$427 VPWR \$653 VGND \$554 VGND sky130_fd_sc_hd__and2b_2
* cell instance $390 r180 *1 177.56,130.56
X$390 VPWR \$2043 VPWR \$2037 VGND \$2039 VGND sky130_fd_sc_hd__and2b_2
* cell instance $391 r0 *1 81.88,32.64
X$391 VPWR \$593 VPWR \$549 VGND \$827 VGND sky130_fd_sc_hd__and2b_2
* cell instance $392 m0 *1 77.74,38.08
X$392 VGND rst_n \$609 \$784 \$643 VPWR VPWR VGND sky130_fd_sc_hd__dfrtp_2
* cell instance $393 r0 *1 168.36,87.04
X$393 VPWR \$1362 VPWR \$1413 VGND \$1483 VGND sky130_fd_sc_hd__and2b_2
* cell instance $394 r0 *1 171.58,87.04
X$394 VGND \$1418 \$1462 \$1413 \$1473 \$1420 \$1419 VPWR VPWR VGND
+ sky130_fd_sc_hd__o32ai_2
* cell instance $395 r0 *1 172.04,81.6
X$395 \$I12007 \$1363 VPWR \$1362 VGND \$1419 VGND sky130_fd_sc_hd__and2b_2
* cell instance $396 m90 *1 177.1,277.44
X$396 VGND \$4257 \$4255 \$2270 \$4203 success \$4252 VPWR VPWR VGND
+ sky130_fd_sc_hd__a32o_2
* cell instance $397 m0 *1 170.2,277.44
X$397 VGND \$4214 \$4255 \$4211 \$4203 \$3967 \$4252 VPWR VPWR VGND
+ sky130_fd_sc_hd__a32o_2
* cell instance $398 r180 *1 92,48.96
X$398 VGND \$686 \$689 I select \$888 \$1095 VPWR VPWR VGND
+ sky130_fd_sc_hd__a32o_2
* cell instance $399 r0 *1 163.76,21.76
X$399 VGND \$291 \$143 \$27 \$79 \$98 \$330 VPWR VPWR VGND
+ sky130_fd_sc_hd__a32o_2
* cell instance $400 m90 *1 174.8,184.96
X$400 VGND \$2625 \$2991 \$1527 VPWR VPWR VGND sky130_fd_sc_hd__xnor2_2
* cell instance $401 m90 *1 184,184.96
X$401 VGND \$2910 \$2695 \$2738 VPWR VPWR VGND sky130_fd_sc_hd__xnor2_2
* cell instance $402 r0 *1 184,184.96
X$402 VGND \$2563 \$2599 \$2663 \$1413 \$2656 VPWR VPWR VGND
+ sky130_fd_sc_hd__a22oi_2
* cell instance $403 m90 *1 167.9,179.52
X$403 VGND \$2786 \$2934 \$2738 VPWR VPWR VGND sky130_fd_sc_hd__xnor2_2
* cell instance $404 m90 *1 177.56,179.52
X$404 VGND rst_n \$2741 \$2734 \$2750 VPWR VPWR VGND sky130_fd_sc_hd__dfstp_2
* cell instance $405 m90 *1 167.9,195.84
X$405 VGND \$3132 \$3073 \$2934 VPWR VPWR VGND sky130_fd_sc_hd__xnor2_2
* cell instance $406 m90 *1 171.12,38.08
X$406 VGND \$665 \$418 \$416 VPWR VPWR VGND sky130_fd_sc_hd__xnor2_2
* cell instance $407 m90 *1 184,179.52
X$407 VGND \$3319 \$2974 \$2738 VPWR VPWR VGND sky130_fd_sc_hd__xnor2_2
* cell instance $408 m90 *1 34.04,152.32
X$408 VGND \$2441 select \$340 VPWR VPWR VGND sky130_fd_sc_hd__xnor2_2
* cell instance $409 m0 *1 177.1,32.64
X$409 VGND \$35 \$504 \$291 VPWR VPWR VGND sky130_fd_sc_hd__xnor2_2
* cell instance $410 r180 *1 186.76,32.64
X$410 VPWR VPWR VGND \$710 \$81 \$49 \$35 \$209 VGND sky130_fd_sc_hd__a211o_2
* cell instance $411 m0 *1 172.04,21.76
X$411 VGND \$46 \$143 \$98 VPWR VPWR VGND sky130_fd_sc_hd__xnor2_2
* cell instance $412 m0 *1 178.02,21.76
X$412 VGND \$956 \$169 \$49 \$57 \$38 \$16 VPWR VPWR VGND
+ sky130_fd_sc_hd__a32o_2
* cell instance $413 m0 *1 165.14,43.52
X$413 VGND \$861 \$645 \$654 VPWR VPWR VGND sky130_fd_sc_hd__xnor2_2
* cell instance $414 m0 *1 165.14,195.84
X$414 VGND \$3334 \$3071 \$2738 VPWR VPWR VGND sky130_fd_sc_hd__xnor2_2
* cell instance $415 m0 *1 166.98,174.08
X$415 VGND \$2671 \$2703 \$2741 VPWR VPWR VGND sky130_fd_sc_hd__xnor2_2
* cell instance $416 m0 *1 158.7,184.96
X$416 VGND \$2872 \$2874 \$2873 VPWR VPWR VGND sky130_fd_sc_hd__xnor2_2
* cell instance $417 m0 *1 170.2,48.96
X$417 VGND \$857 \$792 \$791 VPWR VPWR VGND sky130_fd_sc_hd__xnor2_2
* cell instance $418 r180 *1 184.46,179.52
X$418 VGND \$2748 \$2761 \$2760 VPWR VPWR VGND sky130_fd_sc_hd__xnor2_2
* cell instance $419 r0 *1 162.84,184.96
X$419 VGND \$2995 \$2741 \$2823 VPWR VPWR VGND sky130_fd_sc_hd__xnor2_2
* cell instance $420 r0 *1 166.98,43.52
X$420 VGND \$668 \$861 \$864 VPWR VPWR VGND sky130_fd_sc_hd__xnor2_2
* cell instance $421 r0 *1 171.12,38.08
X$421 VGND \$504 \$521 \$668 VPWR VPWR VGND sky130_fd_sc_hd__xnor2_2
* cell instance $422 r0 *1 178.02,195.84
X$422 VGND \$2590 \$3073 \$2667 VPWR VPWR VGND sky130_fd_sc_hd__xnor2_2
* cell instance $423 r0 *1 167.9,92.48
X$423 VGND \$1542 \$1497 \$1490 VPWR VPWR VGND sky130_fd_sc_hd__xnor2_2
* cell instance $424 m0 *1 170.2,97.92
X$424 VGND \$1490 \$1611 \$1473 \$1468 VPWR VPWR VGND sky130_fd_sc_hd__o21bai_2
* cell instance $425 r0 *1 161.92,190.4
X$425 VGND \$2934 \$2823 \$2760 VPWR VPWR VGND sky130_fd_sc_hd__xnor2_2
* cell instance $426 r0 *1 167.9,21.76
X$426 VGND \$98 \$330 \$28 VPWR VPWR VGND sky130_fd_sc_hd__xnor2_2
* cell instance $427 r0 *1 173.88,21.76
X$427 VGND \$35 \$17 \$15 \$30 \$317 VPWR VPWR VGND sky130_fd_sc_hd__a22o_2
* cell instance $428 r0 *1 170.2,32.64
X$428 VGND \$147 \$554 \$589 VPWR VPWR VGND sky130_fd_sc_hd__xnor2_2
* cell instance $429 r0 *1 171.12,174.08
X$429 VGND \$2566 \$2995 \$2695 VPWR VPWR VGND sky130_fd_sc_hd__xnor2_2
* cell instance $430 r0 *1 76.82,43.52
X$430 VGND \$643 \$781 \$609 VPWR VPWR VGND sky130_fd_sc_hd__xnor2_2
* cell instance $431 r0 *1 165.14,174.08
X$431 VGND \$2701 \$2704 \$2667 VPWR VPWR VGND sky130_fd_sc_hd__xnor2_2
* cell instance $432 r0 *1 168.82,244.8
X$432 VGND \$3933 \$1413 \$1363 VPWR VPWR VGND sky130_fd_sc_hd__xnor2_2
* cell instance $433 r0 *1 156.86,184.96
X$433 VGND \$2695 \$2673 \$2826 VPWR VPWR VGND sky130_fd_sc_hd__xnor2_2
* cell instance $434 m90 *1 114.08,272
X$434 VPWR VGND \$4142 \$4187 \$4189 VPWR \$4148 \$4180 VGND
+ sky130_fd_sc_hd__or4_2
* cell instance $435 m0 *1 123.28,233.92
X$435 VPWR VGND \$3728 \$3755 \$3717 VPWR \$3663 \$3772 VGND
+ sky130_fd_sc_hd__or4_2
* cell instance $436 m0 *1 78.66,108.8
X$436 VPWR VGND \$425 \$27 \$340 VPWR \$1705 \$864 VGND sky130_fd_sc_hd__or4_2
* cell instance $437 r180 *1 113.16,136
X$437 VPWR VGND \$2068 \$2018 \$2021 VPWR \$2202 \$2079 VGND
+ sky130_fd_sc_hd__or4_2
* cell instance $438 r180 *1 109.94,76.16
X$438 VPWR VGND \$1273 \$1274 \$1272 VPWR \$1213 \$1275 VGND
+ sky130_fd_sc_hd__or4_2
* cell instance $439 r0 *1 122.82,212.16
X$439 VPWR VGND \$3276 \$3437 \$3368 VPWR \$3365 \$3369 VGND
+ sky130_fd_sc_hd__or4_2
* cell instance $440 r0 *1 120.52,87.04
X$440 VPWR VGND \$1404 \$1500 \$1503 VPWR \$1501 \$1403 VGND
+ sky130_fd_sc_hd__or4_2
* cell instance $441 r0 *1 114.08,201.28
X$441 VPWR VGND \$3158 \$3227 \$3162 VPWR \$3154 \$3157 VGND
+ sky130_fd_sc_hd__or4_2
* cell instance $442 r0 *1 115,59.84
X$442 VPWR VGND \$1143 \$1201 \$1140 VPWR \$1205 \$1202 VGND
+ sky130_fd_sc_hd__or4_2
* cell instance $445 m90 *1 186.3,38.08
X$445 VPWR VPWR VGND \$711 \$710 \$49 \$345 VGND sky130_fd_sc_hd__a21bo_2
* cell instance $446 m90 *1 180.78,206.72
X$446 VPWR \$3305 VPWR VGND \$3293 \$1826 \$3288 VGND sky130_fd_sc_hd__or3_2
* cell instance $447 m90 *1 77.74,54.4
X$447 VPWR \$979 VPWR VGND \$1170 \$1126 \$837 VGND sky130_fd_sc_hd__or3_2
* cell instance $448 m0 *1 171.12,195.84
X$448 VPWR \$3054 VPWR VGND \$2873 \$2657 \$2601 VGND sky130_fd_sc_hd__or3_2
* cell instance $449 m0 *1 179.86,217.6
X$449 VPWR \$3305 VPWR VGND \$3505 \$1915 \$3288 VGND sky130_fd_sc_hd__or3_2
* cell instance $450 m0 *1 165.14,217.6
X$450 VPWR \$3305 VPWR VGND \$3532 \$1984 \$3288 VGND sky130_fd_sc_hd__or3_2
* cell instance $451 r180 *1 164.68,27.2
X$451 VPWR \$115 VPWR VGND \$386 \$49 \$392 VGND sky130_fd_sc_hd__or3_2
* cell instance $452 r180 *1 180.78,212.16
X$452 VPWR \$3305 VPWR VGND \$3414 \$1936 \$3288 VGND sky130_fd_sc_hd__or3_2
* cell instance $453 r180 *1 164.68,212.16
X$453 VPWR \$3305 VPWR VGND \$3489 \$1976 \$3288 VGND sky130_fd_sc_hd__or3_2
* cell instance $454 r0 *1 180.78,212.16
X$454 VPWR \$3305 VPWR VGND \$3593 \$1933 \$3288 VGND sky130_fd_sc_hd__or3_2
* cell instance $455 r0 *1 184.92,16.32
X$455 VPWR \$17 VPWR VGND \$227 \$56 \$31 VGND sky130_fd_sc_hd__or3_2
* cell instance $456 r0 *1 166.06,206.72
X$456 VPWR \$3305 VPWR VGND \$3351 \$1822 \$3288 VGND sky130_fd_sc_hd__or3_2
* cell instance $457 r0 *1 178.02,212.16
X$457 VPWR \$3305 VPWR VGND \$3407 VGND \$3288 VGND sky130_fd_sc_hd__or3_2
* cell instance $458 r0 *1 161,43.52
X$458 VPWR \$703 VPWR VGND \$866 \$874 \$606 VGND sky130_fd_sc_hd__or3_2
* cell instance $459 r0 *1 178.02,114.24
X$459 VPWR \$1831 VPWR VGND \$1915 \$1902 \$1910 VGND sky130_fd_sc_hd__or3_2
* cell instance $460 r0 *1 174.8,48.96
X$460 VPWR \$635 VPWR VGND \$997 \$857 \$534 VGND sky130_fd_sc_hd__or3_2
* cell instance $461 r0 *1 157.78,21.76
X$461 VPWR \$14 VPWR VGND \$58 \$56 \$46 VGND sky130_fd_sc_hd__or3_2
* cell instance $462 m90 *1 163.76,21.76
X$462 VPWR \$143 VPWR \$288 VGND \$29 VGND sky130_fd_sc_hd__and2b_2
* cell instance $463 r0 *1 185.84,21.76
X$463 VPWR \$151 VPWR VGND \$306 \$56 \$14 VGND sky130_fd_sc_hd__or3_2
* cell instance $464 m90 *1 184,190.4
X$464 VGND \$3067 \$2599 \$2874 VPWR VPWR VGND sky130_fd_sc_hd__xor2_2
* cell instance $465 m90 *1 172.04,27.2
X$465 VGND \$347 \$416 \$79 VPWR VPWR VGND sky130_fd_sc_hd__xor2_2
* cell instance $466 m90 *1 176.64,27.2
X$466 VGND \$427 \$417 \$418 \$416 \$347 VPWR VPWR VGND
+ sky130_fd_sc_hd__and4bb_2
* cell instance $467 m0 *1 176.64,190.4
X$467 VGND \$2667 \$2910 \$2683 VPWR VPWR VGND sky130_fd_sc_hd__xor2_2
* cell instance $468 m0 *1 167.9,27.2
X$468 VGND \$425 \$382 \$330 VPWR VPWR VGND sky130_fd_sc_hd__xor2_2
* cell instance $469 m0 *1 78.2,54.4
X$469 VGND \$979 \$1037 \$1092 VPWR VPWR VGND sky130_fd_sc_hd__xor2_2
* cell instance $470 m0 *1 171.12,43.52
X$470 VGND \$791 \$792 \$718 VPWR VPWR VGND sky130_fd_sc_hd__xor2_2
* cell instance $471 m0 *1 165.14,184.96
X$471 VGND \$2826 \$2774 \$2830 VPWR VPWR VGND sky130_fd_sc_hd__xor2_2
* cell instance $472 m0 *1 166.98,201.28
X$472 VGND \$2760 \$3067 \$3103 VPWR VPWR VGND sky130_fd_sc_hd__xor2_2
* cell instance $473 m0 *1 171.12,32.64
X$473 VGND \$423 \$563 \$49 VPWR VPWR VGND sky130_fd_sc_hd__xor2_2
* cell instance $474 m0 *1 171.12,38.08
X$474 VGND \$589 \$554 \$572 VPWR VPWR VGND sky130_fd_sc_hd__xor2_2
* cell instance $475 r180 *1 178.94,174.08
X$475 VGND \$2673 \$2690 \$2744 VPWR VPWR VGND sky130_fd_sc_hd__xor2_2
* cell instance $476 r180 *1 188.6,190.4
X$476 VGND \$2673 \$2741 \$2974 VPWR VPWR VGND sky130_fd_sc_hd__xor2_2
* cell instance $477 r180 *1 179.86,27.2
X$477 VGND \$291 \$504 \$31 VPWR VPWR VGND sky130_fd_sc_hd__xor2_2
* cell instance $478 r180 *1 171.12,38.08
X$478 VGND \$418 \$486 \$645 VPWR VPWR VGND sky130_fd_sc_hd__xor2_2
* cell instance $479 r180 *1 171.12,32.64
X$479 VGND \$347 \$417 \$486 VPWR VPWR VGND sky130_fd_sc_hd__xor2_2
* cell instance $480 r180 *1 177.1,206.72
X$480 VGND \$2673 \$3067 \$3073 VPWR VPWR VGND sky130_fd_sc_hd__xor2_2
* cell instance $481 r0 *1 28.98,141.44
X$481 VGND \$425 \$2174 \$2247 VPWR VPWR VGND sky130_fd_sc_hd__xor2_2
* cell instance $482 r0 *1 27.14,103.36
X$482 VGND \$417 \$1754 \$1791 VPWR VPWR VGND sky130_fd_sc_hd__xor2_2
* cell instance $483 r0 *1 178.02,174.08
X$483 VGND \$2667 \$2826 \$3085 VPWR VPWR VGND sky130_fd_sc_hd__xor2_2
* cell instance $484 r0 *1 170.2,201.28
X$484 VGND \$2823 \$2917 \$3209 VPWR VPWR VGND sky130_fd_sc_hd__xor2_2
* cell instance $485 m90 *1 175.26,130.56
X$485 VGND \$2110 \$2037 \$2033 \$2084 \$2029 \$2043 VPWR VPWR VGND
+ sky130_fd_sc_hd__o221a_2
* cell instance $486 r180 *1 160.54,190.4
X$486 VGND \$3185 \$2565 \$2681 \$2786 \$2922 \$2667 VPWR VPWR VGND
+ sky130_fd_sc_hd__o221a_2
* cell instance $487 m90 *1 125.58,250.24
X$487 VPWR \$4019 \$3960 select VPWR I VGND \$3896 VGND sky130_fd_sc_hd__a31o_2
* cell instance $488 m90 *1 172.04,108.8
X$488 VPWR \$1936 \$1823 \$1362 VPWR \$1413 VGND \$1842 VGND
+ sky130_fd_sc_hd__a31o_2
* cell instance $489 m90 *1 112.7,130.56
X$489 VPWR \$2127 \$2019 select VPWR I VGND \$2017 VGND sky130_fd_sc_hd__a31o_2
* cell instance $490 m90 *1 116.84,103.36
X$490 VPWR \$1774 \$1740 select VPWR I VGND \$1742 VGND sky130_fd_sc_hd__a31o_2
* cell instance $491 m90 *1 74.52,48.96
X$491 VPWR \$1021 \$969 \$836 VPWR \$609 VGND \$782 VGND sky130_fd_sc_hd__a31o_2
* cell instance $492 m90 *1 161.92,32.64
X$492 VPWR \$601 \$418 \$417 VPWR \$416 VGND \$606 VGND sky130_fd_sc_hd__a31o_2
* cell instance $493 r0 *1 161.92,32.64
X$493 VGND \$492 \$407 \$49 \$520 \$147 \$439 VPWR VPWR VGND
+ sky130_fd_sc_hd__o311a_2
* cell instance $494 m90 *1 170.2,32.64
X$494 VGND \$521 \$382 \$425 \$417 \$476 VPWR VPWR VGND
+ sky130_fd_sc_hd__o2bb2a_2
* cell instance $495 m90 *1 28.98,97.92
X$495 VPWR \$1642 \$347 select VPWR \$1558 VGND \$416 VGND
+ sky130_fd_sc_hd__a31o_2
* cell instance $496 m0 *1 70.84,157.76
X$496 VPWR \$2438 \$2420 select VPWR I VGND \$2266 VGND sky130_fd_sc_hd__a31o_2
* cell instance $497 m0 *1 126.5,288.32
X$497 VPWR \$4346 \$4294 select VPWR I VGND \$4285 VGND sky130_fd_sc_hd__a31o_2
* cell instance $498 m0 *1 125.58,282.88
X$498 VPWR \$4240 \$4242 select VPWR I VGND \$4197 VGND sky130_fd_sc_hd__a31o_2
* cell instance $499 m0 *1 30.82,206.72
X$499 VPWR \$3200 select \$1507 VPWR \$1558 VGND \$3143 VGND
+ sky130_fd_sc_hd__a31o_2
* cell instance $500 m0 *1 120.52,223.04
X$500 VPWR \$3563 \$3568 select VPWR I VGND \$3481 VGND sky130_fd_sc_hd__a31o_2
* cell instance $501 m0 *1 123.28,239.36
X$501 VPWR \$3830 \$3767 select VPWR I VGND \$3765 VGND sky130_fd_sc_hd__a31o_2
* cell instance $502 m0 *1 124.66,76.16
X$502 VPWR \$1283 \$1287 select VPWR I VGND \$1288 VGND sky130_fd_sc_hd__a31o_2
* cell instance $503 m0 *1 71.3,54.4
X$503 VPWR \$1173 \$969 \$836 VPWR \$880 VGND \$929 VGND sky130_fd_sc_hd__a31o_2
* cell instance $504 r180 *1 113.16,97.92
X$504 VPWR \$1629 \$1439 select VPWR I VGND \$1454 VGND sky130_fd_sc_hd__a31o_2
* cell instance $505 r180 *1 83.26,97.92
X$505 VPWR \$1620 \$1701 select VPWR \$1558 VGND \$1513 VGND
+ sky130_fd_sc_hd__a31o_2
* cell instance $506 r180 *1 164.68,174.08
X$506 VPWR \$2703 \$2563 \$2656 VPWR \$1362 VGND \$2663 VGND
+ sky130_fd_sc_hd__a31o_2
* cell instance $507 r180 *1 183.08,48.96
X$507 VPWR \$954 \$368 \$166 VPWR \$572 VGND \$718 VGND sky130_fd_sc_hd__a31o_2
* cell instance $508 r180 *1 119.14,119.68
X$508 VPWR \$2004 \$1961 select VPWR I VGND \$1960 VGND sky130_fd_sc_hd__a31o_2
* cell instance $509 r180 *1 158.7,184.96
X$509 VPWR \$2782 \$2822 \$2878 VPWR \$2918 VGND \$2886 VGND
+ sky130_fd_sc_hd__a31o_2
* cell instance $510 r0 *1 117.3,261.12
X$510 \$I12015 \$4119 \$4034 select VPWR I VGND \$4033 VGND
+ sky130_fd_sc_hd__a31o_2
* cell instance $511 r0 *1 115,54.4
X$511 \$I10490 \$967 \$1046 select VPWR I VGND \$1048 VGND
+ sky130_fd_sc_hd__a31o_2
* cell instance $512 r180 *1 120.52,59.84
X$512 VGND \$1046 \$899 \$760 \$1050 \$984 VPWR \$I10490 VGND
+ sky130_fd_sc_hd__nor4_2
* cell instance $513 r0 *1 112.7,141.44
X$513 VPWR \$2271 \$2146 select VPWR I VGND \$2211 VGND sky130_fd_sc_hd__a31o_2
* cell instance $514 r0 *1 120.52,190.4
X$514 \$I13591 \$2906 \$2988 select VPWR I VGND \$2905 VGND
+ sky130_fd_sc_hd__a31o_2
* cell instance $534 m90 *1 174.8,146.88
X$534 VPWR \$1363 VPWR \$2236 VGND \$1362 \$2305 \$2323 VGND
+ sky130_fd_sc_hd__o211a_2
* cell instance $535 m90 *1 174.8,48.96
X$535 VPWR \$797 VPWR \$858 VGND \$1074 \$718 \$984 VGND
+ sky130_fd_sc_hd__o211a_2
* cell instance $536 m0 *1 181.24,43.52
X$536 VPWR \$997 VPWR \$797 VGND \$954 \$492 \$760 VGND sky130_fd_sc_hd__o211a_2
* cell instance $537 m0 *1 36.34,103.36
X$537 VPWR \$1839 VPWR \$1642 VGND \$1566 \$1532 \$1765 VGND
+ sky130_fd_sc_hd__o211a_2
* cell instance $538 m0 *1 165.14,244.8
X$538 VPWR \$3846 VPWR \$3841 VGND \$3842 \$1527 \$4002 VGND
+ sky130_fd_sc_hd__o211a_2
* cell instance $539 m0 *1 168.82,244.8
X$539 VGND \$1527 \$3182 \$3865 VPWR VPWR VGND sky130_fd_sc_hd__dfxtp_2
* cell instance $540 r180 *1 174.8,141.44
X$540 \$I13343 \$2168 VPWR \$2100 VGND \$2043 \$1363 \$2161 VGND
+ sky130_fd_sc_hd__o211a_2
* cell instance $541 r180 *1 164.68,32.64
X$541 VPWR \$386 VPWR \$147 VGND \$30 \$413 \$534 VGND sky130_fd_sc_hd__o211a_2
* cell instance $542 r180 *1 176.64,54.4
X$542 VPWR \$797 VPWR \$907 VGND \$856 \$718 \$1050 VGND
+ sky130_fd_sc_hd__o211a_2
* cell instance $543 r180 *1 170.2,48.96
X$543 VPWR \$797 VPWR \$717 VGND \$804 \$718 \$899 VGND sky130_fd_sc_hd__o211a_2
* cell instance $544 r180 *1 85.56,108.8
X$544 VPWR select VPWR \$1783 VGND \$1650 \$1652 \$1728 VGND
+ sky130_fd_sc_hd__o211a_2
* cell instance $545 r0 *1 162.38,27.2
X$545 VPWR \$418 VPWR \$417 VGND \$416 \$347 \$421 VGND sky130_fd_sc_hd__o211a_2
* cell instance $546 m90 *1 177.56,146.88
X$546 VPWR \$1413 VPWR \$2236 \$2314 VGND \$2319 VGND sky130_fd_sc_hd__and3_2
* cell instance $547 m90 *1 94.3,48.96
X$547 VPWR \$689 VPWR \$688 \$837 VGND \$969 VGND sky130_fd_sc_hd__and3_2
* cell instance $548 m90 *1 82.8,59.84
X$548 \$I10294 \$1126 VPWR I select VGND \$836 VGND sky130_fd_sc_hd__and3_2
* cell instance $549 m90 *1 70.84,152.32
X$549 VPWR \$2449 VPWR \$2448 \$2417 VGND \$2452 VGND sky130_fd_sc_hd__and3_2
* cell instance $550 m90 *1 177.56,184.96
X$550 VPWR \$1413 VPWR \$1363 \$1362 VGND \$2991 VGND sky130_fd_sc_hd__and3_2
* cell instance $551 m90 *1 27.14,146.88
X$551 VPWR \$27 VPWR \$340 select VGND \$2174 VGND sky130_fd_sc_hd__and3_2
* cell instance $552 m0 *1 173.88,239.36
X$552 \$I10290 \$3846 VPWR \$3607 \$3850 VGND O[5] VGND sky130_fd_sc_hd__and3_2
* cell instance $553 m0 *1 28.06,97.92
X$553 VPWR \$1558 VPWR select \$1532 VGND \$1564 VGND sky130_fd_sc_hd__and3_2
* cell instance $554 m0 *1 176.64,255.68
X$554 VPWR \$3846 VPWR \$3606 \$3850 VGND O[3] VGND sky130_fd_sc_hd__and3_2
* cell instance $555 m0 *1 87.86,54.4
X$555 VPWR \$1038 VPWR \$1095 \$880 VGND or4b_85_c VGND sky130_fd_sc_hd__and3_2
* cell instance $556 m0 *1 180.32,250.24
X$556 VPWR \$3846 VPWR \$3609 \$3850 VGND O[4] VGND sky130_fd_sc_hd__and3_2
* cell instance $557 m0 *1 165.14,250.24
X$557 VPWR \$3846 VPWR \$3501 \$3850 VGND O[6] VGND sky130_fd_sc_hd__and3_2
* cell instance $558 m0 *1 176.64,244.8
X$558 VPWR \$3846 VPWR \$3853 \$3850 VGND O[1] VGND sky130_fd_sc_hd__and3_2
* cell instance $559 r180 *1 164.68,48.96
X$559 VPWR \$865 VPWR \$986 \$866 VGND \$1058 VGND sky130_fd_sc_hd__and3_2
* cell instance $560 r180 *1 81.88,27.2
X$560 \$I10282 \$314 VPWR \$376 \$373 VGND \$375 VGND sky130_fd_sc_hd__and3_2
* cell instance $561 r180 *1 85.56,27.2
X$561 \$I10282 \$378 VPWR \$441 \$442 \$376 \$381 VGND VGND
+ sky130_fd_sc_hd__and4_2
* cell instance $562 r180 *1 72.22,48.96
X$562 VPWR \$689 VPWR \$688 \$836 VGND \$593 VGND sky130_fd_sc_hd__and3_2
* cell instance $563 m0 *1 72.22,48.96
X$563 VPWR \$1170 \$730 VGND \$782 VPWR \$929 VGND sky130_fd_sc_hd__nor3_2
* cell instance $564 r180 *1 79.12,27.2
X$564 \$I10282 \$1128 VPWR \$374 \$591 VGND \$373 VGND sky130_fd_sc_hd__and3_2
* cell instance $565 r0 *1 185.38,43.52
X$565 VPWR \$35 VPWR \$569 \$23 VGND \$50 VGND sky130_fd_sc_hd__and3_2
* cell instance $566 r0 *1 154.56,38.08
X$566 VPWR \$664 VPWR \$556 \$665 VGND \$703 VGND sky130_fd_sc_hd__and3_2
* cell instance $567 r0 *1 169.28,152.32
X$567 VPWR \$1413 VPWR \$1363 \$1362 VGND \$2238 VGND sky130_fd_sc_hd__and3_2
* cell instance $569 r0 *1 174.8,244.8
X$569 VPWR \$3846 VPWR \$3512 \$3850 VGND O[7] VGND sky130_fd_sc_hd__and3_2
* cell instance $570 r0 *1 171.12,54.4
X$570 \$I13345 \$147 VPWR \$78 \$1002 VGND \$805 VGND sky130_fd_sc_hd__and3_2
* cell instance $571 r0 *1 74.98,157.76
X$571 VPWR \$2512 VPWR \$2593 \$2452 VGND \$2454 VGND sky130_fd_sc_hd__and3_2
* cell instance $572 r0 *1 178.02,244.8
X$572 VPWR \$3846 VPWR \$3702 \$3850 VGND O[0] VGND sky130_fd_sc_hd__and3_2
* cell instance $573 r0 *1 180.78,244.8
X$573 VPWR \$3846 VPWR \$3494 \$3850 VGND O[2] VGND sky130_fd_sc_hd__and3_2
* cell instance $574 m90 *1 82.8,141.44
X$574 VGND \$2138 \$2185 \$2135 select VPWR VPWR VGND sky130_fd_sc_hd__mux2_1
* cell instance $575 m90 *1 84.18,152.32
X$575 VGND \$2379 \$2224 \$2377 select VPWR VPWR VGND sky130_fd_sc_hd__mux2_1
* cell instance $576 m90 *1 182.16,27.2
X$576 VGND \$430 \$306 \$58 \$31 VPWR VPWR VGND sky130_fd_sc_hd__mux2_1
* cell instance $577 r0 *1 182.16,27.2
X$577 VPWR VPWR \$345 VGND \$443 \$81 \$35 VGND sky130_fd_sc_hd__o21ba_2
* cell instance $578 m90 *1 81.88,136
X$578 VGND \$2136 \$2104 \$2185 select VPWR VPWR VGND sky130_fd_sc_hd__mux2_1
* cell instance $579 m90 *1 73.6,146.88
X$579 VGND \$2190 \$2265 \$2223 select VPWR VPWR VGND sky130_fd_sc_hd__mux2_1
* cell instance $580 m90 *1 74.52,141.44
X$580 VGND \$2108 \$2222 \$2104 select VPWR VPWR VGND sky130_fd_sc_hd__mux2_1
* cell instance $581 m0 *1 87.86,146.88
X$581 VGND \$2352 \$2135 \$2224 select VPWR VPWR VGND sky130_fd_sc_hd__mux2_1
* cell instance $582 m0 *1 76.82,103.36
X$582 VGND \$1695 \$1773 \$1558 \$1700 VPWR VPWR VGND sky130_fd_sc_hd__mux2_1
* cell instance $583 m0 *1 79.12,163.2
X$583 VGND \$2596 \$2457 \$2544 select VPWR VPWR VGND sky130_fd_sc_hd__mux2_1
* cell instance $584 m0 *1 80.96,103.36
X$584 VGND \$1701 \$1783 \$1650 \$1652 VPWR VPWR VGND sky130_fd_sc_hd__mux2_1
* cell instance $585 m0 *1 85.1,103.36
X$585 VPWR VGND \$1787 VPWR \$1705 VGND sky130_fd_sc_hd__buf_2
* cell instance $586 r180 *1 92,157.76
X$586 VGND \$2527 I Q00 select VPWR VPWR VGND sky130_fd_sc_hd__mux2_1
* cell instance $587 r180 *1 74.52,146.88
X$587 VGND \$2267 \$2223 \$2222 select VPWR VPWR VGND sky130_fd_sc_hd__mux2_1
* cell instance $588 r180 *1 40.48,97.92
X$588 VGND \$1537 \$1566 \$1564 \$347 VPWR VPWR VGND sky130_fd_sc_hd__mux2_1
* cell instance $589 r180 *1 181.24,38.08
X$589 VGND \$627 \$317 \$631 \$49 VPWR VPWR VGND sky130_fd_sc_hd__mux2_1
* cell instance $590 r180 *1 185.38,38.08
X$590 VGND \$676 \$49 \$520 \$55 \$179 \$380 VPWR VPWR VGND
+ sky130_fd_sc_hd__o32a_2
* cell instance $591 r180 *1 79.12,163.2
X$591 VGND \$2437 \$2544 \$2376 select VPWR VPWR VGND sky130_fd_sc_hd__mux2_1
* cell instance $592 r0 *1 178.02,43.52
X$592 VGND \$856 \$83 \$811 \$572 VPWR VPWR VGND sky130_fd_sc_hd__mux2_1
* cell instance $593 r0 *1 75.9,152.32
X$593 VGND \$2423 \$2376 \$2265 select VPWR VPWR VGND sky130_fd_sc_hd__mux2_1
* cell instance $594 r0 *1 182.62,32.64
X$594 VGND \$558 \$35 \$30 \$51 VPWR VPWR VGND sky130_fd_sc_hd__mux2_1
* cell instance $595 r0 *1 77.74,157.76
X$595 VGND \$2521 Q00 \$2457 select VPWR VPWR VGND sky130_fd_sc_hd__mux2_1
* cell instance $596 r0 *1 168.82,136
X$596 VGND \$2048 \$1527 \$1363 \$1362 VPWR \$I13343 VGND
+ sky130_fd_sc_hd__mux2_1
* cell instance $597 m90 *1 189.98,21.76
X$597 VPWR VGND VPWR VGND sky130_fd_sc_hd__decap_3
* cell instance $598 m90 *1 189.98,103.36
X$598 \$I10026 VGND VPWR VGND sky130_fd_sc_hd__decap_3
* cell instance $599 m90 *1 189.98,27.2
X$599 \$I10025 VGND VPWR VGND sky130_fd_sc_hd__decap_3
* cell instance $600 m90 *1 189.98,16.32
X$600 \$I10024 VGND VPWR VGND sky130_fd_sc_hd__decap_3
* cell instance $601 m90 *1 189.98,10.88
X$601 VPWR VGND VPWR VGND sky130_fd_sc_hd__decap_3
* cell instance $602 m90 *1 189.98,114.24
X$602 \$I10022 VGND VPWR VGND sky130_fd_sc_hd__decap_3
* cell instance $603 m90 *1 189.98,266.56
X$603 \$I10021 VGND VPWR VGND sky130_fd_sc_hd__decap_3
* cell instance $604 m90 *1 189.98,277.44
X$604 \$I10020 VGND VPWR VGND sky130_fd_sc_hd__decap_3
* cell instance $605 m90 *1 189.98,97.92
X$605 \$I10019 VGND VPWR VGND sky130_fd_sc_hd__decap_3
* cell instance $606 m90 *1 189.98,76.16
X$606 \$I10018 VGND VPWR VGND sky130_fd_sc_hd__decap_3
* cell instance $607 m90 *1 189.98,92.48
X$607 \$I10017 VGND VPWR VGND sky130_fd_sc_hd__decap_3
* cell instance $608 m90 *1 189.98,87.04
X$608 \$I10016 VGND VPWR VGND sky130_fd_sc_hd__decap_3
* cell instance $609 m90 *1 189.98,282.88
X$609 \$I10015 VGND VPWR VGND sky130_fd_sc_hd__decap_3
* cell instance $610 m90 *1 189.98,272
X$610 \$I10014 VGND VPWR VGND sky130_fd_sc_hd__decap_3
* cell instance $611 m90 *1 189.98,261.12
X$611 \$I10013 VGND VPWR VGND sky130_fd_sc_hd__decap_3
* cell instance $612 m90 *1 189.98,250.24
X$612 \$I10012 VGND VPWR VGND sky130_fd_sc_hd__decap_3
* cell instance $613 m90 *1 189.98,255.68
X$613 \$I10011 VGND VPWR VGND sky130_fd_sc_hd__decap_3
* cell instance $614 m90 *1 189.98,141.44
X$614 \$I10010 VGND VPWR VGND sky130_fd_sc_hd__decap_3
* cell instance $615 m90 *1 189.98,152.32
X$615 \$I10009 VGND VPWR VGND sky130_fd_sc_hd__decap_3
* cell instance $616 m90 *1 189.98,146.88
X$616 \$I10008 VGND VPWR VGND sky130_fd_sc_hd__decap_3
* cell instance $617 m90 *1 189.98,32.64
X$617 VPWR VGND VPWR VGND sky130_fd_sc_hd__decap_3
* cell instance $618 m90 *1 189.98,81.6
X$618 \$I10006 VGND VPWR VGND sky130_fd_sc_hd__decap_3
* cell instance $619 m90 *1 189.98,125.12
X$619 \$I10005 VGND VPWR VGND sky130_fd_sc_hd__decap_3
* cell instance $620 m90 *1 189.98,130.56
X$620 \$I10004 VGND VPWR VGND sky130_fd_sc_hd__decap_3
* cell instance $621 m90 *1 189.98,43.52
X$621 \$I10003 VGND VPWR VGND sky130_fd_sc_hd__decap_3
* cell instance $622 m90 *1 189.98,157.76
X$622 \$I10002 VGND VPWR VGND sky130_fd_sc_hd__decap_3
* cell instance $623 m90 *1 189.98,48.96
X$623 \$I10001 VGND VPWR VGND sky130_fd_sc_hd__decap_3
* cell instance $624 m90 *1 189.98,38.08
X$624 VPWR VGND VPWR VGND sky130_fd_sc_hd__decap_3
* cell instance $625 m90 *1 189.98,136
X$625 \$I9999 VGND VPWR VGND sky130_fd_sc_hd__decap_3
* cell instance $626 m90 *1 189.98,239.36
X$626 \$I9998 VGND VPWR VGND sky130_fd_sc_hd__decap_3
* cell instance $627 m90 *1 189.98,201.28
X$627 \$I9997 VGND VPWR VGND sky130_fd_sc_hd__decap_3
* cell instance $628 m90 *1 189.98,179.52
X$628 VPWR VGND VPWR VGND sky130_fd_sc_hd__decap_3
* cell instance $629 m90 *1 189.98,190.4
X$629 \$I9995 VGND VPWR VGND sky130_fd_sc_hd__decap_3
* cell instance $630 m90 *1 189.98,184.96
X$630 VPWR VGND VPWR VGND sky130_fd_sc_hd__decap_3
* cell instance $631 m90 *1 189.98,195.84
X$631 \$I9993 VGND VPWR VGND sky130_fd_sc_hd__decap_3
* cell instance $632 m90 *1 189.98,217.6
X$632 \$I9992 VGND VPWR VGND sky130_fd_sc_hd__decap_3
* cell instance $633 m90 *1 189.98,206.72
X$633 \$I9991 VGND VPWR VGND sky130_fd_sc_hd__decap_3
* cell instance $634 m90 *1 189.98,212.16
X$634 \$I9990 VGND VPWR VGND sky130_fd_sc_hd__decap_3
* cell instance $635 m90 *1 189.98,119.68
X$635 \$I9989 VGND VPWR VGND sky130_fd_sc_hd__decap_3
* cell instance $636 m90 *1 189.98,70.72
X$636 \$I9988 VGND VPWR VGND sky130_fd_sc_hd__decap_3
* cell instance $637 m90 *1 189.98,108.8
X$637 \$I9987 VGND VPWR VGND sky130_fd_sc_hd__decap_3
* cell instance $638 m90 *1 189.98,65.28
X$638 \$I9986 VGND VPWR VGND sky130_fd_sc_hd__decap_3
* cell instance $639 m90 *1 189.98,54.4
X$639 \$I9985 VGND VPWR VGND sky130_fd_sc_hd__decap_3
* cell instance $640 m90 *1 189.98,223.04
X$640 \$I9984 VGND VPWR VGND sky130_fd_sc_hd__decap_3
* cell instance $641 m90 *1 189.98,228.48
X$641 \$I9983 VGND VPWR VGND sky130_fd_sc_hd__decap_3
* cell instance $642 m90 *1 189.98,244.8
X$642 \$I9982 VGND VPWR VGND sky130_fd_sc_hd__decap_3
* cell instance $643 m90 *1 189.98,163.2
X$643 \$I9981 VGND VPWR VGND sky130_fd_sc_hd__decap_3
* cell instance $644 m90 *1 189.98,174.08
X$644 \$I9980 VGND VPWR VGND sky130_fd_sc_hd__decap_3
* cell instance $645 m90 *1 189.98,168.64
X$645 \$I9979 VGND VPWR VGND sky130_fd_sc_hd__decap_3
* cell instance $646 m90 *1 189.98,233.92
X$646 \$I9978 VGND VPWR VGND sky130_fd_sc_hd__decap_3
* cell instance $647 m90 *1 189.98,59.84
X$647 \$I9977 VGND VPWR VGND sky130_fd_sc_hd__decap_3
* cell instance $648 m0 *1 10.12,239.36
X$648 \$I9976 VGND VPWR VGND sky130_fd_sc_hd__decap_3
* cell instance $649 m0 *1 10.12,228.48
X$649 \$I9975 VGND VPWR VGND sky130_fd_sc_hd__decap_3
* cell instance $650 m0 *1 10.12,244.8
X$650 \$I9974 VGND VPWR VGND sky130_fd_sc_hd__decap_3
* cell instance $651 m0 *1 10.12,54.4
X$651 \$I9973 VGND VPWR VGND sky130_fd_sc_hd__decap_3
* cell instance $652 m0 *1 10.12,212.16
X$652 \$I9972 VGND VPWR VGND sky130_fd_sc_hd__decap_3
* cell instance $653 m0 *1 10.12,217.6
X$653 \$I9971 VGND VPWR VGND sky130_fd_sc_hd__decap_3
* cell instance $654 m0 *1 10.12,288.32
X$654 \$I9970 VGND VPWR VGND sky130_fd_sc_hd__decap_3
* cell instance $655 m0 *1 10.12,233.92
X$655 \$I9969 VGND VPWR VGND sky130_fd_sc_hd__decap_3
* cell instance $656 m0 *1 10.12,261.12
X$656 \$I9968 VGND VPWR VGND sky130_fd_sc_hd__decap_3
* cell instance $657 m0 *1 10.12,266.56
X$657 \$I9967 VGND VPWR VGND sky130_fd_sc_hd__decap_3
* cell instance $658 m0 *1 10.12,255.68
X$658 \$I9966 VGND VPWR VGND sky130_fd_sc_hd__decap_3
* cell instance $659 m0 *1 10.12,282.88
X$659 \$I9965 VGND VPWR VGND sky130_fd_sc_hd__decap_3
* cell instance $660 m0 *1 10.12,21.76
X$660 \$I9964 VGND VPWR VGND sky130_fd_sc_hd__decap_3
* cell instance $661 m0 *1 10.12,250.24
X$661 \$I9963 VGND VPWR VGND sky130_fd_sc_hd__decap_3
* cell instance $662 m0 *1 10.12,272
X$662 \$I9962 VGND VPWR VGND sky130_fd_sc_hd__decap_3
* cell instance $663 m0 *1 10.12,277.44
X$663 \$I9961 VGND VPWR VGND sky130_fd_sc_hd__decap_3
* cell instance $664 m0 *1 10.12,65.28
X$664 \$I9960 VGND VPWR VGND sky130_fd_sc_hd__decap_3
* cell instance $665 m0 *1 10.12,32.64
X$665 \$I9959 VGND VPWR VGND sky130_fd_sc_hd__decap_3
* cell instance $666 m0 *1 10.12,76.16
X$666 \$I9958 VGND VPWR VGND sky130_fd_sc_hd__decap_3
* cell instance $667 m0 *1 10.12,146.88
X$667 \$I9957 VGND VPWR VGND sky130_fd_sc_hd__decap_3
* cell instance $668 m0 *1 10.12,130.56
X$668 \$I9956 VGND VPWR VGND sky130_fd_sc_hd__decap_3
* cell instance $669 m0 *1 10.12,136
X$669 \$I9955 VGND VPWR VGND sky130_fd_sc_hd__decap_3
* cell instance $670 m0 *1 10.12,125.12
X$670 \$I9954 VGND VPWR VGND sky130_fd_sc_hd__decap_3
* cell instance $671 m0 *1 10.12,152.32
X$671 \$I9953 VGND VPWR VGND sky130_fd_sc_hd__decap_3
* cell instance $672 m0 *1 10.12,157.76
X$672 \$I9952 VGND VPWR VGND sky130_fd_sc_hd__decap_3
* cell instance $673 m0 *1 10.12,141.44
X$673 \$I9951 VGND VPWR VGND sky130_fd_sc_hd__decap_3
* cell instance $674 m0 *1 10.12,201.28
X$674 \$I9950 VGND VPWR VGND sky130_fd_sc_hd__decap_3
* cell instance $675 m0 *1 10.12,184.96
X$675 \$I9949 VGND VPWR VGND sky130_fd_sc_hd__decap_3
* cell instance $676 m0 *1 10.12,174.08
X$676 \$I9948 VGND VPWR VGND sky130_fd_sc_hd__decap_3
* cell instance $677 m0 *1 10.12,179.52
X$677 \$I9947 VGND VPWR VGND sky130_fd_sc_hd__decap_3
* cell instance $678 m0 *1 10.12,195.84
X$678 \$I9946 VGND VPWR VGND sky130_fd_sc_hd__decap_3
* cell instance $679 m0 *1 10.12,190.4
X$679 \$I9945 VGND VPWR VGND sky130_fd_sc_hd__decap_3
* cell instance $680 m0 *1 10.12,27.2
X$680 \$I9944 VGND VPWR VGND sky130_fd_sc_hd__decap_3
* cell instance $681 m0 *1 10.12,92.48
X$681 \$I9943 VGND VPWR VGND sky130_fd_sc_hd__decap_3
* cell instance $682 m0 *1 10.12,87.04
X$682 \$I9942 VGND VPWR VGND sky130_fd_sc_hd__decap_3
* cell instance $683 m0 *1 10.12,81.6
X$683 \$I9941 VGND VPWR VGND sky130_fd_sc_hd__decap_3
* cell instance $684 m0 *1 10.12,97.92
X$684 \$I9940 VGND VPWR VGND sky130_fd_sc_hd__decap_3
* cell instance $685 m0 *1 10.12,163.2
X$685 \$I9939 VGND VPWR VGND sky130_fd_sc_hd__decap_3
* cell instance $686 m0 *1 10.12,114.24
X$686 \$I9938 VGND VPWR VGND sky130_fd_sc_hd__decap_3
* cell instance $687 m0 *1 10.12,108.8
X$687 \$I9937 VGND VPWR VGND sky130_fd_sc_hd__decap_3
* cell instance $688 m0 *1 10.12,103.36
X$688 \$I9936 VGND VPWR VGND sky130_fd_sc_hd__decap_3
* cell instance $689 m0 *1 10.12,59.84
X$689 \$I9935 VGND VPWR VGND sky130_fd_sc_hd__decap_3
* cell instance $690 m0 *1 10.12,48.96
X$690 \$I9934 VGND VPWR VGND sky130_fd_sc_hd__decap_3
* cell instance $691 m0 *1 10.12,70.72
X$691 \$I9933 VGND VPWR VGND sky130_fd_sc_hd__decap_3
* cell instance $692 m0 *1 10.12,223.04
X$692 \$I9932 VGND VPWR VGND sky130_fd_sc_hd__decap_3
* cell instance $693 m0 *1 10.12,206.72
X$693 \$I9931 VGND VPWR VGND sky130_fd_sc_hd__decap_3
* cell instance $694 m0 *1 10.12,38.08
X$694 \$I9930 VGND VPWR VGND sky130_fd_sc_hd__decap_3
* cell instance $695 m0 *1 10.12,43.52
X$695 \$I9929 VGND VPWR VGND sky130_fd_sc_hd__decap_3
* cell instance $696 m0 *1 10.12,168.64
X$696 \$I9928 VGND VPWR VGND sky130_fd_sc_hd__decap_3
* cell instance $697 m0 *1 10.12,119.68
X$697 \$I9927 VGND VPWR VGND sky130_fd_sc_hd__decap_3
* cell instance $698 r180 *1 189.98,103.36
X$698 \$I10019 VGND VPWR VGND sky130_fd_sc_hd__decap_3
* cell instance $699 r180 *1 189.98,65.28
X$699 \$I9977 VGND VPWR VGND sky130_fd_sc_hd__decap_3
* cell instance $700 r180 *1 189.98,141.44
X$700 \$I9999 VGND VPWR VGND sky130_fd_sc_hd__decap_3
* cell instance $701 r180 *1 189.98,195.84
X$701 \$I9995 VGND VPWR VGND sky130_fd_sc_hd__decap_3
* cell instance $702 r180 *1 189.98,130.56
X$702 \$I10005 VGND VPWR VGND sky130_fd_sc_hd__decap_3
* cell instance $703 r180 *1 189.98,272
X$703 \$I10021 VGND VPWR VGND sky130_fd_sc_hd__decap_3
* cell instance $704 r180 *1 189.98,206.72
X$704 \$I9997 VGND VPWR VGND sky130_fd_sc_hd__decap_3
* cell instance $705 r180 *1 189.98,282.88
X$705 \$I10020 VGND VPWR VGND sky130_fd_sc_hd__decap_3
* cell instance $706 r180 *1 189.98,277.44
X$706 \$I10014 VGND VPWR VGND sky130_fd_sc_hd__decap_3
* cell instance $707 r180 *1 189.98,97.92
X$707 \$I10017 VGND VPWR VGND sky130_fd_sc_hd__decap_3
* cell instance $708 r180 *1 189.98,87.04
X$708 \$I10006 VGND VPWR VGND sky130_fd_sc_hd__decap_3
* cell instance $709 r180 *1 189.98,16.32
X$709 VPWR VGND VPWR VGND sky130_fd_sc_hd__decap_3
* cell instance $710 r180 *1 189.98,136
X$710 \$I10004 VGND VPWR VGND sky130_fd_sc_hd__decap_3
* cell instance $711 r180 *1 189.98,119.68
X$711 \$I10022 VGND VPWR VGND sky130_fd_sc_hd__decap_3
* cell instance $712 r180 *1 189.98,223.04
X$712 \$I9992 VGND VPWR VGND sky130_fd_sc_hd__decap_3
* cell instance $713 r180 *1 189.98,184.96
X$713 VPWR VGND VPWR VGND sky130_fd_sc_hd__decap_3
* cell instance $714 r180 *1 189.98,217.6
X$714 \$I9990 VGND VPWR VGND sky130_fd_sc_hd__decap_3
* cell instance $715 r180 *1 189.98,21.76
X$715 \$I10024 VGND VPWR VGND sky130_fd_sc_hd__decap_3
* cell instance $716 r180 *1 189.98,27.2
X$716 VPWR VGND VPWR VGND sky130_fd_sc_hd__decap_3
* cell instance $717 r180 *1 189.98,288.32
X$717 \$I10015 VGND VPWR VGND sky130_fd_sc_hd__decap_3
* cell instance $718 r180 *1 189.98,255.68
X$718 \$I10012 VGND VPWR VGND sky130_fd_sc_hd__decap_3
* cell instance $719 r180 *1 189.98,190.4
X$719 VPWR VGND VPWR VGND sky130_fd_sc_hd__decap_3
* cell instance $720 r180 *1 189.98,228.48
X$720 \$I9984 VGND VPWR VGND sky130_fd_sc_hd__decap_3
* cell instance $721 r180 *1 189.98,81.6
X$721 \$I10018 VGND VPWR VGND sky130_fd_sc_hd__decap_3
* cell instance $722 r180 *1 189.98,250.24
X$722 \$I9982 VGND VPWR VGND sky130_fd_sc_hd__decap_3
* cell instance $723 r180 *1 189.98,201.28
X$723 \$I9993 VGND VPWR VGND sky130_fd_sc_hd__decap_3
* cell instance $724 r180 *1 189.98,261.12
X$724 \$I10011 VGND VPWR VGND sky130_fd_sc_hd__decap_3
* cell instance $725 r180 *1 189.98,239.36
X$725 \$I9978 VGND VPWR VGND sky130_fd_sc_hd__decap_3
* cell instance $726 r180 *1 189.98,179.52
X$726 \$I9980 VGND VPWR VGND sky130_fd_sc_hd__decap_3
* cell instance $727 r180 *1 189.98,152.32
X$727 \$I10008 VGND VPWR VGND sky130_fd_sc_hd__decap_3
* cell instance $728 r180 *1 189.98,163.2
X$728 \$I10002 VGND VPWR VGND sky130_fd_sc_hd__decap_3
* cell instance $729 r180 *1 189.98,244.8
X$729 \$I9998 VGND VPWR VGND sky130_fd_sc_hd__decap_3
* cell instance $730 r180 *1 189.98,174.08
X$730 \$I9979 VGND VPWR VGND sky130_fd_sc_hd__decap_3
* cell instance $731 r180 *1 189.98,108.8
X$731 \$I10026 VGND VPWR VGND sky130_fd_sc_hd__decap_3
* cell instance $732 r180 *1 189.98,157.76
X$732 \$I10009 VGND VPWR VGND sky130_fd_sc_hd__decap_3
* cell instance $733 r180 *1 189.98,168.64
X$733 \$I9981 VGND VPWR VGND sky130_fd_sc_hd__decap_3
* cell instance $734 r180 *1 189.98,54.4
X$734 \$I10001 VGND VPWR VGND sky130_fd_sc_hd__decap_3
* cell instance $735 r180 *1 189.98,233.92
X$735 \$I9983 VGND VPWR VGND sky130_fd_sc_hd__decap_3
* cell instance $736 r180 *1 189.98,146.88
X$736 \$I10010 VGND VPWR VGND sky130_fd_sc_hd__decap_3
* cell instance $737 r180 *1 189.98,92.48
X$737 \$I10016 VGND VPWR VGND sky130_fd_sc_hd__decap_3
* cell instance $738 r180 *1 189.98,125.12
X$738 \$I9989 VGND VPWR VGND sky130_fd_sc_hd__decap_3
* cell instance $739 r180 *1 189.98,266.56
X$739 \$I10013 VGND VPWR VGND sky130_fd_sc_hd__decap_3
* cell instance $740 r180 *1 189.98,32.64
X$740 \$I10025 VGND VPWR VGND sky130_fd_sc_hd__decap_3
* cell instance $741 r180 *1 189.98,114.24
X$741 \$I9987 VGND VPWR VGND sky130_fd_sc_hd__decap_3
* cell instance $742 r180 *1 189.98,43.52
X$742 VPWR VGND VPWR VGND sky130_fd_sc_hd__decap_3
* cell instance $743 r180 *1 189.98,48.96
X$743 \$I10003 VGND VPWR VGND sky130_fd_sc_hd__decap_3
* cell instance $744 r180 *1 189.98,70.72
X$744 \$I9986 VGND VPWR VGND sky130_fd_sc_hd__decap_3
* cell instance $745 r180 *1 189.98,59.84
X$745 \$I9985 VGND VPWR VGND sky130_fd_sc_hd__decap_3
* cell instance $746 r180 *1 189.98,38.08
X$746 VPWR VGND VPWR VGND sky130_fd_sc_hd__decap_3
* cell instance $747 r180 *1 189.98,76.16
X$747 \$I9988 VGND VPWR VGND sky130_fd_sc_hd__decap_3
* cell instance $748 r180 *1 189.98,212.16
X$748 \$I9991 VGND VPWR VGND sky130_fd_sc_hd__decap_3
* cell instance $749 r0 *1 10.12,277.44
X$749 \$I9965 VGND VPWR VGND sky130_fd_sc_hd__decap_3
* cell instance $750 r0 *1 10.12,146.88
X$750 \$I9953 VGND VPWR VGND sky130_fd_sc_hd__decap_3
* cell instance $751 r0 *1 10.12,130.56
X$751 \$I9955 VGND VPWR VGND sky130_fd_sc_hd__decap_3
* cell instance $752 r0 *1 10.12,43.52
X$752 \$I9934 VGND VPWR VGND sky130_fd_sc_hd__decap_3
* cell instance $753 r0 *1 10.12,223.04
X$753 \$I9975 VGND VPWR VGND sky130_fd_sc_hd__decap_3
* cell instance $754 r0 *1 10.12,70.72
X$754 \$I9958 VGND VPWR VGND sky130_fd_sc_hd__decap_3
* cell instance $755 r0 *1 10.12,108.8
X$755 \$I9938 VGND VPWR VGND sky130_fd_sc_hd__decap_3
* cell instance $756 r0 *1 10.12,141.44
X$756 \$I9957 VGND VPWR VGND sky130_fd_sc_hd__decap_3
* cell instance $757 r0 *1 10.12,250.24
X$757 \$I9966 VGND VPWR VGND sky130_fd_sc_hd__decap_3
* cell instance $758 r0 *1 10.12,190.4
X$758 \$I9946 VGND VPWR VGND sky130_fd_sc_hd__decap_3
* cell instance $759 r0 *1 10.12,87.04
X$759 \$I9943 VGND VPWR VGND sky130_fd_sc_hd__decap_3
* cell instance $760 r0 *1 10.12,233.92
X$760 \$I9976 VGND VPWR VGND sky130_fd_sc_hd__decap_3
* cell instance $761 r0 *1 10.12,163.2
X$761 \$I9928 VGND VPWR VGND sky130_fd_sc_hd__decap_3
* cell instance $762 r0 *1 10.12,179.52
X$762 \$I9949 VGND VPWR VGND sky130_fd_sc_hd__decap_3
* cell instance $763 r0 *1 10.12,174.08
X$763 \$I9947 VGND VPWR VGND sky130_fd_sc_hd__decap_3
* cell instance $764 r0 *1 10.12,217.6
X$764 \$I9932 VGND VPWR VGND sky130_fd_sc_hd__decap_3
* cell instance $765 r0 *1 10.12,168.64
X$765 \$I9948 VGND VPWR VGND sky130_fd_sc_hd__decap_3
* cell instance $766 r0 *1 10.12,239.36
X$766 \$I9974 VGND VPWR VGND sky130_fd_sc_hd__decap_3
* cell instance $767 r0 *1 10.12,103.36
X$767 \$I9937 VGND VPWR VGND sky130_fd_sc_hd__decap_3
* cell instance $768 r0 *1 10.12,32.64
X$768 \$I9930 VGND VPWR VGND sky130_fd_sc_hd__decap_3
* cell instance $769 r0 *1 10.12,114.24
X$769 \$I9927 VGND VPWR VGND sky130_fd_sc_hd__decap_3
* cell instance $770 r0 *1 10.12,184.96
X$770 \$I9945 VGND VPWR VGND sky130_fd_sc_hd__decap_3
* cell instance $771 r0 *1 10.12,255.68
X$771 \$I9968 VGND VPWR VGND sky130_fd_sc_hd__decap_3
* cell instance $772 r0 *1 10.12,97.92
X$772 \$I9936 VGND VPWR VGND sky130_fd_sc_hd__decap_3
* cell instance $773 r0 *1 10.12,201.28
X$773 \$I9931 VGND VPWR VGND sky130_fd_sc_hd__decap_3
* cell instance $774 r0 *1 10.12,228.48
X$774 \$I9969 VGND VPWR VGND sky130_fd_sc_hd__decap_3
* cell instance $775 r0 *1 10.12,92.48
X$775 \$I9940 VGND VPWR VGND sky130_fd_sc_hd__decap_3
* cell instance $776 r0 *1 10.12,261.12
X$776 \$I9967 VGND VPWR VGND sky130_fd_sc_hd__decap_3
* cell instance $777 r0 *1 10.12,81.6
X$777 \$I9942 VGND VPWR VGND sky130_fd_sc_hd__decap_3
* cell instance $778 r0 *1 10.12,266.56
X$778 \$I9962 VGND VPWR VGND sky130_fd_sc_hd__decap_3
* cell instance $779 r0 *1 10.12,59.84
X$779 \$I9960 VGND VPWR VGND sky130_fd_sc_hd__decap_3
* cell instance $780 r0 *1 10.12,136
X$780 \$I9951 VGND VPWR VGND sky130_fd_sc_hd__decap_3
* cell instance $781 r0 *1 10.12,157.76
X$781 \$I9939 VGND VPWR VGND sky130_fd_sc_hd__decap_3
* cell instance $782 r0 *1 10.12,152.32
X$782 \$I9952 VGND VPWR VGND sky130_fd_sc_hd__decap_3
* cell instance $783 r0 *1 10.12,27.2
X$783 \$I9959 VGND VPWR VGND sky130_fd_sc_hd__decap_3
* cell instance $784 r0 *1 10.12,48.96
X$784 \$I9973 VGND VPWR VGND sky130_fd_sc_hd__decap_3
* cell instance $785 r0 *1 10.12,195.84
X$785 \$I9950 VGND VPWR VGND sky130_fd_sc_hd__decap_3
* cell instance $786 r0 *1 10.12,76.16
X$786 \$I9941 VGND VPWR VGND sky130_fd_sc_hd__decap_3
* cell instance $787 r0 *1 10.12,206.72
X$787 \$I9972 VGND VPWR VGND sky130_fd_sc_hd__decap_3
* cell instance $788 r0 *1 10.12,272
X$788 \$I9961 VGND VPWR VGND sky130_fd_sc_hd__decap_3
* cell instance $789 r0 *1 10.12,10.88
X$789 \$I9835 VGND VPWR VGND sky130_fd_sc_hd__decap_3
* cell instance $790 m0 *1 10.12,16.32
X$790 \$I9835 VGND VPWR VGND sky130_fd_sc_hd__decap_3
* cell instance $791 r0 *1 10.12,38.08
X$791 \$I9929 VGND VPWR VGND sky130_fd_sc_hd__decap_3
* cell instance $792 r0 *1 10.12,119.68
X$792 \$I9954 VGND VPWR VGND sky130_fd_sc_hd__decap_3
* cell instance $793 r0 *1 10.12,54.4
X$793 \$I9935 VGND VPWR VGND sky130_fd_sc_hd__decap_3
* cell instance $794 r0 *1 10.12,212.16
X$794 \$I9971 VGND VPWR VGND sky130_fd_sc_hd__decap_3
* cell instance $795 r0 *1 10.12,282.88
X$795 \$I9970 VGND VPWR VGND sky130_fd_sc_hd__decap_3
* cell instance $796 r0 *1 10.12,125.12
X$796 \$I9956 VGND VPWR VGND sky130_fd_sc_hd__decap_3
* cell instance $797 r0 *1 10.12,16.32
X$797 \$I9964 VGND VPWR VGND sky130_fd_sc_hd__decap_3
* cell instance $798 r0 *1 10.12,65.28
X$798 \$I9933 VGND VPWR VGND sky130_fd_sc_hd__decap_3
* cell instance $799 r0 *1 10.12,244.8
X$799 \$I9963 VGND VPWR VGND sky130_fd_sc_hd__decap_3
* cell instance $800 r0 *1 10.12,21.76
X$800 \$I9944 VGND VPWR VGND sky130_fd_sc_hd__decap_3
* cell instance $1724 m90 *1 121.44,65.28
X$1724 VPWR VGND VPWR \$1243 \$1205 \$1227 \$1220 VGND sky130_fd_sc_hd__o21a_2
* cell instance $1725 m90 *1 164.68,16.32
X$1725 VPWR VGND VPWR \$209 \$31 \$17 \$56 VGND sky130_fd_sc_hd__o21a_2
* cell instance $1726 r0 *1 164.68,16.32
X$1726 VGND \$180 \$147 \$148 \$49 \$150 \$151 VPWR VPWR VGND
+ sky130_fd_sc_hd__o221a_2
* cell instance $1727 r0 *1 168.82,16.32
X$1727 VGND \$98 \$143 \$94 VPWR VPWR VGND sky130_fd_sc_hd__xor2_2
* cell instance $1728 r0 *1 174.8,16.32
X$1728 VPWR \$131 VPWR VGND \$157 \$49 \$30 VGND sky130_fd_sc_hd__or3_2
* cell instance $1729 r180 *1 172.04,21.76
X$1729 VGND \$139 \$79 \$27 VPWR VPWR VGND sky130_fd_sc_hd__xnor2_2
* cell instance $1730 m90 *1 175.26,141.44
X$1730 \$I13963 VGND VPWR \$2237 \$2168 \$2100 \$1363 VGND
+ sky130_fd_sc_hd__o21a_2
* cell instance $1731 m90 *1 115.92,228.48
X$1731 VPWR VGND VPWR \$3716 \$3663 \$3661 \$3713 VGND sky130_fd_sc_hd__o21a_2
* cell instance $1732 m90 *1 118.22,65.28
X$1732 VPWR VGND VPWR \$1255 \$1213 \$1223 \$1221 VGND sky130_fd_sc_hd__o21a_2
* cell instance $1733 m90 *1 115.92,223.04
X$1733 VPWR VGND VPWR \$3621 \$3563 \$3530 \$3474 VGND sky130_fd_sc_hd__o21a_2
* cell instance $1734 m90 *1 113.16,201.28
X$1734 VPWR VGND VPWR \$3159 \$3154 \$3156 \$3151 VGND sky130_fd_sc_hd__o21a_2
* cell instance $1735 m90 *1 120.06,103.36
X$1735 VPWR VGND VPWR \$1769 \$1774 \$1743 \$1781 VGND sky130_fd_sc_hd__o21a_2
* cell instance $1736 m90 *1 187.22,195.84
X$1736 VPWR VGND VPWR \$2948 \$3195 \$3085 \$3103 VGND sky130_fd_sc_hd__o21a_2
* cell instance $1737 m90 *1 115.92,239.36
X$1737 VPWR VGND VPWR \$3877 \$3830 \$3805 \$3756 VGND sky130_fd_sc_hd__o21a_2
* cell instance $1738 m0 *1 105.34,288.32
X$1738 VPWR VGND VPWR \$4290 \$4346 \$4352 \$4318 VGND sky130_fd_sc_hd__o21a_2
* cell instance $1739 m0 *1 115,48.96
X$1739 VPWR VGND VPWR \$966 \$967 \$895 \$878 VGND sky130_fd_sc_hd__o21a_2
* cell instance $1740 m0 *1 73.6,43.52
X$1740 VPWR VGND VPWR \$734 \$1021 \$781 \$831 VGND sky130_fd_sc_hd__o21a_2
* cell instance $1741 m0 *1 119.14,119.68
X$1741 VPWR VGND VPWR \$2002 \$2004 \$1958 \$1879 VGND sky130_fd_sc_hd__o21a_2
* cell instance $1742 m0 *1 119.14,190.4
X$1742 VPWR VGND VPWR \$2983 \$2906 \$2899 \$2868 VGND sky130_fd_sc_hd__o21a_2
* cell instance $1743 m0 *1 117.3,272
X$1743 VPWR VGND VPWR \$4173 \$4148 \$4172 \$4168 VGND sky130_fd_sc_hd__o21a_2
* cell instance $1744 r180 *1 127.88,250.24
X$1744 VPWR VGND VPWR \$3945 \$4019 \$3898 \$3892 VGND sky130_fd_sc_hd__o21a_2
* cell instance $1745 r180 *1 118.22,70.72
X$1745 VPWR VGND VPWR \$1303 \$1283 \$1261 \$1280 VGND sky130_fd_sc_hd__o21a_2
* cell instance $1746 r180 *1 113.16,212.16
X$1746 VPWR VGND VPWR \$3366 \$3365 \$3269 \$3362 VGND sky130_fd_sc_hd__o21a_2
* cell instance $1747 r180 *1 113.16,282.88
X$1747 VPWR VGND VPWR \$4245 \$4240 \$4238 \$4196 VGND sky130_fd_sc_hd__o21a_2
* cell instance $1748 r180 *1 185.38,21.76
X$1748 VPWR VGND VPWR \$311 \$61 \$97 \$31 VGND sky130_fd_sc_hd__o21a_2
* cell instance $1749 r0 *1 167.9,146.88
X$1749 VPWR VGND VPWR \$2331 \$2236 \$2238 \$2305 VGND sky130_fd_sc_hd__o21a_2
* cell instance $1750 m0 *1 171.12,152.32
X$1750 VGND \$2404 \$1413 \$1362 \$1363 VPWR VPWR VGND sky130_fd_sc_hd__nor3b_2
* cell instance $1751 r0 *1 108.1,255.68
X$1751 VPWR VGND VPWR \$4032 \$4119 \$4124 \$4089 VGND sky130_fd_sc_hd__o21a_2
* cell instance $1752 r0 *1 109.48,92.48
X$1752 VPWR VGND VPWR \$1556 \$1501 \$1517 \$1555 VGND sky130_fd_sc_hd__o21a_2
* cell instance $1753 r0 *1 111.78,97.92
X$1753 VPWR VGND VPWR \$1709 \$1629 \$1582 \$1618 VGND sky130_fd_sc_hd__o21a_2
* cell instance $1754 r0 *1 120.52,130.56
X$1754 VPWR VGND VPWR \$2125 \$2127 \$2076 \$2052 VGND sky130_fd_sc_hd__o21a_2
* cell instance $1755 r0 *1 110.86,136
X$1755 VPWR VGND VPWR \$2141 \$2202 \$2072 \$2020 VGND sky130_fd_sc_hd__o21a_2
* cell instance $1756 r0 *1 71.3,43.52
X$1756 VPWR VGND VPWR \$919 \$781 \$593 \$837 VGND sky130_fd_sc_hd__o21a_2
* cell instance $1757 r0 *1 111.78,146.88
X$1757 VPWR VGND VPWR \$2296 \$2271 \$2294 \$2229 VGND sky130_fd_sc_hd__o21a_2
* cell instance $1758 m90 *1 164.22,244.8
X$1758 VPWR VGND VPWR \$3490 \$3905 VGND sky130_fd_sc_hd__inv_2
* cell instance $1759 m90 *1 172.5,157.76
X$1759 \$I1151 VGND VPWR \$2305 \$1413 VGND sky130_fd_sc_hd__inv_2
* cell instance $1760 m90 *1 80.5,92.48
X$1760 VPWR VGND VPWR \$1539 \$1513 VGND sky130_fd_sc_hd__inv_2
* cell instance $1761 m90 *1 109.02,233.92
X$1761 VPWR VGND VPWR \$3755 \$3713 VGND sky130_fd_sc_hd__inv_2
* cell instance $1762 m0 *1 165.6,174.08
X$1762 VPWR VGND VPWR \$2670 \$2705 VGND sky130_fd_sc_hd__inv_2
* cell instance $1763 m0 *1 174.34,277.44
X$1763 VPWR VGND VPWR \$4211 \$2270 VGND sky130_fd_sc_hd__inv_2
* cell instance $1764 m0 *1 154.1,179.52
X$1764 VPWR VGND VPWR \$2656 \$1527 VGND sky130_fd_sc_hd__inv_2
* cell instance $1765 m0 *1 33.58,108.8
X$1765 VPWR VGND VPWR \$1839 \$1754 VGND sky130_fd_sc_hd__inv_2
* cell instance $1766 m0 *1 84.64,146.88
X$1766 VPWR VGND VPWR \$2270 \$2266 VGND sky130_fd_sc_hd__inv_2
* cell instance $1767 r180 *1 115,76.16
X$1767 VPWR VGND VPWR \$1274 \$1221 VGND sky130_fd_sc_hd__inv_2
* cell instance $1768 r180 *1 176.18,146.88
X$1768 \$I13963 VGND VPWR \$2236 \$1527 VGND sky130_fd_sc_hd__inv_2
* cell instance $1769 r180 *1 115.92,282.88
X$1769 VPWR VGND VPWR \$4187 \$4168 VGND sky130_fd_sc_hd__inv_2
* cell instance $1770 r180 *1 163.3,250.24
X$1770 VPWR VGND VPWR \$3941 success VGND sky130_fd_sc_hd__inv_2
* cell instance $1771 r180 *1 89.24,103.36
X$1771 VPWR VGND VPWR \$1773 \$1652 VGND sky130_fd_sc_hd__inv_2
* cell instance $1772 r180 *1 115,70.72
X$1772 VPWR VGND VPWR \$1201 \$1220 VGND sky130_fd_sc_hd__inv_2
* cell instance $1773 r180 *1 109.94,212.16
X$1773 VPWR VGND VPWR \$3227 \$3151 VGND sky130_fd_sc_hd__inv_2
* cell instance $1774 r180 *1 115,130.56
X$1774 VPWR VGND VPWR \$2018 \$2020 VGND sky130_fd_sc_hd__inv_2
* cell instance $1775 r180 *1 80.04,97.92
X$1775 VPWR VGND VPWR \$1614 \$1558 VGND sky130_fd_sc_hd__inv_2
* cell instance $1776 r180 *1 115,103.36
X$1776 VPWR VGND VPWR \$1500 \$1555 VGND sky130_fd_sc_hd__inv_2
* cell instance $1777 r180 *1 110.4,217.6
X$1777 VPWR VGND VPWR \$3437 \$3362 VGND sky130_fd_sc_hd__inv_2
* cell instance $1778 r0 *1 168.82,239.36
X$1778 VPWR VGND VPWR \$3864 \$1527 VGND sky130_fd_sc_hd__inv_2
* cell instance $1779 r0 *1 176.18,32.64
X$1779 VPWR VGND VPWR \$569 \$97 VGND sky130_fd_sc_hd__inv_2
* cell instance $1780 r0 *1 75.44,43.52
X$1780 VPWR VGND VPWR \$888 \$836 VGND sky130_fd_sc_hd__inv_2
* cell instance $1781 r0 *1 75.9,103.36
X$1781 VPWR VGND VPWR \$1700 select VGND sky130_fd_sc_hd__inv_2
* cell instance $1782 m0 *1 183.54,195.84
X$1782 VPWR VGND VPWR \$3102 \$2581 \$3089 \$2922 \$2673 VGND
+ sky130_fd_sc_hd__o22a_2
* cell instance $1783 r0 *1 171.12,97.92
X$1783 \$I1121 VGND VPWR \$1681 \$1592 \$1468 \$1663 \$1527 VGND
+ sky130_fd_sc_hd__o22a_2
* cell instance $1784 r0 *1 172.04,108.8
X$1784 VPWR VGND VPWR \$1822 \$1902 \$1910 \$1362 \$1363 VGND
+ sky130_fd_sc_hd__o22a_2
* cell instance $1785 r180 *1 181.7,92.48
X$1785 VGND \$1422 \$1475 \$1473 \$1428 \$1483 \$1469 VPWR VPWR VGND
+ sky130_fd_sc_hd__a311o_2
* cell instance $1786 m90 *1 108.56,277.44
X$1786 VPWR VPWR \$4189 \$4187 \$2448 VGND VGND sky130_fd_sc_hd__and2_2
* cell instance $1787 m90 *1 109.48,206.72
X$1787 VPWR VPWR \$3162 \$3227 \$3321 VGND VGND sky130_fd_sc_hd__and2_2
* cell instance $1788 m90 *1 111.78,97.92
X$1788 VPWR VPWR \$1503 \$1500 \$316 VGND VGND sky130_fd_sc_hd__and2_2
* cell instance $1789 m90 *1 71.3,43.52
X$1789 VPWR VPWR \$609 \$782 \$880 VGND VGND sky130_fd_sc_hd__and2_2
* cell instance $1790 m90 *1 115,81.6
X$1790 VPWR VPWR \$1272 \$1274 \$442 VGND VGND sky130_fd_sc_hd__and2_2
* cell instance $1791 m0 *1 165.14,27.2
X$1791 VPWR VPWR \$340 \$347 \$348 VGND VGND sky130_fd_sc_hd__and2_2
* cell instance $1792 m0 *1 158.7,21.76
X$1792 VPWR VPWR \$126 \$29 \$100 VGND VGND sky130_fd_sc_hd__and2_2
* cell instance $1793 m0 *1 171.12,272
X$1793 \$I13626 VPWR \$1539 \$692 \$4203 VGND VGND sky130_fd_sc_hd__and2_2
* cell instance $1794 m0 *1 166.98,87.04
X$1794 \$I12007 VPWR \$1413 \$1363 \$1428 VGND VGND sky130_fd_sc_hd__and2_2
* cell instance $1795 m0 *1 165.6,87.04
X$1795 \$I12007 VPWR VGND sky130_fd_sc_hd__conb_1
* cell instance $1796 r180 *1 174.8,261.12
X$1796 \$I14138 VPWR \$3846 \$3850 \$3058 VGND VGND sky130_fd_sc_hd__and2_2
* cell instance $1797 r180 *1 113.16,65.28
X$1797 VPWR VPWR \$1140 \$1201 \$381 VGND VGND sky130_fd_sc_hd__and2_2
* cell instance $1798 r180 *1 113.16,217.6
X$1798 VPWR VPWR \$3368 \$3437 \$2519 VGND VGND sky130_fd_sc_hd__and2_2
* cell instance $1799 r180 *1 113.16,239.36
X$1799 VPWR VPWR \$3717 \$3755 \$2419 VGND VGND sky130_fd_sc_hd__and2_2
* cell instance $1800 r180 *1 113.16,130.56
X$1800 VPWR VPWR \$2021 \$2018 \$374 VGND VGND sky130_fd_sc_hd__and2_2
* cell instance $1801 r0 *1 168.36,97.92
X$1801 \$I1121 VPWR \$1663 \$1592 \$1660 VGND VGND sky130_fd_sc_hd__and2_2
* cell instance $1802 r0 *1 165.6,87.04
X$1802 VPWR VPWR \$1363 \$1466 \$1418 VGND VGND sky130_fd_sc_hd__and2_2
* cell instance $1803 m0 *1 138.92,136
X$1803 VPWR VGND sky130_fd_sc_hd__tapvpwrvgnd_1
* cell instance $1804 m0 *1 35.88,195.84
X$1804 VPWR VGND sky130_fd_sc_hd__tapvpwrvgnd_1
* cell instance $1805 m0 *1 138.92,179.52
X$1805 VPWR VGND sky130_fd_sc_hd__tapvpwrvgnd_1
* cell instance $1806 m0 *1 35.88,190.4
X$1806 VPWR VGND sky130_fd_sc_hd__tapvpwrvgnd_1
* cell instance $1807 m0 *1 87.4,54.4
X$1807 VPWR VGND sky130_fd_sc_hd__tapvpwrvgnd_1
* cell instance $1808 m0 *1 138.92,108.8
X$1808 VPWR VGND sky130_fd_sc_hd__tapvpwrvgnd_1
* cell instance $1809 m0 *1 164.68,168.64
X$1809 VPWR VGND sky130_fd_sc_hd__tapvpwrvgnd_1
* cell instance $1810 m0 *1 138.92,87.04
X$1810 VPWR VGND sky130_fd_sc_hd__tapvpwrvgnd_1
* cell instance $1811 m0 *1 138.92,195.84
X$1811 VPWR VGND sky130_fd_sc_hd__tapvpwrvgnd_1
* cell instance $1812 m0 *1 138.92,92.48
X$1812 VPWR VGND sky130_fd_sc_hd__tapvpwrvgnd_1
* cell instance $1813 m0 *1 164.68,206.72
X$1813 VPWR VGND sky130_fd_sc_hd__tapvpwrvgnd_1
* cell instance $1814 m0 *1 138.92,97.92
X$1814 VPWR VGND sky130_fd_sc_hd__tapvpwrvgnd_1
* cell instance $1815 m0 *1 35.88,16.32
X$1815 VPWR VGND sky130_fd_sc_hd__tapvpwrvgnd_1
* cell instance $1816 m0 *1 113.16,261.12
X$1816 VPWR VGND sky130_fd_sc_hd__tapvpwrvgnd_1
* cell instance $1817 m0 *1 35.88,184.96
X$1817 VPWR VGND sky130_fd_sc_hd__tapvpwrvgnd_1
* cell instance $1818 m0 *1 87.4,65.28
X$1818 VPWR VGND sky130_fd_sc_hd__tapvpwrvgnd_1
* cell instance $1819 m0 *1 87.4,70.72
X$1819 VPWR VGND sky130_fd_sc_hd__tapvpwrvgnd_1
* cell instance $1820 m0 *1 87.4,233.92
X$1820 VPWR VGND sky130_fd_sc_hd__tapvpwrvgnd_1
* cell instance $1821 m0 *1 164.68,108.8
X$1821 VPWR VGND sky130_fd_sc_hd__tapvpwrvgnd_1
* cell instance $1822 m0 *1 138.92,163.2
X$1822 VPWR VGND sky130_fd_sc_hd__tapvpwrvgnd_1
* cell instance $1823 m0 *1 164.68,48.96
X$1823 VPWR VGND sky130_fd_sc_hd__tapvpwrvgnd_1
* cell instance $1824 m0 *1 164.68,288.32
X$1824 VPWR VGND sky130_fd_sc_hd__tapvpwrvgnd_1
* cell instance $1825 m0 *1 113.16,146.88
X$1825 VPWR VGND sky130_fd_sc_hd__tapvpwrvgnd_1
* cell instance $1826 m0 *1 164.68,119.68
X$1826 VPWR VGND sky130_fd_sc_hd__tapvpwrvgnd_1
* cell instance $1827 m0 *1 164.68,277.44
X$1827 VPWR VGND sky130_fd_sc_hd__tapvpwrvgnd_1
* cell instance $1828 m0 *1 138.92,114.24
X$1828 VPWR VGND sky130_fd_sc_hd__tapvpwrvgnd_1
* cell instance $1829 m0 *1 164.68,130.56
X$1829 VPWR VGND sky130_fd_sc_hd__tapvpwrvgnd_1
* cell instance $1830 m0 *1 87.4,217.6
X$1830 VPWR VGND sky130_fd_sc_hd__tapvpwrvgnd_1
* cell instance $1831 m0 *1 138.92,174.08
X$1831 VPWR VGND sky130_fd_sc_hd__tapvpwrvgnd_1
* cell instance $1832 m0 *1 138.92,168.64
X$1832 VPWR VGND sky130_fd_sc_hd__tapvpwrvgnd_1
* cell instance $1833 m0 *1 164.68,76.16
X$1833 VPWR VGND sky130_fd_sc_hd__tapvpwrvgnd_1
* cell instance $1834 m0 *1 61.64,103.36
X$1834 VPWR VGND sky130_fd_sc_hd__tapvpwrvgnd_1
* cell instance $1835 m0 *1 113.16,87.04
X$1835 VPWR VGND sky130_fd_sc_hd__tapvpwrvgnd_1
* cell instance $1836 m0 *1 61.64,217.6
X$1836 VPWR VGND sky130_fd_sc_hd__tapvpwrvgnd_1
* cell instance $1837 m0 *1 87.4,38.08
X$1837 VPWR VGND sky130_fd_sc_hd__tapvpwrvgnd_1
* cell instance $1838 m0 *1 113.16,97.92
X$1838 VPWR VGND sky130_fd_sc_hd__tapvpwrvgnd_1
* cell instance $1839 m0 *1 61.64,212.16
X$1839 VPWR VGND sky130_fd_sc_hd__tapvpwrvgnd_1
* cell instance $1840 m0 *1 61.64,206.72
X$1840 VPWR VGND sky130_fd_sc_hd__tapvpwrvgnd_1
* cell instance $1841 m0 *1 113.16,76.16
X$1841 VPWR VGND sky130_fd_sc_hd__tapvpwrvgnd_1
* cell instance $1842 m0 *1 164.68,87.04
X$1842 VPWR VGND sky130_fd_sc_hd__tapvpwrvgnd_1
* cell instance $1843 m0 *1 35.88,43.52
X$1843 VPWR VGND sky130_fd_sc_hd__tapvpwrvgnd_1
* cell instance $1844 m0 *1 164.68,282.88
X$1844 VPWR VGND sky130_fd_sc_hd__tapvpwrvgnd_1
* cell instance $1845 m0 *1 138.92,201.28
X$1845 VPWR VGND sky130_fd_sc_hd__tapvpwrvgnd_1
* cell instance $1846 m0 *1 113.16,266.56
X$1846 VPWR VGND sky130_fd_sc_hd__tapvpwrvgnd_1
* cell instance $1847 m0 *1 126.04,288.32
X$1847 VPWR VGND sky130_fd_sc_hd__tapvpwrvgnd_1
* cell instance $1848 m0 *1 151.8,288.32
X$1848 VPWR VGND sky130_fd_sc_hd__tapvpwrvgnd_1
* cell instance $1849 m0 *1 138.92,76.16
X$1849 VPWR VGND sky130_fd_sc_hd__tapvpwrvgnd_1
* cell instance $1850 m0 *1 164.68,174.08
X$1850 VPWR VGND sky130_fd_sc_hd__tapvpwrvgnd_1
* cell instance $1851 m0 *1 61.64,250.24
X$1851 VPWR VGND sky130_fd_sc_hd__tapvpwrvgnd_1
* cell instance $1852 m0 *1 113.16,206.72
X$1852 VPWR VGND sky130_fd_sc_hd__tapvpwrvgnd_1
* cell instance $1853 m0 *1 113.16,108.8
X$1853 VPWR VGND sky130_fd_sc_hd__tapvpwrvgnd_1
* cell instance $1854 m0 *1 61.64,272
X$1854 VPWR VGND sky130_fd_sc_hd__tapvpwrvgnd_1
* cell instance $1855 m0 *1 113.16,59.84
X$1855 VPWR VGND sky130_fd_sc_hd__tapvpwrvgnd_1
* cell instance $1856 m0 *1 113.16,255.68
X$1856 VPWR VGND sky130_fd_sc_hd__tapvpwrvgnd_1
* cell instance $1857 m0 *1 61.64,277.44
X$1857 VPWR VGND sky130_fd_sc_hd__tapvpwrvgnd_1
* cell instance $1858 m0 *1 113.16,250.24
X$1858 VPWR VGND sky130_fd_sc_hd__tapvpwrvgnd_1
* cell instance $1859 m0 *1 138.92,184.96
X$1859 VPWR VGND sky130_fd_sc_hd__tapvpwrvgnd_1
* cell instance $1860 m0 *1 35.88,21.76
X$1860 VPWR VGND sky130_fd_sc_hd__tapvpwrvgnd_1
* cell instance $1861 m0 *1 35.88,27.2
X$1861 VPWR VGND sky130_fd_sc_hd__tapvpwrvgnd_1
* cell instance $1862 m0 *1 87.4,244.8
X$1862 VPWR VGND sky130_fd_sc_hd__tapvpwrvgnd_1
* cell instance $1863 m0 *1 35.88,70.72
X$1863 VPWR VGND sky130_fd_sc_hd__tapvpwrvgnd_1
* cell instance $1864 m0 *1 35.88,168.64
X$1864 VPWR VGND sky130_fd_sc_hd__tapvpwrvgnd_1
* cell instance $1865 m0 *1 35.88,54.4
X$1865 VPWR VGND sky130_fd_sc_hd__tapvpwrvgnd_1
* cell instance $1866 m0 *1 35.88,65.28
X$1866 VPWR VGND sky130_fd_sc_hd__tapvpwrvgnd_1
* cell instance $1867 m0 *1 35.88,179.52
X$1867 VPWR VGND sky130_fd_sc_hd__tapvpwrvgnd_1
* cell instance $1868 m0 *1 164.68,272
X$1868 VPWR VGND sky130_fd_sc_hd__tapvpwrvgnd_1
* cell instance $1869 m0 *1 164.68,179.52
X$1869 VPWR VGND sky130_fd_sc_hd__tapvpwrvgnd_1
* cell instance $1870 m0 *1 138.92,190.4
X$1870 VPWR VGND sky130_fd_sc_hd__tapvpwrvgnd_1
* cell instance $1871 m0 *1 35.88,59.84
X$1871 VPWR VGND sky130_fd_sc_hd__tapvpwrvgnd_1
* cell instance $1872 m0 *1 100.28,288.32
X$1872 VPWR VGND sky130_fd_sc_hd__tapvpwrvgnd_1
* cell instance $1873 m0 *1 164.68,217.6
X$1873 VPWR VGND sky130_fd_sc_hd__tapvpwrvgnd_1
* cell instance $1874 m0 *1 87.4,92.48
X$1874 VPWR VGND sky130_fd_sc_hd__tapvpwrvgnd_1
* cell instance $1875 m0 *1 87.4,87.04
X$1875 VPWR VGND sky130_fd_sc_hd__tapvpwrvgnd_1
* cell instance $1876 m0 *1 61.64,244.8
X$1876 VPWR VGND sky130_fd_sc_hd__tapvpwrvgnd_1
* cell instance $1877 m0 *1 61.64,228.48
X$1877 VPWR VGND sky130_fd_sc_hd__tapvpwrvgnd_1
* cell instance $1878 m0 *1 61.64,239.36
X$1878 VPWR VGND sky130_fd_sc_hd__tapvpwrvgnd_1
* cell instance $1879 m0 *1 61.64,223.04
X$1879 VPWR VGND sky130_fd_sc_hd__tapvpwrvgnd_1
* cell instance $1880 m0 *1 61.64,233.92
X$1880 VPWR VGND sky130_fd_sc_hd__tapvpwrvgnd_1
* cell instance $1881 m0 *1 35.88,38.08
X$1881 VPWR VGND sky130_fd_sc_hd__tapvpwrvgnd_1
* cell instance $1882 m0 *1 113.16,136
X$1882 VPWR VGND sky130_fd_sc_hd__tapvpwrvgnd_1
* cell instance $1883 m0 *1 35.88,48.96
X$1883 VPWR VGND sky130_fd_sc_hd__tapvpwrvgnd_1
* cell instance $1884 m0 *1 35.88,250.24
X$1884 VPWR VGND sky130_fd_sc_hd__tapvpwrvgnd_1
* cell instance $1885 m0 *1 61.64,125.12
X$1885 VPWR VGND sky130_fd_sc_hd__tapvpwrvgnd_1
* cell instance $1886 m0 *1 164.68,97.92
X$1886 VPWR VGND sky130_fd_sc_hd__tapvpwrvgnd_1
* cell instance $1887 m0 *1 177.56,288.32
X$1887 VPWR VGND sky130_fd_sc_hd__tapvpwrvgnd_1
* cell instance $1888 m0 *1 61.64,130.56
X$1888 VPWR VGND sky130_fd_sc_hd__tapvpwrvgnd_1
* cell instance $1889 m0 *1 61.64,136
X$1889 VPWR VGND sky130_fd_sc_hd__tapvpwrvgnd_1
* cell instance $1890 m0 *1 35.88,261.12
X$1890 VPWR VGND sky130_fd_sc_hd__tapvpwrvgnd_1
* cell instance $1891 m0 *1 138.92,272
X$1891 VPWR VGND sky130_fd_sc_hd__tapvpwrvgnd_1
* cell instance $1892 m0 *1 138.92,239.36
X$1892 VPWR VGND sky130_fd_sc_hd__tapvpwrvgnd_1
* cell instance $1893 m0 *1 138.92,223.04
X$1893 VPWR VGND sky130_fd_sc_hd__tapvpwrvgnd_1
* cell instance $1894 m0 *1 138.92,277.44
X$1894 VPWR VGND sky130_fd_sc_hd__tapvpwrvgnd_1
* cell instance $1895 m0 *1 35.88,201.28
X$1895 VPWR VGND sky130_fd_sc_hd__tapvpwrvgnd_1
* cell instance $1896 m0 *1 164.68,157.76
X$1896 VPWR VGND sky130_fd_sc_hd__tapvpwrvgnd_1
* cell instance $1897 m0 *1 138.92,282.88
X$1897 VPWR VGND sky130_fd_sc_hd__tapvpwrvgnd_1
* cell instance $1898 m0 *1 61.64,27.2
X$1898 VPWR VGND sky130_fd_sc_hd__tapvpwrvgnd_1
* cell instance $1899 m0 *1 61.64,21.76
X$1899 VPWR VGND sky130_fd_sc_hd__tapvpwrvgnd_1
* cell instance $1900 m0 *1 113.16,130.56
X$1900 VPWR VGND sky130_fd_sc_hd__tapvpwrvgnd_1
* cell instance $1901 m0 *1 138.92,81.6
X$1901 VPWR VGND sky130_fd_sc_hd__tapvpwrvgnd_1
* cell instance $1902 m0 *1 61.64,87.04
X$1902 VPWR VGND sky130_fd_sc_hd__tapvpwrvgnd_1
* cell instance $1903 m0 *1 138.92,212.16
X$1903 VPWR VGND sky130_fd_sc_hd__tapvpwrvgnd_1
* cell instance $1904 m0 *1 164.68,27.2
X$1904 VPWR VGND sky130_fd_sc_hd__tapvpwrvgnd_1
* cell instance $1905 m0 *1 113.16,119.68
X$1905 VPWR VGND sky130_fd_sc_hd__tapvpwrvgnd_1
* cell instance $1906 m0 *1 164.68,163.2
X$1906 VPWR VGND sky130_fd_sc_hd__tapvpwrvgnd_1
* cell instance $1907 m0 *1 164.68,146.88
X$1907 VPWR VGND sky130_fd_sc_hd__tapvpwrvgnd_1
* cell instance $1908 m0 *1 87.4,48.96
X$1908 VPWR VGND sky130_fd_sc_hd__tapvpwrvgnd_1
* cell instance $1909 m0 *1 138.92,250.24
X$1909 VPWR VGND sky130_fd_sc_hd__tapvpwrvgnd_1
* cell instance $1910 m0 *1 113.16,32.64
X$1910 VPWR VGND sky130_fd_sc_hd__tapvpwrvgnd_1
* cell instance $1911 m0 *1 164.68,38.08
X$1911 VPWR VGND sky130_fd_sc_hd__tapvpwrvgnd_1
* cell instance $1912 m0 *1 87.4,141.44
X$1912 VPWR VGND sky130_fd_sc_hd__tapvpwrvgnd_1
* cell instance $1913 m0 *1 164.68,136
X$1913 VPWR VGND sky130_fd_sc_hd__tapvpwrvgnd_1
* cell instance $1914 m0 *1 35.88,272
X$1914 VPWR VGND sky130_fd_sc_hd__tapvpwrvgnd_1
* cell instance $1915 m0 *1 87.4,43.52
X$1915 VPWR VGND sky130_fd_sc_hd__tapvpwrvgnd_1
* cell instance $1916 m0 *1 113.16,54.4
X$1916 VPWR VGND sky130_fd_sc_hd__tapvpwrvgnd_1
* cell instance $1917 m0 *1 164.68,16.32
X$1917 VPWR VGND sky130_fd_sc_hd__tapvpwrvgnd_1
* cell instance $1918 m0 *1 113.16,65.28
X$1918 VPWR VGND sky130_fd_sc_hd__tapvpwrvgnd_1
* cell instance $1919 m0 *1 35.88,266.56
X$1919 VPWR VGND sky130_fd_sc_hd__tapvpwrvgnd_1
* cell instance $1920 m0 *1 138.92,233.92
X$1920 VPWR VGND sky130_fd_sc_hd__tapvpwrvgnd_1
* cell instance $1921 m0 *1 113.16,223.04
X$1921 VPWR VGND sky130_fd_sc_hd__tapvpwrvgnd_1
* cell instance $1922 m0 *1 138.92,32.64
X$1922 VPWR VGND sky130_fd_sc_hd__tapvpwrvgnd_1
* cell instance $1923 m0 *1 35.88,288.32
X$1923 VPWR VGND sky130_fd_sc_hd__tapvpwrvgnd_1
* cell instance $1924 m0 *1 164.68,32.64
X$1924 VPWR VGND sky130_fd_sc_hd__tapvpwrvgnd_1
* cell instance $1925 m0 *1 138.92,266.56
X$1925 VPWR VGND sky130_fd_sc_hd__tapvpwrvgnd_1
* cell instance $1926 m0 *1 35.88,282.88
X$1926 VPWR VGND sky130_fd_sc_hd__tapvpwrvgnd_1
* cell instance $1927 m0 *1 138.92,255.68
X$1927 VPWR VGND sky130_fd_sc_hd__tapvpwrvgnd_1
* cell instance $1928 m0 *1 23,288.32
X$1928 VPWR VGND sky130_fd_sc_hd__tapvpwrvgnd_1
* cell instance $1929 m0 *1 138.92,261.12
X$1929 VPWR VGND sky130_fd_sc_hd__tapvpwrvgnd_1
* cell instance $1930 m0 *1 35.88,255.68
X$1930 VPWR VGND sky130_fd_sc_hd__tapvpwrvgnd_1
* cell instance $1931 m0 *1 48.76,288.32
X$1931 VPWR VGND sky130_fd_sc_hd__tapvpwrvgnd_1
* cell instance $1932 m0 *1 113.16,217.6
X$1932 VPWR VGND sky130_fd_sc_hd__tapvpwrvgnd_1
* cell instance $1933 m0 *1 87.4,212.16
X$1933 VPWR VGND sky130_fd_sc_hd__tapvpwrvgnd_1
* cell instance $1934 m0 *1 113.16,92.48
X$1934 VPWR VGND sky130_fd_sc_hd__tapvpwrvgnd_1
* cell instance $1935 m0 *1 35.88,233.92
X$1935 VPWR VGND sky130_fd_sc_hd__tapvpwrvgnd_1
* cell instance $1936 m0 *1 164.68,152.32
X$1936 VPWR VGND sky130_fd_sc_hd__tapvpwrvgnd_1
* cell instance $1937 m0 *1 87.4,228.48
X$1937 VPWR VGND sky130_fd_sc_hd__tapvpwrvgnd_1
* cell instance $1938 m0 *1 87.4,223.04
X$1938 VPWR VGND sky130_fd_sc_hd__tapvpwrvgnd_1
* cell instance $1939 m0 *1 35.88,239.36
X$1939 VPWR VGND sky130_fd_sc_hd__tapvpwrvgnd_1
* cell instance $1940 m0 *1 164.68,141.44
X$1940 VPWR VGND sky130_fd_sc_hd__tapvpwrvgnd_1
* cell instance $1941 m0 *1 164.68,21.76
X$1941 VPWR VGND sky130_fd_sc_hd__tapvpwrvgnd_1
* cell instance $1942 m0 *1 35.88,228.48
X$1942 VPWR VGND sky130_fd_sc_hd__tapvpwrvgnd_1
* cell instance $1943 m0 *1 35.88,277.44
X$1943 VPWR VGND sky130_fd_sc_hd__tapvpwrvgnd_1
* cell instance $1944 m0 *1 87.4,239.36
X$1944 VPWR VGND sky130_fd_sc_hd__tapvpwrvgnd_1
* cell instance $1945 m0 *1 164.68,201.28
X$1945 VPWR VGND sky130_fd_sc_hd__tapvpwrvgnd_1
* cell instance $1946 m0 *1 87.4,59.84
X$1946 VPWR VGND sky130_fd_sc_hd__tapvpwrvgnd_1
* cell instance $1947 m0 *1 164.68,195.84
X$1947 VPWR VGND sky130_fd_sc_hd__tapvpwrvgnd_1
* cell instance $1948 m0 *1 113.16,70.72
X$1948 VPWR VGND sky130_fd_sc_hd__tapvpwrvgnd_1
* cell instance $1949 m0 *1 87.4,16.32
X$1949 VPWR VGND sky130_fd_sc_hd__tapvpwrvgnd_1
* cell instance $1950 m0 *1 35.88,163.2
X$1950 VPWR VGND sky130_fd_sc_hd__tapvpwrvgnd_1
* cell instance $1951 m0 *1 113.16,163.2
X$1951 VPWR VGND sky130_fd_sc_hd__tapvpwrvgnd_1
* cell instance $1952 m0 *1 87.4,157.76
X$1952 VPWR VGND sky130_fd_sc_hd__tapvpwrvgnd_1
* cell instance $1953 m0 *1 138.92,103.36
X$1953 VPWR VGND sky130_fd_sc_hd__tapvpwrvgnd_1
* cell instance $1954 m0 *1 35.88,174.08
X$1954 VPWR VGND sky130_fd_sc_hd__tapvpwrvgnd_1
* cell instance $1955 m0 *1 164.68,212.16
X$1955 VPWR VGND sky130_fd_sc_hd__tapvpwrvgnd_1
* cell instance $1956 m0 *1 87.4,81.6
X$1956 VPWR VGND sky130_fd_sc_hd__tapvpwrvgnd_1
* cell instance $1957 m0 *1 61.64,146.88
X$1957 VPWR VGND sky130_fd_sc_hd__tapvpwrvgnd_1
* cell instance $1958 m0 *1 61.64,16.32
X$1958 VPWR VGND sky130_fd_sc_hd__tapvpwrvgnd_1
* cell instance $1959 m0 *1 61.64,157.76
X$1959 VPWR VGND sky130_fd_sc_hd__tapvpwrvgnd_1
* cell instance $1960 m0 *1 87.4,21.76
X$1960 VPWR VGND sky130_fd_sc_hd__tapvpwrvgnd_1
* cell instance $1961 m0 *1 164.68,114.24
X$1961 VPWR VGND sky130_fd_sc_hd__tapvpwrvgnd_1
* cell instance $1962 m0 *1 164.68,125.12
X$1962 VPWR VGND sky130_fd_sc_hd__tapvpwrvgnd_1
* cell instance $1963 m0 *1 138.92,288.32
X$1963 VPWR VGND sky130_fd_sc_hd__tapvpwrvgnd_1
* cell instance $1964 m0 *1 138.92,228.48
X$1964 VPWR VGND sky130_fd_sc_hd__tapvpwrvgnd_1
* cell instance $1965 m0 *1 35.88,223.04
X$1965 VPWR VGND sky130_fd_sc_hd__tapvpwrvgnd_1
* cell instance $1966 m0 *1 61.64,152.32
X$1966 VPWR VGND sky130_fd_sc_hd__tapvpwrvgnd_1
* cell instance $1967 m0 *1 87.4,206.72
X$1967 VPWR VGND sky130_fd_sc_hd__tapvpwrvgnd_1
* cell instance $1968 m0 *1 35.88,244.8
X$1968 VPWR VGND sky130_fd_sc_hd__tapvpwrvgnd_1
* cell instance $1969 m0 *1 87.4,27.2
X$1969 VPWR VGND sky130_fd_sc_hd__tapvpwrvgnd_1
* cell instance $1970 m0 *1 35.88,212.16
X$1970 VPWR VGND sky130_fd_sc_hd__tapvpwrvgnd_1
* cell instance $1971 m0 *1 35.88,217.6
X$1971 VPWR VGND sky130_fd_sc_hd__tapvpwrvgnd_1
* cell instance $1972 m0 *1 138.92,119.68
X$1972 VPWR VGND sky130_fd_sc_hd__tapvpwrvgnd_1
* cell instance $1973 m0 *1 35.88,206.72
X$1973 VPWR VGND sky130_fd_sc_hd__tapvpwrvgnd_1
* cell instance $1974 m0 *1 138.92,217.6
X$1974 VPWR VGND sky130_fd_sc_hd__tapvpwrvgnd_1
* cell instance $1975 m0 *1 87.4,152.32
X$1975 VPWR VGND sky130_fd_sc_hd__tapvpwrvgnd_1
* cell instance $1976 m0 *1 113.16,81.6
X$1976 VPWR VGND sky130_fd_sc_hd__tapvpwrvgnd_1
* cell instance $1977 m0 *1 138.92,206.72
X$1977 VPWR VGND sky130_fd_sc_hd__tapvpwrvgnd_1
* cell instance $1978 m0 *1 164.68,103.36
X$1978 VPWR VGND sky130_fd_sc_hd__tapvpwrvgnd_1
* cell instance $1979 m0 *1 61.64,92.48
X$1979 VPWR VGND sky130_fd_sc_hd__tapvpwrvgnd_1
* cell instance $1980 m0 *1 138.92,244.8
X$1980 VPWR VGND sky130_fd_sc_hd__tapvpwrvgnd_1
* cell instance $1981 m0 *1 164.68,59.84
X$1981 VPWR VGND sky130_fd_sc_hd__tapvpwrvgnd_1
* cell instance $1982 m0 *1 113.16,190.4
X$1982 VPWR VGND sky130_fd_sc_hd__tapvpwrvgnd_1
* cell instance $1983 m0 *1 35.88,92.48
X$1983 VPWR VGND sky130_fd_sc_hd__tapvpwrvgnd_1
* cell instance $1984 m0 *1 35.88,81.6
X$1984 VPWR VGND sky130_fd_sc_hd__tapvpwrvgnd_1
* cell instance $1985 m0 *1 164.68,65.28
X$1985 VPWR VGND sky130_fd_sc_hd__tapvpwrvgnd_1
* cell instance $1986 m0 *1 35.88,87.04
X$1986 VPWR VGND sky130_fd_sc_hd__tapvpwrvgnd_1
* cell instance $1987 m0 *1 164.68,70.72
X$1987 VPWR VGND sky130_fd_sc_hd__tapvpwrvgnd_1
* cell instance $1988 m0 *1 35.88,114.24
X$1988 VPWR VGND sky130_fd_sc_hd__tapvpwrvgnd_1
* cell instance $1989 m0 *1 87.4,168.64
X$1989 VPWR VGND sky130_fd_sc_hd__tapvpwrvgnd_1
* cell instance $1990 m0 *1 113.16,184.96
X$1990 VPWR VGND sky130_fd_sc_hd__tapvpwrvgnd_1
* cell instance $1991 m0 *1 35.88,125.12
X$1991 VPWR VGND sky130_fd_sc_hd__tapvpwrvgnd_1
* cell instance $1992 m0 *1 113.16,239.36
X$1992 VPWR VGND sky130_fd_sc_hd__tapvpwrvgnd_1
* cell instance $1993 m0 *1 35.88,136
X$1993 VPWR VGND sky130_fd_sc_hd__tapvpwrvgnd_1
* cell instance $1994 m0 *1 113.16,272
X$1994 VPWR VGND sky130_fd_sc_hd__tapvpwrvgnd_1
* cell instance $1995 m0 *1 35.88,130.56
X$1995 VPWR VGND sky130_fd_sc_hd__tapvpwrvgnd_1
* cell instance $1996 m0 *1 35.88,76.16
X$1996 VPWR VGND sky130_fd_sc_hd__tapvpwrvgnd_1
* cell instance $1997 m0 *1 113.16,141.44
X$1997 VPWR VGND sky130_fd_sc_hd__tapvpwrvgnd_1
* cell instance $1998 m0 *1 164.68,190.4
X$1998 VPWR VGND sky130_fd_sc_hd__tapvpwrvgnd_1
* cell instance $1999 m0 *1 87.4,190.4
X$1999 VPWR VGND sky130_fd_sc_hd__tapvpwrvgnd_1
* cell instance $2000 m0 *1 87.4,146.88
X$2000 VPWR VGND sky130_fd_sc_hd__tapvpwrvgnd_1
* cell instance $2001 m0 *1 113.16,228.48
X$2001 VPWR VGND sky130_fd_sc_hd__tapvpwrvgnd_1
* cell instance $2002 m0 *1 113.16,212.16
X$2002 VPWR VGND sky130_fd_sc_hd__tapvpwrvgnd_1
* cell instance $2003 m0 *1 87.4,277.44
X$2003 VPWR VGND sky130_fd_sc_hd__tapvpwrvgnd_1
* cell instance $2004 m0 *1 35.88,157.76
X$2004 VPWR VGND sky130_fd_sc_hd__tapvpwrvgnd_1
* cell instance $2005 m0 *1 87.4,261.12
X$2005 VPWR VGND sky130_fd_sc_hd__tapvpwrvgnd_1
* cell instance $2006 m0 *1 35.88,146.88
X$2006 VPWR VGND sky130_fd_sc_hd__tapvpwrvgnd_1
* cell instance $2007 m0 *1 164.68,54.4
X$2007 VPWR VGND sky130_fd_sc_hd__tapvpwrvgnd_1
* cell instance $2008 m0 *1 138.92,141.44
X$2008 VPWR VGND sky130_fd_sc_hd__tapvpwrvgnd_1
* cell instance $2009 m0 *1 87.4,266.56
X$2009 VPWR VGND sky130_fd_sc_hd__tapvpwrvgnd_1
* cell instance $2010 m0 *1 61.64,54.4
X$2010 VPWR VGND sky130_fd_sc_hd__tapvpwrvgnd_1
* cell instance $2011 m0 *1 61.64,108.8
X$2011 VPWR VGND sky130_fd_sc_hd__tapvpwrvgnd_1
* cell instance $2012 m0 *1 61.64,114.24
X$2012 VPWR VGND sky130_fd_sc_hd__tapvpwrvgnd_1
* cell instance $2013 m0 *1 113.16,114.24
X$2013 VPWR VGND sky130_fd_sc_hd__tapvpwrvgnd_1
* cell instance $2014 m0 *1 138.92,125.12
X$2014 VPWR VGND sky130_fd_sc_hd__tapvpwrvgnd_1
* cell instance $2015 m0 *1 61.64,201.28
X$2015 VPWR VGND sky130_fd_sc_hd__tapvpwrvgnd_1
* cell instance $2016 m0 *1 61.64,184.96
X$2016 VPWR VGND sky130_fd_sc_hd__tapvpwrvgnd_1
* cell instance $2017 m0 *1 138.92,146.88
X$2017 VPWR VGND sky130_fd_sc_hd__tapvpwrvgnd_1
* cell instance $2018 m0 *1 113.16,152.32
X$2018 VPWR VGND sky130_fd_sc_hd__tapvpwrvgnd_1
* cell instance $2019 m0 *1 61.64,190.4
X$2019 VPWR VGND sky130_fd_sc_hd__tapvpwrvgnd_1
* cell instance $2020 m0 *1 164.68,43.52
X$2020 VPWR VGND sky130_fd_sc_hd__tapvpwrvgnd_1
* cell instance $2021 m0 *1 113.16,21.76
X$2021 VPWR VGND sky130_fd_sc_hd__tapvpwrvgnd_1
* cell instance $2022 m0 *1 164.68,228.48
X$2022 VPWR VGND sky130_fd_sc_hd__tapvpwrvgnd_1
* cell instance $2023 m0 *1 164.68,233.92
X$2023 VPWR VGND sky130_fd_sc_hd__tapvpwrvgnd_1
* cell instance $2024 m0 *1 87.4,76.16
X$2024 VPWR VGND sky130_fd_sc_hd__tapvpwrvgnd_1
* cell instance $2025 m0 *1 61.64,59.84
X$2025 VPWR VGND sky130_fd_sc_hd__tapvpwrvgnd_1
* cell instance $2026 m0 *1 61.64,76.16
X$2026 VPWR VGND sky130_fd_sc_hd__tapvpwrvgnd_1
* cell instance $2027 m0 *1 113.16,168.64
X$2027 VPWR VGND sky130_fd_sc_hd__tapvpwrvgnd_1
* cell instance $2028 r0 *1 104.88,163.2
X$2028 VGND clk \$1271 VPWR VPWR VGND sky130_fd_sc_hd__clkbuf_16
* cell instance $2029 m0 *1 61.64,48.96
X$2029 VPWR VGND sky130_fd_sc_hd__tapvpwrvgnd_1
* cell instance $2030 m0 *1 61.64,38.08
X$2030 VPWR VGND sky130_fd_sc_hd__tapvpwrvgnd_1
* cell instance $2031 m0 *1 35.88,97.92
X$2031 VPWR VGND sky130_fd_sc_hd__tapvpwrvgnd_1
* cell instance $2032 m0 *1 61.64,43.52
X$2032 VPWR VGND sky130_fd_sc_hd__tapvpwrvgnd_1
* cell instance $2033 m0 *1 61.64,119.68
X$2033 VPWR VGND sky130_fd_sc_hd__tapvpwrvgnd_1
* cell instance $2034 m0 *1 87.4,103.36
X$2034 VPWR VGND sky130_fd_sc_hd__tapvpwrvgnd_1
* cell instance $2035 m0 *1 164.68,239.36
X$2035 VPWR VGND sky130_fd_sc_hd__tapvpwrvgnd_1
* cell instance $2036 m0 *1 113.16,288.32
X$2036 VPWR VGND sky130_fd_sc_hd__tapvpwrvgnd_1
* cell instance $2037 m0 *1 35.88,32.64
X$2037 VPWR VGND sky130_fd_sc_hd__tapvpwrvgnd_1
* cell instance $2038 m0 *1 164.68,244.8
X$2038 VPWR VGND sky130_fd_sc_hd__tapvpwrvgnd_1
* cell instance $2039 m0 *1 138.92,16.32
X$2039 VPWR VGND sky130_fd_sc_hd__tapvpwrvgnd_1
* cell instance $2040 m0 *1 113.16,27.2
X$2040 VPWR VGND sky130_fd_sc_hd__tapvpwrvgnd_1
* cell instance $2041 m0 *1 35.88,108.8
X$2041 VPWR VGND sky130_fd_sc_hd__tapvpwrvgnd_1
* cell instance $2042 m0 *1 113.16,244.8
X$2042 VPWR VGND sky130_fd_sc_hd__tapvpwrvgnd_1
* cell instance $2043 m0 *1 87.4,184.96
X$2043 VPWR VGND sky130_fd_sc_hd__tapvpwrvgnd_1
* cell instance $2044 m0 *1 113.16,103.36
X$2044 VPWR VGND sky130_fd_sc_hd__tapvpwrvgnd_1
* cell instance $2045 m0 *1 113.16,277.44
X$2045 VPWR VGND sky130_fd_sc_hd__tapvpwrvgnd_1
* cell instance $2046 m0 *1 87.4,130.56
X$2046 VPWR VGND sky130_fd_sc_hd__tapvpwrvgnd_1
* cell instance $2047 m0 *1 61.64,32.64
X$2047 VPWR VGND sky130_fd_sc_hd__tapvpwrvgnd_1
* cell instance $2048 m0 *1 61.64,70.72
X$2048 VPWR VGND sky130_fd_sc_hd__tapvpwrvgnd_1
* cell instance $2049 m0 *1 35.88,103.36
X$2049 VPWR VGND sky130_fd_sc_hd__tapvpwrvgnd_1
* cell instance $2050 m0 *1 87.4,97.92
X$2050 VPWR VGND sky130_fd_sc_hd__tapvpwrvgnd_1
* cell instance $2051 m0 *1 87.4,32.64
X$2051 VPWR VGND sky130_fd_sc_hd__tapvpwrvgnd_1
* cell instance $2052 m0 *1 87.4,125.12
X$2052 VPWR VGND sky130_fd_sc_hd__tapvpwrvgnd_1
* cell instance $2053 m0 *1 113.16,38.08
X$2053 VPWR VGND sky130_fd_sc_hd__tapvpwrvgnd_1
* cell instance $2054 m0 *1 113.16,174.08
X$2054 VPWR VGND sky130_fd_sc_hd__tapvpwrvgnd_1
* cell instance $2055 m0 *1 113.16,179.52
X$2055 VPWR VGND sky130_fd_sc_hd__tapvpwrvgnd_1
* cell instance $2056 m0 *1 113.16,282.88
X$2056 VPWR VGND sky130_fd_sc_hd__tapvpwrvgnd_1
* cell instance $2057 m0 *1 87.4,195.84
X$2057 VPWR VGND sky130_fd_sc_hd__tapvpwrvgnd_1
* cell instance $2058 m0 *1 113.16,48.96
X$2058 VPWR VGND sky130_fd_sc_hd__tapvpwrvgnd_1
* cell instance $2059 m0 *1 87.4,201.28
X$2059 VPWR VGND sky130_fd_sc_hd__tapvpwrvgnd_1
* cell instance $2060 m0 *1 61.64,65.28
X$2060 VPWR VGND sky130_fd_sc_hd__tapvpwrvgnd_1
* cell instance $2061 m0 *1 138.92,21.76
X$2061 VPWR VGND sky130_fd_sc_hd__tapvpwrvgnd_1
* cell instance $2062 m0 *1 61.64,141.44
X$2062 VPWR VGND sky130_fd_sc_hd__tapvpwrvgnd_1
* cell instance $2063 m0 *1 61.64,97.92
X$2063 VPWR VGND sky130_fd_sc_hd__tapvpwrvgnd_1
* cell instance $2064 m0 *1 164.68,250.24
X$2064 VPWR VGND sky130_fd_sc_hd__tapvpwrvgnd_1
* cell instance $2065 m0 *1 138.92,157.76
X$2065 VPWR VGND sky130_fd_sc_hd__tapvpwrvgnd_1
* cell instance $2066 m0 *1 87.4,174.08
X$2066 VPWR VGND sky130_fd_sc_hd__tapvpwrvgnd_1
* cell instance $2067 m0 *1 61.64,174.08
X$2067 VPWR VGND sky130_fd_sc_hd__tapvpwrvgnd_1
* cell instance $2068 m0 *1 61.64,179.52
X$2068 VPWR VGND sky130_fd_sc_hd__tapvpwrvgnd_1
* cell instance $2069 m0 *1 61.64,195.84
X$2069 VPWR VGND sky130_fd_sc_hd__tapvpwrvgnd_1
* cell instance $2070 m0 *1 35.88,141.44
X$2070 VPWR VGND sky130_fd_sc_hd__tapvpwrvgnd_1
* cell instance $2071 m0 *1 87.4,119.68
X$2071 VPWR VGND sky130_fd_sc_hd__tapvpwrvgnd_1
* cell instance $2072 m0 *1 164.68,223.04
X$2072 VPWR VGND sky130_fd_sc_hd__tapvpwrvgnd_1
* cell instance $2073 m0 *1 164.68,261.12
X$2073 VPWR VGND sky130_fd_sc_hd__tapvpwrvgnd_1
* cell instance $2074 m0 *1 113.16,157.76
X$2074 VPWR VGND sky130_fd_sc_hd__tapvpwrvgnd_1
* cell instance $2075 m0 *1 113.16,195.84
X$2075 VPWR VGND sky130_fd_sc_hd__tapvpwrvgnd_1
* cell instance $2076 m0 *1 87.4,250.24
X$2076 VPWR VGND sky130_fd_sc_hd__tapvpwrvgnd_1
* cell instance $2077 m0 *1 138.92,152.32
X$2077 VPWR VGND sky130_fd_sc_hd__tapvpwrvgnd_1
* cell instance $2078 m0 *1 61.64,255.68
X$2078 VPWR VGND sky130_fd_sc_hd__tapvpwrvgnd_1
* cell instance $2079 m0 *1 138.92,43.52
X$2079 VPWR VGND sky130_fd_sc_hd__tapvpwrvgnd_1
* cell instance $2080 m0 *1 74.52,288.32
X$2080 VPWR VGND sky130_fd_sc_hd__tapvpwrvgnd_1
* cell instance $2081 m0 *1 61.64,288.32
X$2081 VPWR VGND sky130_fd_sc_hd__tapvpwrvgnd_1
* cell instance $2082 m0 *1 61.64,261.12
X$2082 VPWR VGND sky130_fd_sc_hd__tapvpwrvgnd_1
* cell instance $2083 m0 *1 138.92,54.4
X$2083 VPWR VGND sky130_fd_sc_hd__tapvpwrvgnd_1
* cell instance $2084 m0 *1 138.92,38.08
X$2084 VPWR VGND sky130_fd_sc_hd__tapvpwrvgnd_1
* cell instance $2085 m0 *1 61.64,282.88
X$2085 VPWR VGND sky130_fd_sc_hd__tapvpwrvgnd_1
* cell instance $2086 m0 *1 164.68,184.96
X$2086 VPWR VGND sky130_fd_sc_hd__tapvpwrvgnd_1
* cell instance $2087 m0 *1 138.92,65.28
X$2087 VPWR VGND sky130_fd_sc_hd__tapvpwrvgnd_1
* cell instance $2088 m0 *1 138.92,70.72
X$2088 VPWR VGND sky130_fd_sc_hd__tapvpwrvgnd_1
* cell instance $2089 m0 *1 87.4,136
X$2089 VPWR VGND sky130_fd_sc_hd__tapvpwrvgnd_1
* cell instance $2090 m0 *1 61.64,266.56
X$2090 VPWR VGND sky130_fd_sc_hd__tapvpwrvgnd_1
* cell instance $2091 m0 *1 164.68,266.56
X$2091 VPWR VGND sky130_fd_sc_hd__tapvpwrvgnd_1
* cell instance $2092 m0 *1 164.68,81.6
X$2092 VPWR VGND sky130_fd_sc_hd__tapvpwrvgnd_1
* cell instance $2093 m0 *1 61.64,81.6
X$2093 VPWR VGND sky130_fd_sc_hd__tapvpwrvgnd_1
* cell instance $2094 m0 *1 87.4,108.8
X$2094 VPWR VGND sky130_fd_sc_hd__tapvpwrvgnd_1
* cell instance $2095 m0 *1 35.88,119.68
X$2095 VPWR VGND sky130_fd_sc_hd__tapvpwrvgnd_1
* cell instance $2096 m0 *1 138.92,130.56
X$2096 VPWR VGND sky130_fd_sc_hd__tapvpwrvgnd_1
* cell instance $2097 m0 *1 61.64,168.64
X$2097 VPWR VGND sky130_fd_sc_hd__tapvpwrvgnd_1
* cell instance $2098 m0 *1 164.68,92.48
X$2098 VPWR VGND sky130_fd_sc_hd__tapvpwrvgnd_1
* cell instance $2099 m0 *1 113.16,43.52
X$2099 VPWR VGND sky130_fd_sc_hd__tapvpwrvgnd_1
* cell instance $2100 m0 *1 87.4,272
X$2100 VPWR VGND sky130_fd_sc_hd__tapvpwrvgnd_1
* cell instance $2101 m0 *1 138.92,48.96
X$2101 VPWR VGND sky130_fd_sc_hd__tapvpwrvgnd_1
* cell instance $2102 m0 *1 113.16,125.12
X$2102 VPWR VGND sky130_fd_sc_hd__tapvpwrvgnd_1
* cell instance $2103 m0 *1 87.4,282.88
X$2103 VPWR VGND sky130_fd_sc_hd__tapvpwrvgnd_1
* cell instance $2104 m0 *1 35.88,152.32
X$2104 VPWR VGND sky130_fd_sc_hd__tapvpwrvgnd_1
* cell instance $2105 m0 *1 113.16,16.32
X$2105 VPWR VGND sky130_fd_sc_hd__tapvpwrvgnd_1
* cell instance $2106 m0 *1 138.92,27.2
X$2106 VPWR VGND sky130_fd_sc_hd__tapvpwrvgnd_1
* cell instance $2107 m0 *1 164.68,255.68
X$2107 VPWR VGND sky130_fd_sc_hd__tapvpwrvgnd_1
* cell instance $2108 m0 *1 87.4,163.2
X$2108 VPWR VGND sky130_fd_sc_hd__tapvpwrvgnd_1
* cell instance $2109 m0 *1 113.16,233.92
X$2109 VPWR VGND sky130_fd_sc_hd__tapvpwrvgnd_1
* cell instance $2110 m0 *1 138.92,59.84
X$2110 VPWR VGND sky130_fd_sc_hd__tapvpwrvgnd_1
* cell instance $2111 m0 *1 61.64,163.2
X$2111 VPWR VGND sky130_fd_sc_hd__tapvpwrvgnd_1
* cell instance $2112 m0 *1 87.4,288.32
X$2112 VPWR VGND sky130_fd_sc_hd__tapvpwrvgnd_1
* cell instance $2113 m0 *1 87.4,114.24
X$2113 VPWR VGND sky130_fd_sc_hd__tapvpwrvgnd_1
* cell instance $2114 m0 *1 87.4,179.52
X$2114 VPWR VGND sky130_fd_sc_hd__tapvpwrvgnd_1
* cell instance $2115 m0 *1 87.4,255.68
X$2115 VPWR VGND sky130_fd_sc_hd__tapvpwrvgnd_1
* cell instance $2116 m0 *1 113.16,201.28
X$2116 VPWR VGND sky130_fd_sc_hd__tapvpwrvgnd_1
* cell instance $2117 r0 *1 48.76,261.12
X$2117 VPWR VGND sky130_fd_sc_hd__tapvpwrvgnd_1
* cell instance $2118 r0 *1 100.28,21.76
X$2118 VPWR VGND sky130_fd_sc_hd__tapvpwrvgnd_1
* cell instance $2119 r0 *1 100.28,136
X$2119 VPWR VGND sky130_fd_sc_hd__tapvpwrvgnd_1
* cell instance $2120 r0 *1 177.56,244.8
X$2120 VPWR VGND sky130_fd_sc_hd__tapvpwrvgnd_1
* cell instance $2121 r0 *1 100.28,152.32
X$2121 VPWR VGND sky130_fd_sc_hd__tapvpwrvgnd_1
* cell instance $2122 r0 *1 100.28,130.56
X$2122 VPWR VGND sky130_fd_sc_hd__tapvpwrvgnd_1
* cell instance $2123 r0 *1 100.28,16.32
X$2123 VPWR VGND sky130_fd_sc_hd__tapvpwrvgnd_1
* cell instance $2124 r0 *1 100.28,27.2
X$2124 VPWR VGND sky130_fd_sc_hd__tapvpwrvgnd_1
* cell instance $2125 r0 *1 100.28,114.24
X$2125 VPWR VGND sky130_fd_sc_hd__tapvpwrvgnd_1
* cell instance $2126 r0 *1 100.28,97.92
X$2126 VPWR VGND sky130_fd_sc_hd__tapvpwrvgnd_1
* cell instance $2127 r0 *1 177.56,266.56
X$2127 VPWR VGND sky130_fd_sc_hd__tapvpwrvgnd_1
* cell instance $2128 r0 *1 100.28,119.68
X$2128 VPWR VGND sky130_fd_sc_hd__tapvpwrvgnd_1
* cell instance $2129 r0 *1 48.76,255.68
X$2129 VPWR VGND sky130_fd_sc_hd__tapvpwrvgnd_1
* cell instance $2130 r0 *1 100.28,108.8
X$2130 VPWR VGND sky130_fd_sc_hd__tapvpwrvgnd_1
* cell instance $2131 r0 *1 48.76,282.88
X$2131 VPWR VGND sky130_fd_sc_hd__tapvpwrvgnd_1
* cell instance $2132 r0 *1 100.28,54.4
X$2132 VPWR VGND sky130_fd_sc_hd__tapvpwrvgnd_1
* cell instance $2133 r0 *1 100.28,70.72
X$2133 VPWR VGND sky130_fd_sc_hd__tapvpwrvgnd_1
* cell instance $2134 r0 *1 97.52,70.72
X$2134 VPWR VGND VPWR \$729 VGND sky130_fd_sc_hd__clkbuf_4
* cell instance $2135 r180 *1 102.58,76.16
X$2135 VGND \$1271 \$729 VPWR VPWR VGND sky130_fd_sc_hd__clkbuf_8
* cell instance $2136 r0 *1 100.28,92.48
X$2136 VPWR VGND sky130_fd_sc_hd__tapvpwrvgnd_1
* cell instance $2137 r0 *1 48.76,250.24
X$2137 VPWR VGND sky130_fd_sc_hd__tapvpwrvgnd_1
* cell instance $2138 r0 *1 100.28,59.84
X$2138 VPWR VGND sky130_fd_sc_hd__tapvpwrvgnd_1
* cell instance $2139 r0 *1 100.28,146.88
X$2139 VPWR VGND sky130_fd_sc_hd__tapvpwrvgnd_1
* cell instance $2140 r0 *1 177.56,92.48
X$2140 VPWR VGND sky130_fd_sc_hd__tapvpwrvgnd_1
* cell instance $2141 r0 *1 100.28,65.28
X$2141 VPWR VGND sky130_fd_sc_hd__tapvpwrvgnd_1
* cell instance $2142 r0 *1 100.28,87.04
X$2142 VPWR VGND sky130_fd_sc_hd__tapvpwrvgnd_1
* cell instance $2143 r0 *1 100.28,48.96
X$2143 VPWR VGND sky130_fd_sc_hd__tapvpwrvgnd_1
* cell instance $2144 r0 *1 151.8,244.8
X$2144 VPWR VGND sky130_fd_sc_hd__tapvpwrvgnd_1
* cell instance $2145 r0 *1 100.28,125.12
X$2145 VPWR VGND sky130_fd_sc_hd__tapvpwrvgnd_1
* cell instance $2146 r0 *1 177.56,136
X$2146 VPWR VGND sky130_fd_sc_hd__tapvpwrvgnd_1
* cell instance $2147 r0 *1 126.04,266.56
X$2147 VPWR VGND sky130_fd_sc_hd__tapvpwrvgnd_1
* cell instance $2148 r0 *1 100.28,76.16
X$2148 VPWR VGND sky130_fd_sc_hd__tapvpwrvgnd_1
* cell instance $2149 r0 *1 100.28,32.64
X$2149 VPWR VGND sky130_fd_sc_hd__tapvpwrvgnd_1
* cell instance $2150 r0 *1 48.76,272
X$2150 VPWR VGND sky130_fd_sc_hd__tapvpwrvgnd_1
* cell instance $2151 r0 *1 48.76,277.44
X$2151 VPWR VGND sky130_fd_sc_hd__tapvpwrvgnd_1
* cell instance $2152 r0 *1 177.56,125.12
X$2152 VPWR VGND sky130_fd_sc_hd__tapvpwrvgnd_1
* cell instance $2153 r0 *1 100.28,103.36
X$2153 VPWR VGND sky130_fd_sc_hd__tapvpwrvgnd_1
* cell instance $2154 r0 *1 100.28,38.08
X$2154 VPWR VGND sky130_fd_sc_hd__tapvpwrvgnd_1
* cell instance $2155 r0 *1 100.28,43.52
X$2155 VPWR VGND sky130_fd_sc_hd__tapvpwrvgnd_1
* cell instance $2156 r0 *1 126.04,108.8
X$2156 VPWR VGND sky130_fd_sc_hd__tapvpwrvgnd_1
* cell instance $2157 r0 *1 126.04,32.64
X$2157 VPWR VGND sky130_fd_sc_hd__tapvpwrvgnd_1
* cell instance $2158 r0 *1 100.28,81.6
X$2158 VPWR VGND sky130_fd_sc_hd__tapvpwrvgnd_1
* cell instance $2159 r0 *1 126.04,272
X$2159 VPWR VGND sky130_fd_sc_hd__tapvpwrvgnd_1
* cell instance $2160 r0 *1 177.56,108.8
X$2160 VPWR VGND sky130_fd_sc_hd__tapvpwrvgnd_1
* cell instance $2161 r0 *1 74.52,277.44
X$2161 VPWR VGND sky130_fd_sc_hd__tapvpwrvgnd_1
* cell instance $2162 r0 *1 100.28,250.24
X$2162 VPWR VGND sky130_fd_sc_hd__tapvpwrvgnd_1
* cell instance $2163 r0 *1 100.28,212.16
X$2163 VPWR VGND sky130_fd_sc_hd__tapvpwrvgnd_1
* cell instance $2164 r0 *1 74.52,223.04
X$2164 VPWR VGND sky130_fd_sc_hd__tapvpwrvgnd_1
* cell instance $2165 r0 *1 100.28,206.72
X$2165 VPWR VGND sky130_fd_sc_hd__tapvpwrvgnd_1
* cell instance $2166 r0 *1 177.56,141.44
X$2166 VPWR VGND sky130_fd_sc_hd__tapvpwrvgnd_1
* cell instance $2167 r0 *1 177.56,130.56
X$2167 VPWR VGND sky130_fd_sc_hd__tapvpwrvgnd_1
* cell instance $2168 r0 *1 74.52,233.92
X$2168 VPWR VGND sky130_fd_sc_hd__tapvpwrvgnd_1
* cell instance $2169 r0 *1 100.28,217.6
X$2169 VPWR VGND sky130_fd_sc_hd__tapvpwrvgnd_1
* cell instance $2170 r0 *1 74.52,228.48
X$2170 VPWR VGND sky130_fd_sc_hd__tapvpwrvgnd_1
* cell instance $2171 r0 *1 100.28,244.8
X$2171 VPWR VGND sky130_fd_sc_hd__tapvpwrvgnd_1
* cell instance $2172 r0 *1 74.52,239.36
X$2172 VPWR VGND sky130_fd_sc_hd__tapvpwrvgnd_1
* cell instance $2173 r0 *1 177.56,157.76
X$2173 VPWR VGND sky130_fd_sc_hd__tapvpwrvgnd_1
* cell instance $2174 r0 *1 126.04,282.88
X$2174 VPWR VGND sky130_fd_sc_hd__tapvpwrvgnd_1
* cell instance $2175 r0 *1 177.56,87.04
X$2175 VPWR VGND sky130_fd_sc_hd__tapvpwrvgnd_1
* cell instance $2176 r0 *1 100.28,266.56
X$2176 VPWR VGND sky130_fd_sc_hd__tapvpwrvgnd_1
* cell instance $2177 r0 *1 126.04,201.28
X$2177 VPWR VGND sky130_fd_sc_hd__tapvpwrvgnd_1
* cell instance $2178 r0 *1 74.52,272
X$2178 VPWR VGND sky130_fd_sc_hd__tapvpwrvgnd_1
* cell instance $2179 r0 *1 74.52,266.56
X$2179 VPWR VGND sky130_fd_sc_hd__tapvpwrvgnd_1
* cell instance $2180 r0 *1 100.28,277.44
X$2180 VPWR VGND sky130_fd_sc_hd__tapvpwrvgnd_1
* cell instance $2181 r0 *1 74.52,282.88
X$2181 VPWR VGND sky130_fd_sc_hd__tapvpwrvgnd_1
* cell instance $2182 r0 *1 151.8,16.32
X$2182 VPWR VGND sky130_fd_sc_hd__tapvpwrvgnd_1
* cell instance $2183 r0 *1 74.52,261.12
X$2183 VPWR VGND sky130_fd_sc_hd__tapvpwrvgnd_1
* cell instance $2184 r0 *1 177.56,76.16
X$2184 VPWR VGND sky130_fd_sc_hd__tapvpwrvgnd_1
* cell instance $2185 r0 *1 177.56,146.88
X$2185 VPWR VGND sky130_fd_sc_hd__tapvpwrvgnd_1
* cell instance $2186 r0 *1 100.28,233.92
X$2186 VPWR VGND sky130_fd_sc_hd__tapvpwrvgnd_1
* cell instance $2187 r0 *1 177.56,152.32
X$2187 VPWR VGND sky130_fd_sc_hd__tapvpwrvgnd_1
* cell instance $2188 r0 *1 74.52,206.72
X$2188 VPWR VGND sky130_fd_sc_hd__tapvpwrvgnd_1
* cell instance $2189 r0 *1 151.8,27.2
X$2189 VPWR VGND sky130_fd_sc_hd__tapvpwrvgnd_1
* cell instance $2190 r0 *1 74.52,212.16
X$2190 VPWR VGND sky130_fd_sc_hd__tapvpwrvgnd_1
* cell instance $2191 r0 *1 126.04,277.44
X$2191 VPWR VGND sky130_fd_sc_hd__tapvpwrvgnd_1
* cell instance $2192 r0 *1 74.52,255.68
X$2192 VPWR VGND sky130_fd_sc_hd__tapvpwrvgnd_1
* cell instance $2193 r0 *1 100.28,223.04
X$2193 VPWR VGND sky130_fd_sc_hd__tapvpwrvgnd_1
* cell instance $2194 r0 *1 74.52,250.24
X$2194 VPWR VGND sky130_fd_sc_hd__tapvpwrvgnd_1
* cell instance $2195 r0 *1 151.8,201.28
X$2195 VPWR VGND sky130_fd_sc_hd__tapvpwrvgnd_1
* cell instance $2196 r0 *1 100.28,184.96
X$2196 VPWR VGND sky130_fd_sc_hd__tapvpwrvgnd_1
* cell instance $2197 r0 *1 126.04,76.16
X$2197 VPWR VGND sky130_fd_sc_hd__tapvpwrvgnd_1
* cell instance $2198 r0 *1 100.28,168.64
X$2198 VPWR VGND sky130_fd_sc_hd__tapvpwrvgnd_1
* cell instance $2199 r0 *1 100.28,179.52
X$2199 VPWR VGND sky130_fd_sc_hd__tapvpwrvgnd_1
* cell instance $2200 r0 *1 100.28,174.08
X$2200 VPWR VGND sky130_fd_sc_hd__tapvpwrvgnd_1
* cell instance $2201 r0 *1 151.8,21.76
X$2201 VPWR VGND sky130_fd_sc_hd__tapvpwrvgnd_1
* cell instance $2202 r0 *1 126.04,250.24
X$2202 VPWR VGND sky130_fd_sc_hd__tapvpwrvgnd_1
* cell instance $2203 r0 *1 126.04,261.12
X$2203 VPWR VGND sky130_fd_sc_hd__tapvpwrvgnd_1
* cell instance $2204 r0 *1 48.76,244.8
X$2204 VPWR VGND sky130_fd_sc_hd__tapvpwrvgnd_1
* cell instance $2205 r0 *1 100.28,163.2
X$2205 VPWR VGND sky130_fd_sc_hd__tapvpwrvgnd_1
* cell instance $2206 r0 *1 100.28,141.44
X$2206 VPWR VGND sky130_fd_sc_hd__tapvpwrvgnd_1
* cell instance $2207 r0 *1 126.04,239.36
X$2207 VPWR VGND sky130_fd_sc_hd__tapvpwrvgnd_1
* cell instance $2208 r0 *1 177.56,179.52
X$2208 VPWR VGND sky130_fd_sc_hd__tapvpwrvgnd_1
* cell instance $2209 r0 *1 100.28,157.76
X$2209 VPWR VGND sky130_fd_sc_hd__tapvpwrvgnd_1
* cell instance $2210 r0 *1 100.28,10.88
X$2210 VPWR VGND sky130_fd_sc_hd__tapvpwrvgnd_1
* cell instance $2211 r0 *1 177.56,81.6
X$2211 VPWR VGND sky130_fd_sc_hd__tapvpwrvgnd_1
* cell instance $2212 r0 *1 23,244.8
X$2212 VPWR VGND sky130_fd_sc_hd__tapvpwrvgnd_1
* cell instance $2213 r0 *1 74.52,217.6
X$2213 VPWR VGND sky130_fd_sc_hd__tapvpwrvgnd_1
* cell instance $2214 r0 *1 100.28,255.68
X$2214 VPWR VGND sky130_fd_sc_hd__tapvpwrvgnd_1
* cell instance $2215 r0 *1 100.28,228.48
X$2215 VPWR VGND sky130_fd_sc_hd__tapvpwrvgnd_1
* cell instance $2216 r0 *1 100.28,239.36
X$2216 VPWR VGND sky130_fd_sc_hd__tapvpwrvgnd_1
* cell instance $2217 r0 *1 177.56,97.92
X$2217 VPWR VGND sky130_fd_sc_hd__tapvpwrvgnd_1
* cell instance $2218 r0 *1 100.28,282.88
X$2218 VPWR VGND sky130_fd_sc_hd__tapvpwrvgnd_1
* cell instance $2219 r0 *1 100.28,190.4
X$2219 VPWR VGND sky130_fd_sc_hd__tapvpwrvgnd_1
* cell instance $2220 r0 *1 100.28,261.12
X$2220 VPWR VGND sky130_fd_sc_hd__tapvpwrvgnd_1
* cell instance $2221 r0 *1 177.56,201.28
X$2221 VPWR VGND sky130_fd_sc_hd__tapvpwrvgnd_1
* cell instance $2222 r0 *1 74.52,244.8
X$2222 VPWR VGND sky130_fd_sc_hd__tapvpwrvgnd_1
* cell instance $2223 r0 *1 23,201.28
X$2223 VPWR VGND sky130_fd_sc_hd__tapvpwrvgnd_1
* cell instance $2224 r0 *1 48.76,201.28
X$2224 VPWR VGND sky130_fd_sc_hd__tapvpwrvgnd_1
* cell instance $2225 r0 *1 74.52,201.28
X$2225 VPWR VGND sky130_fd_sc_hd__tapvpwrvgnd_1
* cell instance $2226 r0 *1 177.56,103.36
X$2226 VPWR VGND sky130_fd_sc_hd__tapvpwrvgnd_1
* cell instance $2227 r0 *1 100.28,201.28
X$2227 VPWR VGND sky130_fd_sc_hd__tapvpwrvgnd_1
* cell instance $2228 r0 *1 177.56,119.68
X$2228 VPWR VGND sky130_fd_sc_hd__tapvpwrvgnd_1
* cell instance $2229 r0 *1 100.28,195.84
X$2229 VPWR VGND sky130_fd_sc_hd__tapvpwrvgnd_1
* cell instance $2230 r0 *1 151.8,157.76
X$2230 VPWR VGND sky130_fd_sc_hd__tapvpwrvgnd_1
* cell instance $2231 r0 *1 100.28,272
X$2231 VPWR VGND sky130_fd_sc_hd__tapvpwrvgnd_1
* cell instance $2232 r0 *1 177.56,195.84
X$2232 VPWR VGND sky130_fd_sc_hd__tapvpwrvgnd_1
* cell instance $2233 r0 *1 23,92.48
X$2233 VPWR VGND sky130_fd_sc_hd__tapvpwrvgnd_1
* cell instance $2234 r0 *1 23,81.6
X$2234 VPWR VGND sky130_fd_sc_hd__tapvpwrvgnd_1
* cell instance $2235 r0 *1 48.76,92.48
X$2235 VPWR VGND sky130_fd_sc_hd__tapvpwrvgnd_1
* cell instance $2236 r0 *1 48.76,76.16
X$2236 VPWR VGND sky130_fd_sc_hd__tapvpwrvgnd_1
* cell instance $2237 r0 *1 74.52,76.16
X$2237 VPWR VGND sky130_fd_sc_hd__tapvpwrvgnd_1
* cell instance $2238 r0 *1 126.04,152.32
X$2238 VPWR VGND sky130_fd_sc_hd__tapvpwrvgnd_1
* cell instance $2239 r0 *1 48.76,87.04
X$2239 VPWR VGND sky130_fd_sc_hd__tapvpwrvgnd_1
* cell instance $2240 r0 *1 48.76,81.6
X$2240 VPWR VGND sky130_fd_sc_hd__tapvpwrvgnd_1
* cell instance $2241 r0 *1 74.52,59.84
X$2241 VPWR VGND sky130_fd_sc_hd__tapvpwrvgnd_1
* cell instance $2242 r0 *1 74.52,54.4
X$2242 VPWR VGND sky130_fd_sc_hd__tapvpwrvgnd_1
* cell instance $2243 r0 *1 151.8,65.28
X$2243 VPWR VGND sky130_fd_sc_hd__tapvpwrvgnd_1
* cell instance $2244 r0 *1 151.8,59.84
X$2244 VPWR VGND sky130_fd_sc_hd__tapvpwrvgnd_1
* cell instance $2245 r0 *1 151.8,54.4
X$2245 VPWR VGND sky130_fd_sc_hd__tapvpwrvgnd_1
* cell instance $2246 r0 *1 177.56,114.24
X$2246 VPWR VGND sky130_fd_sc_hd__tapvpwrvgnd_1
* cell instance $2247 r0 *1 177.56,206.72
X$2247 VPWR VGND sky130_fd_sc_hd__tapvpwrvgnd_1
* cell instance $2248 r0 *1 177.56,21.76
X$2248 VPWR VGND sky130_fd_sc_hd__tapvpwrvgnd_1
* cell instance $2249 m90 *1 182.62,21.76
X$2249 VGND \$56 \$31 \$94 \$313 \$105 VPWR VPWR VGND sky130_fd_sc_hd__o31ai_2
* cell instance $2250 r0 *1 182.62,21.76
X$2250 VPWR \$61 VPWR VGND \$51 \$100 VGND sky130_fd_sc_hd__nand2b_2
* cell instance $2251 r0 *1 151.8,223.04
X$2251 VPWR VGND sky130_fd_sc_hd__tapvpwrvgnd_1
* cell instance $2252 r0 *1 177.56,38.08
X$2252 VPWR VGND sky130_fd_sc_hd__tapvpwrvgnd_1
* cell instance $2253 r0 *1 178.02,38.08
X$2253 VGND \$717 \$572 \$718 \$681 \$627 VPWR VPWR VGND
+ sky130_fd_sc_hd__o211ai_2
* cell instance $2254 r0 *1 74.52,70.72
X$2254 VPWR VGND sky130_fd_sc_hd__tapvpwrvgnd_1
* cell instance $2255 r0 *1 74.52,65.28
X$2255 VPWR VGND sky130_fd_sc_hd__tapvpwrvgnd_1
* cell instance $2256 r0 *1 151.8,43.52
X$2256 VPWR VGND sky130_fd_sc_hd__tapvpwrvgnd_1
* cell instance $2257 r0 *1 151.8,48.96
X$2257 VPWR VGND sky130_fd_sc_hd__tapvpwrvgnd_1
* cell instance $2258 r0 *1 151.8,38.08
X$2258 VPWR VGND sky130_fd_sc_hd__tapvpwrvgnd_1
* cell instance $2259 r0 *1 177.56,48.96
X$2259 VPWR VGND sky130_fd_sc_hd__tapvpwrvgnd_1
* cell instance $2260 m90 *1 181.24,48.96
X$2260 VPWR VPWR \$30 VGND \$50 \$1002 \$49 VGND sky130_fd_sc_hd__o21ai_2
* cell instance $2261 r0 *1 151.8,184.96
X$2261 VPWR VGND sky130_fd_sc_hd__tapvpwrvgnd_1
* cell instance $2262 r0 *1 48.76,32.64
X$2262 VPWR VGND sky130_fd_sc_hd__tapvpwrvgnd_1
* cell instance $2263 r0 *1 74.52,48.96
X$2263 VPWR VGND sky130_fd_sc_hd__tapvpwrvgnd_1
* cell instance $2264 r0 *1 177.56,10.88
X$2264 VPWR VGND sky130_fd_sc_hd__tapvpwrvgnd_1
* cell instance $2265 r0 *1 178.02,10.88
X$2265 VPWR VGND VPWR \$72 \$54 \$57 \$56 VGND sky130_fd_sc_hd__o21a_2
* cell instance $2266 r0 *1 177.56,43.52
X$2266 VPWR VGND sky130_fd_sc_hd__tapvpwrvgnd_1
* cell instance $2267 m90 *1 177.56,43.52
X$2267 VGND \$857 \$795 \$846 \$49 \$501 \$858 VPWR VPWR VGND
+ sky130_fd_sc_hd__a221o_2
* cell instance $2268 r0 *1 151.8,70.72
X$2268 VPWR VGND sky130_fd_sc_hd__tapvpwrvgnd_1
* cell instance $2269 r0 *1 151.8,261.12
X$2269 VPWR VGND sky130_fd_sc_hd__tapvpwrvgnd_1
* cell instance $2270 r0 *1 23,43.52
X$2270 VPWR VGND sky130_fd_sc_hd__tapvpwrvgnd_1
* cell instance $2271 r0 *1 151.8,250.24
X$2271 VPWR VGND sky130_fd_sc_hd__tapvpwrvgnd_1
* cell instance $2272 r0 *1 177.56,16.32
X$2272 VPWR VGND sky130_fd_sc_hd__tapvpwrvgnd_1
* cell instance $2273 m90 *1 181.7,16.32
X$2273 VPWR VPWR VGND \$166 \$169 \$46 \$54 VGND sky130_fd_sc_hd__a21bo_2
* cell instance $2274 r0 *1 23,125.12
X$2274 VPWR VGND sky130_fd_sc_hd__tapvpwrvgnd_1
* cell instance $2275 r0 *1 23,38.08
X$2275 VPWR VGND sky130_fd_sc_hd__tapvpwrvgnd_1
* cell instance $2276 r0 *1 23,141.44
X$2276 VPWR VGND sky130_fd_sc_hd__tapvpwrvgnd_1
* cell instance $2277 r0 *1 151.8,174.08
X$2277 VPWR VGND sky130_fd_sc_hd__tapvpwrvgnd_1
* cell instance $2278 r0 *1 23,136
X$2278 VPWR VGND sky130_fd_sc_hd__tapvpwrvgnd_1
* cell instance $2279 r0 *1 151.8,168.64
X$2279 VPWR VGND sky130_fd_sc_hd__tapvpwrvgnd_1
* cell instance $2280 r0 *1 23,70.72
X$2280 VPWR VGND sky130_fd_sc_hd__tapvpwrvgnd_1
* cell instance $2281 r0 *1 74.52,81.6
X$2281 VPWR VGND sky130_fd_sc_hd__tapvpwrvgnd_1
* cell instance $2282 r0 *1 23,48.96
X$2282 VPWR VGND sky130_fd_sc_hd__tapvpwrvgnd_1
* cell instance $2283 r0 *1 23,59.84
X$2283 VPWR VGND sky130_fd_sc_hd__tapvpwrvgnd_1
* cell instance $2284 r0 *1 126.04,136
X$2284 VPWR VGND sky130_fd_sc_hd__tapvpwrvgnd_1
* cell instance $2285 r0 *1 48.76,152.32
X$2285 VPWR VGND sky130_fd_sc_hd__tapvpwrvgnd_1
* cell instance $2286 r0 *1 151.8,163.2
X$2286 VPWR VGND sky130_fd_sc_hd__tapvpwrvgnd_1
* cell instance $2287 r0 *1 23,54.4
X$2287 VPWR VGND sky130_fd_sc_hd__tapvpwrvgnd_1
* cell instance $2288 r0 *1 23,65.28
X$2288 VPWR VGND sky130_fd_sc_hd__tapvpwrvgnd_1
* cell instance $2289 r0 *1 74.52,97.92
X$2289 VPWR VGND sky130_fd_sc_hd__tapvpwrvgnd_1
* cell instance $2290 r0 *1 74.52,103.36
X$2290 VPWR VGND sky130_fd_sc_hd__tapvpwrvgnd_1
* cell instance $2291 r0 *1 48.76,146.88
X$2291 VPWR VGND sky130_fd_sc_hd__tapvpwrvgnd_1
* cell instance $2292 r0 *1 48.76,141.44
X$2292 VPWR VGND sky130_fd_sc_hd__tapvpwrvgnd_1
* cell instance $2293 r0 *1 177.56,27.2
X$2293 VPWR VGND sky130_fd_sc_hd__tapvpwrvgnd_1
* cell instance $2294 r0 *1 23,108.8
X$2294 VPWR VGND sky130_fd_sc_hd__tapvpwrvgnd_1
* cell instance $2295 r0 *1 23,76.16
X$2295 VPWR VGND sky130_fd_sc_hd__tapvpwrvgnd_1
* cell instance $2296 r0 *1 23,97.92
X$2296 VPWR VGND sky130_fd_sc_hd__tapvpwrvgnd_1
* cell instance $2297 r0 *1 23,103.36
X$2297 VPWR VGND sky130_fd_sc_hd__tapvpwrvgnd_1
* cell instance $2298 r0 *1 23,87.04
X$2298 VPWR VGND sky130_fd_sc_hd__tapvpwrvgnd_1
* cell instance $2299 r0 *1 23,114.24
X$2299 VPWR VGND sky130_fd_sc_hd__tapvpwrvgnd_1
* cell instance $2300 r0 *1 126.04,146.88
X$2300 VPWR VGND sky130_fd_sc_hd__tapvpwrvgnd_1
* cell instance $2301 r0 *1 151.8,190.4
X$2301 VPWR VGND sky130_fd_sc_hd__tapvpwrvgnd_1
* cell instance $2302 r0 *1 177.56,168.64
X$2302 VPWR VGND sky130_fd_sc_hd__tapvpwrvgnd_1
* cell instance $2303 r0 *1 74.52,190.4
X$2303 VPWR VGND sky130_fd_sc_hd__tapvpwrvgnd_1
* cell instance $2304 r0 *1 74.52,195.84
X$2304 VPWR VGND sky130_fd_sc_hd__tapvpwrvgnd_1
* cell instance $2305 r0 *1 74.52,168.64
X$2305 VPWR VGND sky130_fd_sc_hd__tapvpwrvgnd_1
* cell instance $2306 r0 *1 74.52,174.08
X$2306 VPWR VGND sky130_fd_sc_hd__tapvpwrvgnd_1
* cell instance $2307 r0 *1 74.52,179.52
X$2307 VPWR VGND sky130_fd_sc_hd__tapvpwrvgnd_1
* cell instance $2308 r0 *1 177.56,65.28
X$2308 VPWR VGND sky130_fd_sc_hd__tapvpwrvgnd_1
* cell instance $2309 r0 *1 74.52,184.96
X$2309 VPWR VGND sky130_fd_sc_hd__tapvpwrvgnd_1
* cell instance $2310 r0 *1 177.56,70.72
X$2310 VPWR VGND sky130_fd_sc_hd__tapvpwrvgnd_1
* cell instance $2311 r0 *1 177.56,54.4
X$2311 VPWR VGND sky130_fd_sc_hd__tapvpwrvgnd_1
* cell instance $2312 r0 *1 74.52,163.2
X$2312 VPWR VGND sky130_fd_sc_hd__tapvpwrvgnd_1
* cell instance $2313 r0 *1 177.56,212.16
X$2313 VPWR VGND sky130_fd_sc_hd__tapvpwrvgnd_1
* cell instance $2314 r0 *1 177.56,59.84
X$2314 VPWR VGND sky130_fd_sc_hd__tapvpwrvgnd_1
* cell instance $2315 r0 *1 177.56,184.96
X$2315 VPWR VGND sky130_fd_sc_hd__tapvpwrvgnd_1
* cell instance $2316 r0 *1 74.52,43.52
X$2316 VPWR VGND sky130_fd_sc_hd__tapvpwrvgnd_1
* cell instance $2317 r0 *1 74.52,152.32
X$2317 VPWR VGND sky130_fd_sc_hd__tapvpwrvgnd_1
* cell instance $2318 r0 *1 177.56,228.48
X$2318 VPWR VGND sky130_fd_sc_hd__tapvpwrvgnd_1
* cell instance $2319 r0 *1 177.56,233.92
X$2319 VPWR VGND sky130_fd_sc_hd__tapvpwrvgnd_1
* cell instance $2320 r0 *1 177.56,174.08
X$2320 VPWR VGND sky130_fd_sc_hd__tapvpwrvgnd_1
* cell instance $2321 r0 *1 74.52,141.44
X$2321 VPWR VGND sky130_fd_sc_hd__tapvpwrvgnd_1
* cell instance $2322 r0 *1 74.52,146.88
X$2322 VPWR VGND sky130_fd_sc_hd__tapvpwrvgnd_1
* cell instance $2323 r0 *1 177.56,239.36
X$2323 VPWR VGND sky130_fd_sc_hd__tapvpwrvgnd_1
* cell instance $2324 r0 *1 177.56,163.2
X$2324 VPWR VGND sky130_fd_sc_hd__tapvpwrvgnd_1
* cell instance $2325 r0 *1 74.52,119.68
X$2325 VPWR VGND sky130_fd_sc_hd__tapvpwrvgnd_1
* cell instance $2326 r0 *1 74.52,130.56
X$2326 VPWR VGND sky130_fd_sc_hd__tapvpwrvgnd_1
* cell instance $2327 r0 *1 74.52,125.12
X$2327 VPWR VGND sky130_fd_sc_hd__tapvpwrvgnd_1
* cell instance $2328 r0 *1 74.52,136
X$2328 VPWR VGND sky130_fd_sc_hd__tapvpwrvgnd_1
* cell instance $2329 r0 *1 177.56,223.04
X$2329 VPWR VGND sky130_fd_sc_hd__tapvpwrvgnd_1
* cell instance $2330 r0 *1 151.8,179.52
X$2330 VPWR VGND sky130_fd_sc_hd__tapvpwrvgnd_1
* cell instance $2331 r0 *1 74.52,38.08
X$2331 VPWR VGND sky130_fd_sc_hd__tapvpwrvgnd_1
* cell instance $2332 r0 *1 23,32.64
X$2332 VPWR VGND sky130_fd_sc_hd__tapvpwrvgnd_1
* cell instance $2333 r0 *1 74.52,32.64
X$2333 VPWR VGND sky130_fd_sc_hd__tapvpwrvgnd_1
* cell instance $2334 r0 *1 126.04,10.88
X$2334 VPWR VGND sky130_fd_sc_hd__tapvpwrvgnd_1
* cell instance $2335 r0 *1 177.56,217.6
X$2335 VPWR VGND sky130_fd_sc_hd__tapvpwrvgnd_1
* cell instance $2336 r0 *1 126.04,16.32
X$2336 VPWR VGND sky130_fd_sc_hd__tapvpwrvgnd_1
* cell instance $2337 r0 *1 126.04,21.76
X$2337 VPWR VGND sky130_fd_sc_hd__tapvpwrvgnd_1
* cell instance $2338 r0 *1 48.76,136
X$2338 VPWR VGND sky130_fd_sc_hd__tapvpwrvgnd_1
* cell instance $2339 r0 *1 48.76,125.12
X$2339 VPWR VGND sky130_fd_sc_hd__tapvpwrvgnd_1
* cell instance $2340 r0 *1 48.76,130.56
X$2340 VPWR VGND sky130_fd_sc_hd__tapvpwrvgnd_1
* cell instance $2341 r0 *1 48.76,119.68
X$2341 VPWR VGND sky130_fd_sc_hd__tapvpwrvgnd_1
* cell instance $2342 r0 *1 126.04,27.2
X$2342 VPWR VGND sky130_fd_sc_hd__tapvpwrvgnd_1
* cell instance $2343 r0 *1 113.16,10.88
X$2343 VPWR VGND sky130_fd_sc_hd__tapvpwrvgnd_1
* cell instance $2344 r0 *1 138.92,10.88
X$2344 VPWR VGND sky130_fd_sc_hd__tapvpwrvgnd_1
* cell instance $2345 r0 *1 74.52,157.76
X$2345 VPWR VGND sky130_fd_sc_hd__tapvpwrvgnd_1
* cell instance $2346 r0 *1 126.04,43.52
X$2346 VPWR VGND sky130_fd_sc_hd__tapvpwrvgnd_1
* cell instance $2347 r0 *1 48.76,108.8
X$2347 VPWR VGND sky130_fd_sc_hd__tapvpwrvgnd_1
* cell instance $2348 r0 *1 126.04,48.96
X$2348 VPWR VGND sky130_fd_sc_hd__tapvpwrvgnd_1
* cell instance $2349 r0 *1 126.04,59.84
X$2349 VPWR VGND sky130_fd_sc_hd__tapvpwrvgnd_1
* cell instance $2350 r0 *1 126.04,65.28
X$2350 VPWR VGND sky130_fd_sc_hd__tapvpwrvgnd_1
* cell instance $2351 r0 *1 126.04,54.4
X$2351 VPWR VGND sky130_fd_sc_hd__tapvpwrvgnd_1
* cell instance $2352 r0 *1 126.04,70.72
X$2352 VPWR VGND sky130_fd_sc_hd__tapvpwrvgnd_1
* cell instance $2353 r0 *1 151.8,195.84
X$2353 VPWR VGND sky130_fd_sc_hd__tapvpwrvgnd_1
* cell instance $2354 r0 *1 151.8,228.48
X$2354 VPWR VGND sky130_fd_sc_hd__tapvpwrvgnd_1
* cell instance $2355 r0 *1 151.8,239.36
X$2355 VPWR VGND sky130_fd_sc_hd__tapvpwrvgnd_1
* cell instance $2356 r0 *1 151.8,233.92
X$2356 VPWR VGND sky130_fd_sc_hd__tapvpwrvgnd_1
* cell instance $2357 r0 *1 151.8,206.72
X$2357 VPWR VGND sky130_fd_sc_hd__tapvpwrvgnd_1
* cell instance $2358 r0 *1 151.8,217.6
X$2358 VPWR VGND sky130_fd_sc_hd__tapvpwrvgnd_1
* cell instance $2359 r0 *1 151.8,212.16
X$2359 VPWR VGND sky130_fd_sc_hd__tapvpwrvgnd_1
* cell instance $2360 r0 *1 48.76,114.24
X$2360 VPWR VGND sky130_fd_sc_hd__tapvpwrvgnd_1
* cell instance $2361 r0 *1 48.76,97.92
X$2361 VPWR VGND sky130_fd_sc_hd__tapvpwrvgnd_1
* cell instance $2362 r0 *1 48.76,103.36
X$2362 VPWR VGND sky130_fd_sc_hd__tapvpwrvgnd_1
* cell instance $2363 r0 *1 126.04,38.08
X$2363 VPWR VGND sky130_fd_sc_hd__tapvpwrvgnd_1
* cell instance $2364 r0 *1 23,217.6
X$2364 VPWR VGND sky130_fd_sc_hd__tapvpwrvgnd_1
* cell instance $2365 r0 *1 23,228.48
X$2365 VPWR VGND sky130_fd_sc_hd__tapvpwrvgnd_1
* cell instance $2366 r0 *1 74.52,27.2
X$2366 VPWR VGND sky130_fd_sc_hd__tapvpwrvgnd_1
* cell instance $2367 r0 *1 177.56,250.24
X$2367 VPWR VGND sky130_fd_sc_hd__tapvpwrvgnd_1
* cell instance $2368 r0 *1 74.52,10.88
X$2368 VPWR VGND sky130_fd_sc_hd__tapvpwrvgnd_1
* cell instance $2369 r0 *1 74.52,16.32
X$2369 VPWR VGND sky130_fd_sc_hd__tapvpwrvgnd_1
* cell instance $2370 r0 *1 23,212.16
X$2370 VPWR VGND sky130_fd_sc_hd__tapvpwrvgnd_1
* cell instance $2371 r0 *1 23,239.36
X$2371 VPWR VGND sky130_fd_sc_hd__tapvpwrvgnd_1
* cell instance $2372 r0 *1 48.76,239.36
X$2372 VPWR VGND sky130_fd_sc_hd__tapvpwrvgnd_1
* cell instance $2373 r0 *1 126.04,87.04
X$2373 VPWR VGND sky130_fd_sc_hd__tapvpwrvgnd_1
* cell instance $2374 r0 *1 48.76,233.92
X$2374 VPWR VGND sky130_fd_sc_hd__tapvpwrvgnd_1
* cell instance $2375 r0 *1 48.76,223.04
X$2375 VPWR VGND sky130_fd_sc_hd__tapvpwrvgnd_1
* cell instance $2376 r0 *1 48.76,217.6
X$2376 VPWR VGND sky130_fd_sc_hd__tapvpwrvgnd_1
* cell instance $2377 r0 *1 48.76,212.16
X$2377 VPWR VGND sky130_fd_sc_hd__tapvpwrvgnd_1
* cell instance $2378 r0 *1 151.8,255.68
X$2378 VPWR VGND sky130_fd_sc_hd__tapvpwrvgnd_1
* cell instance $2379 r0 *1 177.56,255.68
X$2379 VPWR VGND sky130_fd_sc_hd__tapvpwrvgnd_1
* cell instance $2380 r0 *1 74.52,114.24
X$2380 VPWR VGND sky130_fd_sc_hd__tapvpwrvgnd_1
* cell instance $2381 r0 *1 126.04,130.56
X$2381 VPWR VGND sky130_fd_sc_hd__tapvpwrvgnd_1
* cell instance $2382 r0 *1 126.04,212.16
X$2382 VPWR VGND sky130_fd_sc_hd__tapvpwrvgnd_1
* cell instance $2383 r0 *1 126.04,81.6
X$2383 VPWR VGND sky130_fd_sc_hd__tapvpwrvgnd_1
* cell instance $2384 r0 *1 126.04,217.6
X$2384 VPWR VGND sky130_fd_sc_hd__tapvpwrvgnd_1
* cell instance $2385 r0 *1 126.04,92.48
X$2385 VPWR VGND sky130_fd_sc_hd__tapvpwrvgnd_1
* cell instance $2386 r0 *1 48.76,228.48
X$2386 VPWR VGND sky130_fd_sc_hd__tapvpwrvgnd_1
* cell instance $2387 r0 *1 177.56,261.12
X$2387 VPWR VGND sky130_fd_sc_hd__tapvpwrvgnd_1
* cell instance $2388 r0 *1 126.04,228.48
X$2388 VPWR VGND sky130_fd_sc_hd__tapvpwrvgnd_1
* cell instance $2389 r0 *1 126.04,119.68
X$2389 VPWR VGND sky130_fd_sc_hd__tapvpwrvgnd_1
* cell instance $2390 r0 *1 151.8,10.88
X$2390 VPWR VGND sky130_fd_sc_hd__tapvpwrvgnd_1
* cell instance $2391 r0 *1 126.04,206.72
X$2391 VPWR VGND sky130_fd_sc_hd__tapvpwrvgnd_1
* cell instance $2392 r0 *1 23,157.76
X$2392 VPWR VGND sky130_fd_sc_hd__tapvpwrvgnd_1
* cell instance $2393 r0 *1 48.76,206.72
X$2393 VPWR VGND sky130_fd_sc_hd__tapvpwrvgnd_1
* cell instance $2394 r0 *1 48.76,266.56
X$2394 VPWR VGND sky130_fd_sc_hd__tapvpwrvgnd_1
* cell instance $2395 r0 *1 23,261.12
X$2395 VPWR VGND sky130_fd_sc_hd__tapvpwrvgnd_1
* cell instance $2396 r0 *1 177.56,282.88
X$2396 VPWR VGND sky130_fd_sc_hd__tapvpwrvgnd_1
* cell instance $2397 r0 *1 23,266.56
X$2397 VPWR VGND sky130_fd_sc_hd__tapvpwrvgnd_1
* cell instance $2398 r0 *1 126.04,223.04
X$2398 VPWR VGND sky130_fd_sc_hd__tapvpwrvgnd_1
* cell instance $2399 r0 *1 151.8,136
X$2399 VPWR VGND sky130_fd_sc_hd__tapvpwrvgnd_1
* cell instance $2400 r0 *1 151.8,125.12
X$2400 VPWR VGND sky130_fd_sc_hd__tapvpwrvgnd_1
* cell instance $2401 r0 *1 151.8,130.56
X$2401 VPWR VGND sky130_fd_sc_hd__tapvpwrvgnd_1
* cell instance $2402 r0 *1 151.8,119.68
X$2402 VPWR VGND sky130_fd_sc_hd__tapvpwrvgnd_1
* cell instance $2403 r0 *1 151.8,152.32
X$2403 VPWR VGND sky130_fd_sc_hd__tapvpwrvgnd_1
* cell instance $2404 r0 *1 151.8,141.44
X$2404 VPWR VGND sky130_fd_sc_hd__tapvpwrvgnd_1
* cell instance $2405 r0 *1 151.8,146.88
X$2405 VPWR VGND sky130_fd_sc_hd__tapvpwrvgnd_1
* cell instance $2406 r0 *1 177.56,272
X$2406 VPWR VGND sky130_fd_sc_hd__tapvpwrvgnd_1
* cell instance $2407 r0 *1 177.56,32.64
X$2407 VPWR VGND sky130_fd_sc_hd__tapvpwrvgnd_1
* cell instance $2408 m90 *1 182.62,32.64
X$2408 VGND \$501 \$227 \$572 \$15 \$35 VPWR VPWR VGND sky130_fd_sc_hd__o22ai_2
* cell instance $2409 r0 *1 177.56,190.4
X$2409 VPWR VGND sky130_fd_sc_hd__tapvpwrvgnd_1
* cell instance $2410 r0 *1 23,282.88
X$2410 VPWR VGND sky130_fd_sc_hd__tapvpwrvgnd_1
* cell instance $2411 r0 *1 126.04,103.36
X$2411 VPWR VGND sky130_fd_sc_hd__tapvpwrvgnd_1
* cell instance $2412 r0 *1 23,255.68
X$2412 VPWR VGND sky130_fd_sc_hd__tapvpwrvgnd_1
* cell instance $2413 r0 *1 126.04,97.92
X$2413 VPWR VGND sky130_fd_sc_hd__tapvpwrvgnd_1
* cell instance $2414 r0 *1 126.04,255.68
X$2414 VPWR VGND sky130_fd_sc_hd__tapvpwrvgnd_1
* cell instance $2415 r0 *1 151.8,32.64
X$2415 VPWR VGND sky130_fd_sc_hd__tapvpwrvgnd_1
* cell instance $2416 r0 *1 126.04,233.92
X$2416 VPWR VGND sky130_fd_sc_hd__tapvpwrvgnd_1
* cell instance $2417 r0 *1 61.64,10.88
X$2417 VPWR VGND sky130_fd_sc_hd__tapvpwrvgnd_1
* cell instance $2418 r0 *1 177.56,277.44
X$2418 VPWR VGND sky130_fd_sc_hd__tapvpwrvgnd_1
* cell instance $2419 r0 *1 23,272
X$2419 VPWR VGND sky130_fd_sc_hd__tapvpwrvgnd_1
* cell instance $2420 r0 *1 23,250.24
X$2420 VPWR VGND sky130_fd_sc_hd__tapvpwrvgnd_1
* cell instance $2421 r0 *1 74.52,21.76
X$2421 VPWR VGND sky130_fd_sc_hd__tapvpwrvgnd_1
* cell instance $2422 r0 *1 23,233.92
X$2422 VPWR VGND sky130_fd_sc_hd__tapvpwrvgnd_1
* cell instance $2423 r0 *1 23,223.04
X$2423 VPWR VGND sky130_fd_sc_hd__tapvpwrvgnd_1
* cell instance $2424 r0 *1 23,206.72
X$2424 VPWR VGND sky130_fd_sc_hd__tapvpwrvgnd_1
* cell instance $2425 r0 *1 23,277.44
X$2425 VPWR VGND sky130_fd_sc_hd__tapvpwrvgnd_1
* cell instance $2426 r0 *1 23,195.84
X$2426 VPWR VGND sky130_fd_sc_hd__tapvpwrvgnd_1
* cell instance $2427 r0 *1 23,168.64
X$2427 VPWR VGND sky130_fd_sc_hd__tapvpwrvgnd_1
* cell instance $2428 r0 *1 23,179.52
X$2428 VPWR VGND sky130_fd_sc_hd__tapvpwrvgnd_1
* cell instance $2429 r0 *1 151.8,97.92
X$2429 VPWR VGND sky130_fd_sc_hd__tapvpwrvgnd_1
* cell instance $2430 r0 *1 48.76,48.96
X$2430 VPWR VGND sky130_fd_sc_hd__tapvpwrvgnd_1
* cell instance $2431 r0 *1 151.8,114.24
X$2431 VPWR VGND sky130_fd_sc_hd__tapvpwrvgnd_1
* cell instance $2432 r0 *1 48.76,43.52
X$2432 VPWR VGND sky130_fd_sc_hd__tapvpwrvgnd_1
* cell instance $2433 r0 *1 151.8,103.36
X$2433 VPWR VGND sky130_fd_sc_hd__tapvpwrvgnd_1
* cell instance $2434 r0 *1 23,184.96
X$2434 VPWR VGND sky130_fd_sc_hd__tapvpwrvgnd_1
* cell instance $2435 r0 *1 151.8,76.16
X$2435 VPWR VGND sky130_fd_sc_hd__tapvpwrvgnd_1
* cell instance $2436 r0 *1 74.52,92.48
X$2436 VPWR VGND sky130_fd_sc_hd__tapvpwrvgnd_1
* cell instance $2437 r0 *1 48.76,38.08
X$2437 VPWR VGND sky130_fd_sc_hd__tapvpwrvgnd_1
* cell instance $2438 r0 *1 151.8,92.48
X$2438 VPWR VGND sky130_fd_sc_hd__tapvpwrvgnd_1
* cell instance $2439 r0 *1 151.8,87.04
X$2439 VPWR VGND sky130_fd_sc_hd__tapvpwrvgnd_1
* cell instance $2440 r0 *1 48.76,157.76
X$2440 VPWR VGND sky130_fd_sc_hd__tapvpwrvgnd_1
* cell instance $2441 r0 *1 151.8,81.6
X$2441 VPWR VGND sky130_fd_sc_hd__tapvpwrvgnd_1
* cell instance $2442 r0 *1 23,119.68
X$2442 VPWR VGND sky130_fd_sc_hd__tapvpwrvgnd_1
* cell instance $2443 r0 *1 126.04,190.4
X$2443 VPWR VGND sky130_fd_sc_hd__tapvpwrvgnd_1
* cell instance $2444 r0 *1 48.76,59.84
X$2444 VPWR VGND sky130_fd_sc_hd__tapvpwrvgnd_1
* cell instance $2445 r0 *1 48.76,65.28
X$2445 VPWR VGND sky130_fd_sc_hd__tapvpwrvgnd_1
* cell instance $2446 r0 *1 23,146.88
X$2446 VPWR VGND sky130_fd_sc_hd__tapvpwrvgnd_1
* cell instance $2447 r0 *1 23,130.56
X$2447 VPWR VGND sky130_fd_sc_hd__tapvpwrvgnd_1
* cell instance $2448 r0 *1 23,152.32
X$2448 VPWR VGND sky130_fd_sc_hd__tapvpwrvgnd_1
* cell instance $2449 r0 *1 126.04,195.84
X$2449 VPWR VGND sky130_fd_sc_hd__tapvpwrvgnd_1
* cell instance $2450 r0 *1 151.8,272
X$2450 VPWR VGND sky130_fd_sc_hd__tapvpwrvgnd_1
* cell instance $2451 r0 *1 151.8,282.88
X$2451 VPWR VGND sky130_fd_sc_hd__tapvpwrvgnd_1
* cell instance $2452 r0 *1 151.8,277.44
X$2452 VPWR VGND sky130_fd_sc_hd__tapvpwrvgnd_1
* cell instance $2453 r0 *1 126.04,184.96
X$2453 VPWR VGND sky130_fd_sc_hd__tapvpwrvgnd_1
* cell instance $2454 r0 *1 126.04,244.8
X$2454 VPWR VGND sky130_fd_sc_hd__tapvpwrvgnd_1
* cell instance $2455 r0 *1 126.04,141.44
X$2455 VPWR VGND sky130_fd_sc_hd__tapvpwrvgnd_1
* cell instance $2456 r0 *1 74.52,87.04
X$2456 VPWR VGND sky130_fd_sc_hd__tapvpwrvgnd_1
* cell instance $2457 r0 *1 87.4,10.88
X$2457 VPWR VGND sky130_fd_sc_hd__tapvpwrvgnd_1
* cell instance $2458 r0 *1 48.76,174.08
X$2458 VPWR VGND sky130_fd_sc_hd__tapvpwrvgnd_1
* cell instance $2459 r0 *1 35.88,10.88
X$2459 VPWR VGND sky130_fd_sc_hd__tapvpwrvgnd_1
* cell instance $2460 r0 *1 126.04,157.76
X$2460 VPWR VGND sky130_fd_sc_hd__tapvpwrvgnd_1
* cell instance $2461 r0 *1 48.76,10.88
X$2461 VPWR VGND sky130_fd_sc_hd__tapvpwrvgnd_1
* cell instance $2462 r0 *1 151.8,266.56
X$2462 VPWR VGND sky130_fd_sc_hd__tapvpwrvgnd_1
* cell instance $2463 r0 *1 126.04,114.24
X$2463 VPWR VGND sky130_fd_sc_hd__tapvpwrvgnd_1
* cell instance $2464 r0 *1 48.76,163.2
X$2464 VPWR VGND sky130_fd_sc_hd__tapvpwrvgnd_1
* cell instance $2465 r0 *1 23,16.32
X$2465 VPWR VGND sky130_fd_sc_hd__tapvpwrvgnd_1
* cell instance $2466 r0 *1 48.76,179.52
X$2466 VPWR VGND sky130_fd_sc_hd__tapvpwrvgnd_1
* cell instance $2467 r0 *1 126.04,125.12
X$2467 VPWR VGND sky130_fd_sc_hd__tapvpwrvgnd_1
* cell instance $2468 r0 *1 48.76,168.64
X$2468 VPWR VGND sky130_fd_sc_hd__tapvpwrvgnd_1
* cell instance $2469 r0 *1 126.04,163.2
X$2469 VPWR VGND sky130_fd_sc_hd__tapvpwrvgnd_1
* cell instance $2470 r0 *1 23,10.88
X$2470 VPWR VGND sky130_fd_sc_hd__tapvpwrvgnd_1
* cell instance $2471 r0 *1 23,21.76
X$2471 VPWR VGND sky130_fd_sc_hd__tapvpwrvgnd_1
* cell instance $2472 r0 *1 23,163.2
X$2472 VPWR VGND sky130_fd_sc_hd__tapvpwrvgnd_1
* cell instance $2473 r0 *1 48.76,190.4
X$2473 VPWR VGND sky130_fd_sc_hd__tapvpwrvgnd_1
* cell instance $2474 r0 *1 48.76,21.76
X$2474 VPWR VGND sky130_fd_sc_hd__tapvpwrvgnd_1
* cell instance $2475 r0 *1 48.76,184.96
X$2475 VPWR VGND sky130_fd_sc_hd__tapvpwrvgnd_1
* cell instance $2476 r0 *1 48.76,195.84
X$2476 VPWR VGND sky130_fd_sc_hd__tapvpwrvgnd_1
* cell instance $2477 r0 *1 48.76,27.2
X$2477 VPWR VGND sky130_fd_sc_hd__tapvpwrvgnd_1
* cell instance $2478 r0 *1 48.76,16.32
X$2478 VPWR VGND sky130_fd_sc_hd__tapvpwrvgnd_1
* cell instance $2479 r0 *1 126.04,179.52
X$2479 VPWR VGND sky130_fd_sc_hd__tapvpwrvgnd_1
* cell instance $2480 r0 *1 126.04,168.64
X$2480 VPWR VGND sky130_fd_sc_hd__tapvpwrvgnd_1
* cell instance $2481 r0 *1 23,190.4
X$2481 VPWR VGND sky130_fd_sc_hd__tapvpwrvgnd_1
* cell instance $2482 r0 *1 23,174.08
X$2482 VPWR VGND sky130_fd_sc_hd__tapvpwrvgnd_1
* cell instance $2483 r0 *1 126.04,174.08
X$2483 VPWR VGND sky130_fd_sc_hd__tapvpwrvgnd_1
* cell instance $2484 r0 *1 48.76,70.72
X$2484 VPWR VGND sky130_fd_sc_hd__tapvpwrvgnd_1
* cell instance $2485 r0 *1 74.52,108.8
X$2485 VPWR VGND sky130_fd_sc_hd__tapvpwrvgnd_1
* cell instance $2486 r0 *1 48.76,54.4
X$2486 VPWR VGND sky130_fd_sc_hd__tapvpwrvgnd_1
* cell instance $2487 r0 *1 151.8,108.8
X$2487 VPWR VGND sky130_fd_sc_hd__tapvpwrvgnd_1
* cell instance $2488 r0 *1 23,27.2
X$2488 VPWR VGND sky130_fd_sc_hd__tapvpwrvgnd_1
* cell instance $2489 m90 *1 166.06,48.96
X$2489 VPWR VPWR \$986 \$861 VGND \$864 VGND sky130_fd_sc_hd__nand2_2
* cell instance $2490 m90 *1 155.48,32.64
X$2490 VPWR VPWR \$556 \$486 VGND \$418 VGND sky130_fd_sc_hd__nand2_2
* cell instance $2491 m90 *1 40.94,97.92
X$2491 VPWR VPWR \$1566 select VGND \$1558 VGND sky130_fd_sc_hd__nand2_2
* cell instance $2492 m90 *1 155.48,21.76
X$2492 VPWR VPWR \$105 \$56 VGND \$98 VGND sky130_fd_sc_hd__nand2_2
* cell instance $2493 m90 *1 154.56,27.2
X$2493 VPWR VPWR \$89 \$29 VGND \$98 VGND sky130_fd_sc_hd__nand2_2
* cell instance $2494 m90 *1 126.04,130.56
X$2494 VPWR VPWR \$2079 select VGND I VGND sky130_fd_sc_hd__nand2_2
* cell instance $2495 m90 *1 118.68,266.56
X$2495 VPWR VPWR \$4180 select VGND I VGND sky130_fd_sc_hd__nand2_2
* cell instance $2496 m90 *1 164.22,168.64
X$2496 VPWR VPWR \$2705 \$2634 VGND \$1362 VGND sky130_fd_sc_hd__nand2_2
* cell instance $2497 m90 *1 177.1,97.92
X$2497 \$I1121 VPWR \$1592 \$1527 VGND \$1362 VGND sky130_fd_sc_hd__nand2_2
* cell instance $2498 m90 *1 155.02,190.4
X$2498 VPWR VPWR \$2917 \$2796 VGND \$2914 VGND sky130_fd_sc_hd__nand2_2
* cell instance $2499 m90 *1 166.52,201.28
X$2499 VPWR VPWR \$2878 \$2910 VGND \$2760 VGND sky130_fd_sc_hd__nand2_2
* cell instance $2500 m90 *1 126.04,233.92
X$2500 VPWR VPWR \$3772 select VGND I VGND sky130_fd_sc_hd__nand2_2
* cell instance $2501 m0 *1 152.26,38.08
X$2501 VPWR VPWR \$654 \$417 VGND \$416 VGND sky130_fd_sc_hd__nand2_2
* cell instance $2502 m0 *1 184.46,27.2
X$2502 VPWR VPWR \$368 \$313 VGND \$49 VGND sky130_fd_sc_hd__nand2_2
* cell instance $2503 m0 *1 155.02,27.2
X$2503 VPWR VPWR \$92 \$347 VGND \$340 VGND sky130_fd_sc_hd__nand2_2
* cell instance $2504 m0 *1 162.38,16.32
X$2504 VPWR VPWR \$81 \$97 VGND \$98 VGND sky130_fd_sc_hd__nand2_2
* cell instance $2505 m0 *1 110.86,92.48
X$2505 VPWR VPWR \$1403 select VGND I VGND sky130_fd_sc_hd__nand2_2
* cell instance $2506 m0 *1 153.18,184.96
X$2506 VPWR VPWR \$2714 \$1527 VGND \$1363 VGND sky130_fd_sc_hd__nand2_2
* cell instance $2507 m0 *1 177.1,136
X$2507 VPWR VPWR \$2100 \$2043 VGND \$1413 VGND sky130_fd_sc_hd__nand2_2
* cell instance $2508 m0 *1 167.44,168.64
X$2508 \$I11849 VPWR \$2563 \$1363 VGND \$1413 VGND sky130_fd_sc_hd__nand2_2
* cell instance $2509 m0 *1 160.08,16.32
X$2509 VPWR VPWR \$288 \$92 VGND \$139 VGND sky130_fd_sc_hd__nand2_2
* cell instance $2510 m0 *1 153.18,32.64
X$2510 VPWR VPWR \$664 \$417 VGND \$347 VGND sky130_fd_sc_hd__nand2_2
* cell instance $2511 r180 *1 119.6,201.28
X$2511 VPWR VPWR \$3157 select VGND I VGND sky130_fd_sc_hd__nand2_2
* cell instance $2512 r180 *1 113.16,70.72
X$2512 VPWR VPWR \$1275 select VGND I VGND sky130_fd_sc_hd__nand2_2
* cell instance $2513 r180 *1 157.78,16.32
X$2513 VPWR VPWR \$15 \$14 VGND \$46 VGND sky130_fd_sc_hd__nand2_2
* cell instance $2514 r180 *1 126.04,217.6
X$2514 VPWR VPWR \$3369 select VGND I VGND sky130_fd_sc_hd__nand2_2
* cell instance $2515 r180 *1 69.46,48.96
X$2515 VPWR VPWR \$781 \$969 VGND \$836 VGND sky130_fd_sc_hd__nand2_2
* cell instance $2516 r180 *1 167.44,54.4
X$2516 VPWR VPWR \$490 \$521 VGND \$668 VGND sky130_fd_sc_hd__nand2_2
* cell instance $2517 r180 *1 170.2,97.92
X$2517 VPWR VPWR \$1663 \$1363 VGND \$1413 VGND sky130_fd_sc_hd__nand2_2
* cell instance $2518 r180 *1 155.48,16.32
X$2518 VPWR VPWR \$23 \$46 VGND \$126 VGND sky130_fd_sc_hd__nand2_2
* cell instance $2519 r0 *1 169.74,163.2
X$2519 \$I11849 VPWR \$2564 \$2625 VGND \$2599 VGND sky130_fd_sc_hd__nand2_2
* cell instance $2520 r0 *1 112.7,59.84
X$2520 VPWR VPWR \$1202 select VGND I VGND sky130_fd_sc_hd__nand2_2
* cell instance $2521 r0 *1 156.86,27.2
X$2521 VPWR VPWR \$476 \$416 VGND \$347 VGND sky130_fd_sc_hd__nand2_2
* cell instance $2522 r0 *1 154.56,27.2
X$2522 VPWR VPWR \$413 \$57 VGND \$49 VGND sky130_fd_sc_hd__nand2_2
* cell instance $2523 r0 *1 185.84,27.2
X$2523 VPWR VPWR \$439 \$430 VGND \$49 VGND sky130_fd_sc_hd__nand2_2
* cell instance $2524 r0 *1 181.24,10.88
X$2524 VPWR VPWR \$57 \$15 VGND \$35 VGND sky130_fd_sc_hd__nand2_2
* cell instance $2525 r0 *1 74.98,38.08
X$2525 VPWR VPWR \$831 \$782 VGND \$609 VGND sky130_fd_sc_hd__nand2_2
* cell instance $2526 r0 *1 76.36,108.8
X$2526 \$I280 VPWR \$1650 I VGND \$1729 VGND sky130_fd_sc_hd__nand2_2
* cell instance $2527 m90 *1 162.38,10.88
X$2527 VPWR VGND \$46 \$181 \$14 VPWR VGND sky130_fd_sc_hd__nor2_2
* cell instance $2528 r0 *1 157.78,10.88
X$2528 VPWR \$17 VPWR VGND \$14 \$94 VGND sky130_fd_sc_hd__or2_2
* cell instance $2529 m90 *1 164.68,10.88
X$2529 VPWR VPWR \$28 \$79 VGND \$27 VGND sky130_fd_sc_hd__nand2_2
* cell instance $2530 m90 *1 185.84,10.88
X$2530 VPWR \$16 VPWR VGND \$61 \$35 VGND sky130_fd_sc_hd__or2_2
* cell instance $2531 m90 *1 151.8,184.96
X$2531 VPWR \$2822 VPWR VGND \$2910 \$2760 VGND sky130_fd_sc_hd__or2_2
* cell instance $2532 m0 *1 183.08,48.96
X$2532 VPWR \$846 VPWR VGND \$392 \$572 VGND sky130_fd_sc_hd__or2_2
* cell instance $2533 m0 *1 80.96,114.24
X$2533 VPWR \$1783 VPWR VGND I \$1729 VGND sky130_fd_sc_hd__or2_2
* cell instance $2534 m0 *1 166.52,282.88
X$2534 VPWR \$4316 VPWR VGND \$3846 \$3143 VGND sky130_fd_sc_hd__or2_2
* cell instance $2535 r180 *1 167.9,206.72
X$2535 VPWR \$2922 VPWR VGND select \$3058 VGND sky130_fd_sc_hd__or2_2
* cell instance $2536 r180 *1 158.7,21.76
X$2536 VPWR \$126 VPWR VGND \$247 \$348 VGND sky130_fd_sc_hd__or2_2
* cell instance $2537 r180 *1 186.3,16.32
X$2537 VPWR \$54 VPWR VGND \$14 \$35 VGND sky130_fd_sc_hd__or2_2
* cell instance $2538 r0 *1 164.22,168.64
X$2538 VPWR \$2599 VPWR VGND \$1362 \$1363 VGND sky130_fd_sc_hd__or2_2
* cell instance $2539 r0 *1 154.56,16.32
X$2539 VPWR \$61 VPWR VGND \$29 \$94 VGND sky130_fd_sc_hd__or2_2
* cell instance $2540 r0 *1 166.52,136
X$2540 \$I13343 \$2043 VPWR VGND \$1527 \$1362 VGND sky130_fd_sc_hd__or2_2
* cell instance $2541 r0 *1 186.3,38.08
X$2541 VPWR \$631 VPWR VGND \$311 \$115 VGND sky130_fd_sc_hd__or2_2
* cell instance $2542 m90 *1 154.56,38.08
X$2542 VPWR VGND \$664 \$606 \$665 VPWR VGND sky130_fd_sc_hd__nor2_2
* cell instance $2543 m90 *1 151.8,21.76
X$2543 VPWR VGND \$181 \$389 \$57 VPWR VGND sky130_fd_sc_hd__nor2_2
* cell instance $2544 m90 *1 123.74,233.92
X$2544 VPWR VGND \$3728 \$3661 \$3772 VPWR VGND sky130_fd_sc_hd__nor2_2
* cell instance $2545 m90 *1 115.92,87.04
X$2545 VPWR VGND \$1404 \$1517 \$1403 VPWR VGND sky130_fd_sc_hd__nor2_2
* cell instance $2546 m0 *1 155.48,32.64
X$2546 VPWR VGND \$416 \$874 \$556 VPWR VGND sky130_fd_sc_hd__nor2_2
* cell instance $2547 m0 *1 157.78,32.64
X$2547 VPWR VPWR VGND \$423 \$489 \$291 \$490 VGND sky130_fd_sc_hd__a21o_2
* cell instance $2548 m0 *1 25.76,157.76
X$2548 VPWR VGND \$1558 \$2491 \$2441 VPWR VGND sky130_fd_sc_hd__nor2_2
* cell instance $2549 m0 *1 159.16,174.08
X$2549 VPWR VGND \$1413 \$2657 \$2656 VPWR VGND sky130_fd_sc_hd__nor2_2
* cell instance $2550 m0 *1 186.3,16.32
X$2550 VPWR VGND \$31 \$115 \$61 VPWR VGND sky130_fd_sc_hd__nor2_2
* cell instance $2551 m0 *1 150.42,27.2
X$2551 VPWR VGND \$105 \$345 \$31 VPWR VGND sky130_fd_sc_hd__nor2_2
* cell instance $2552 m0 *1 172.04,103.36
X$2552 \$I1121 VGND \$1527 \$1757 \$1663 VPWR VGND sky130_fd_sc_hd__nor2_2
* cell instance $2553 m0 *1 167.44,54.4
X$2553 VPWR VGND \$1008 \$563 \$1058 VPWR VGND sky130_fd_sc_hd__nor2_2
* cell instance $2554 m0 *1 150.88,32.64
X$2554 VPWR VGND \$31 \$392 \$89 VPWR VGND sky130_fd_sc_hd__nor2_2
* cell instance $2555 m0 *1 169.74,157.76
X$2555 VPWR VGND \$1413 \$2497 \$1363 VPWR VGND sky130_fd_sc_hd__nor2_2
* cell instance $2556 m0 *1 157.78,16.32
X$2556 VPWR VGND \$47 \$14 \$29 VPWR VGND sky130_fd_sc_hd__nor2_2
* cell instance $2557 r180 *1 187.68,21.76
X$2557 VPWR VGND \$35 \$30 \$181 VPWR VGND sky130_fd_sc_hd__nor2_2
* cell instance $2558 r180 *1 113.16,201.28
X$2558 VPWR VGND \$3158 \$3156 \$3157 VPWR VGND sky130_fd_sc_hd__nor2_2
* cell instance $2559 r180 *1 161.92,27.2
X$2559 VPWR VGND \$416 \$351 \$417 VPWR VGND sky130_fd_sc_hd__nor2_2
* cell instance $2560 r180 *1 158.24,43.52
X$2560 VPWR VGND \$668 \$489 \$521 VPWR VGND sky130_fd_sc_hd__nor2_2
* cell instance $2561 r180 *1 153.18,184.96
X$2561 VPWR VGND \$1362 \$3054 \$1527 VPWR VGND sky130_fd_sc_hd__nor2_2
* cell instance $2562 r180 *1 157.32,195.84
X$2562 VPWR VGND \$3058 \$2766 select VPWR VGND sky130_fd_sc_hd__nor2_2
* cell instance $2563 r180 *1 176.64,108.8
X$2563 \$I12478 VGND \$1363 \$1823 \$1527 VPWR VGND sky130_fd_sc_hd__nor2_2
* cell instance $2564 r180 *1 155.02,27.2
X$2564 VPWR VGND \$348 \$47 \$247 VPWR VGND sky130_fd_sc_hd__nor2_2
* cell instance $2565 r180 *1 159.62,27.2
X$2565 VPWR VGND \$340 \$247 \$347 VPWR VGND sky130_fd_sc_hd__nor2_2
* cell instance $2566 r180 *1 179.4,206.72
X$2566 VPWR VGND \$2681 \$3070 \$3319 VPWR VGND sky130_fd_sc_hd__nor2_2
* cell instance $2567 r180 *1 115.92,212.16
X$2567 VPWR VGND \$3276 \$3269 \$3369 VPWR VGND sky130_fd_sc_hd__nor2_2
* cell instance $2568 r180 *1 156.4,21.76
X$2568 VPWR VGND \$139 \$56 \$126 VPWR VGND sky130_fd_sc_hd__nor2_2
* cell instance $2569 r180 *1 153.18,190.4
X$2569 VPWR VGND \$1413 \$2601 \$1363 VPWR VGND sky130_fd_sc_hd__nor2_2
* cell instance $2570 r0 *1 114.08,266.56
X$2570 VPWR VGND \$4142 \$4172 \$4180 VPWR VGND sky130_fd_sc_hd__nor2_2
* cell instance $2571 r0 *1 166.52,168.64
X$2571 VPWR VGND \$1362 \$2700 \$2619 VPWR VGND sky130_fd_sc_hd__nor2_2
* cell instance $2572 r0 *1 168.82,54.4
X$2572 \$I13345 VGND \$1186 \$797 \$421 VPWR VGND sky130_fd_sc_hd__nor2_2
* cell instance $2573 r0 *1 29.9,92.48
X$2573 VPWR VGND \$347 \$1507 \$1532 VPWR VGND sky130_fd_sc_hd__nor2_2
* cell instance $2574 r0 *1 165.6,130.56
X$2574 VPWR VGND \$1527 \$2033 \$2029 VPWR VGND sky130_fd_sc_hd__nor2_2
* cell instance $2575 r0 *1 152.26,16.32
X$2575 VPWR VGND \$31 \$179 \$181 VPWR VGND sky130_fd_sc_hd__nor2_2
* cell instance $2576 r0 *1 165.6,92.48
X$2576 VPWR VGND \$1413 \$1468 \$1363 VPWR VGND sky130_fd_sc_hd__nor2_2
* cell instance $2577 r0 *1 162.84,212.16
X$2577 VPWR VGND \$3288 \$3456 \$3305 VPWR VGND sky130_fd_sc_hd__nor2_2
* cell instance $2578 r0 *1 159.16,16.32
X$2578 VPWR VGND \$46 \$151 \$97 VPWR VGND sky130_fd_sc_hd__nor2_2
* cell instance $2579 r180 *1 164.68,21.76
X$2579 VPWR VGND \$306 \$147 \$49 VPWR \$205 \$209 VGND sky130_fd_sc_hd__or4_2
* cell instance $2580 r0 *1 155.48,21.76
X$2580 VPWR VGND \$247 \$97 \$288 VPWR VGND sky130_fd_sc_hd__nor2_2
* cell instance $2581 r0 *1 123.74,136
X$2581 VPWR VGND \$2068 \$2072 \$2079 VPWR VGND sky130_fd_sc_hd__nor2_2
* cell instance $2582 r0 *1 74.98,48.96
X$2582 VPWR VGND \$836 \$1026 \$1082 VPWR VGND sky130_fd_sc_hd__nor2_2
* cell instance $2583 r0 *1 156.86,16.32
X$2583 VPWR VGND \$139 \$143 \$92 VPWR VGND sky130_fd_sc_hd__nor2_2
* cell instance $2584 r0 *1 109.02,70.72
X$2584 VPWR VGND \$1273 \$1223 \$1275 VPWR VGND sky130_fd_sc_hd__nor2_2
* cell instance $2585 r0 *1 184,174.08
X$2585 VPWR VGND \$2566 \$2682 \$2681 VPWR VGND sky130_fd_sc_hd__nor2_2
* cell instance $2586 r0 *1 121.44,65.28
X$2586 VPWR VGND \$1143 \$1227 \$1202 VPWR VGND sky130_fd_sc_hd__nor2_2
* cell instance $2587 r0 *1 165.14,255.68
X$2587 VPWR VGND \$737 \$3385 \$4042 VPWR VGND sky130_fd_sc_hd__nor2_2
* cell instance $2588 r0 *1 149.5,27.2
X$2588 VPWR VGND \$105 \$407 \$35 VPWR VGND sky130_fd_sc_hd__nor2_2
* cell instance $2589 r0 *1 158.7,43.52
X$2589 VPWR VGND \$791 \$1186 \$792 VPWR VGND sky130_fd_sc_hd__nor2_2
* cell instance $2590 r0 *1 185.84,10.88
X$2590 VPWR VGND \$35 \$65 \$58 VPWR VGND sky130_fd_sc_hd__nor2_2
* cell instance $2591 r0 *1 172.04,163.2
X$2591 \$I11849 VGND select \$2576 \$2566 VPWR VGND sky130_fd_sc_hd__nor2_2
* cell instance $2592 r0 *1 164.68,10.88
X$2592 VPWR VGND sky130_fd_sc_hd__tapvpwrvgnd_1
* cell instance $2593 r0 *1 167.9,10.88
X$2593 VGND \$78 \$29 \$49 \$98 \$30 \$50 VPWR VPWR VGND
+ sky130_fd_sc_hd__a311o_2
* cell instance $2594 m90 *1 175.72,10.88
X$2594 VPWR VGND VPWR \$38 \$16 \$47 \$51 \$31 VGND sky130_fd_sc_hd__o22a_2
* cell instance $2595 m90 *1 177.1,10.88
X$2595 VPWR VGND VPWR \$37 \$17 VGND sky130_fd_sc_hd__inv_2
* cell instance $2596 r180 *1 171.12,16.32
X$2596 VGND \$83 \$120 \$72 \$49 VPWR VPWR VGND sky130_fd_sc_hd__mux2_1
* cell instance $2597 r180 *1 173.88,16.32
X$2597 VPWR \$35 VPWR \$46 \$100 VGND \$520 VGND sky130_fd_sc_hd__and3_2
* cell instance $2598 r180 *1 177.56,16.32
X$2598 VPWR \$105 VPWR \$35 VGND \$94 \$56 \$131 VGND sky130_fd_sc_hd__o211a_2
* cell instance $2600 m0 *1 180.78,16.32
X$2600 VPWR \$120 \$23 \$89 VPWR \$31 VGND \$100 VGND sky130_fd_sc_hd__a31o_2
* device instance $1 r0 *1 112.74,208.415 sky130_fd_pr__pfet_01v8_hvt
XM$1 \$I13765 \$I13785 \$I13711 VPWR sky130_fd_pr__pfet_01v8_hvt L=150000
+ W=420000 AS=109200000000 AD=69300000000 PS=1360000 PD=750000
* device instance $2 r0 *1 113.22,208.415 sky130_fd_pr__pfet_01v8_hvt
XM$2 \$I13711 \$425 \$I13719 VPWR sky130_fd_pr__pfet_01v8_hvt L=150000 W=420000
+ AS=69300000000 AD=44100000000 PS=750000 PD=630000
* device instance $3 r0 *1 113.58,208.415 sky130_fd_pr__pfet_01v8_hvt
XM$3 \$I13719 \$864 \$I13744 VPWR sky130_fd_pr__pfet_01v8_hvt L=150000 W=420000
+ AS=44100000000 AD=69300000000 PS=630000 PD=750000
* device instance $4 r0 *1 114.06,208.415 sky130_fd_pr__pfet_01v8_hvt
XM$4 \$I13744 \$340 VPWR VPWR sky130_fd_pr__pfet_01v8_hvt L=150000 W=420000
+ AS=69300000000 AD=168350000000 PS=750000 PD=1495000
* device instance $5 r0 *1 115.45,208.415 sky130_fd_pr__pfet_01v8_hvt
XM$5 VPWR \$27 \$I13785 VPWR sky130_fd_pr__pfet_01v8_hvt L=150000 W=420000
+ AS=169300000000 AD=109200000000 PS=1500000 PD=1360000
* device instance $6 r0 *1 114.545,208.705 sky130_fd_pr__pfet_01v8_hvt
XM$6 VPWR \$I13765 \$3276 VPWR sky130_fd_pr__pfet_01v8_hvt L=150000 W=2000000
+ AS=303350000000 AD=304300000000 PS=2765000 PD=2770000
* device instance $8 r0 *1 121.02,143.135 sky130_fd_pr__pfet_01v8_hvt
XM$8 \$I13767 \$I13784 \$I13712 VPWR sky130_fd_pr__pfet_01v8_hvt L=150000
+ W=420000 AS=109200000000 AD=69300000000 PS=1360000 PD=750000
* device instance $9 r0 *1 121.5,143.135 sky130_fd_pr__pfet_01v8_hvt
XM$9 \$I13712 \$984 \$I13720 VPWR sky130_fd_pr__pfet_01v8_hvt L=150000 W=420000
+ AS=69300000000 AD=44100000000 PS=750000 PD=630000
* device instance $10 r0 *1 121.86,143.135 sky130_fd_pr__pfet_01v8_hvt
XM$10 \$I13720 \$760 \$I13746 VPWR sky130_fd_pr__pfet_01v8_hvt L=150000
+ W=420000 AS=44100000000 AD=69300000000 PS=630000 PD=750000
* device instance $11 r0 *1 122.34,143.135 sky130_fd_pr__pfet_01v8_hvt
XM$11 \$I13746 \$899 VPWR VPWR sky130_fd_pr__pfet_01v8_hvt L=150000 W=420000
+ AS=69300000000 AD=168350000000 PS=750000 PD=1495000
* device instance $12 r0 *1 123.73,143.135 sky130_fd_pr__pfet_01v8_hvt
XM$12 VPWR \$1050 \$I13784 VPWR sky130_fd_pr__pfet_01v8_hvt L=150000 W=420000
+ AS=169300000000 AD=109200000000 PS=1500000 PD=1360000
* device instance $13 r0 *1 122.825,143.425 sky130_fd_pr__pfet_01v8_hvt
XM$13 VPWR \$I13767 \$2068 VPWR sky130_fd_pr__pfet_01v8_hvt L=150000 W=2000000
+ AS=303350000000 AD=304300000000 PS=2765000 PD=2770000
* device instance $15 r0 *1 114.09,270.305 sky130_fd_pr__pfet_01v8_hvt
XM$15 VPWR \$864 \$I14177 VPWR sky130_fd_pr__pfet_01v8_hvt L=150000 W=420000
+ AS=169300000000 AD=109200000000 PS=1500000 PD=1360000
* device instance $16 r0 *1 114.575,270.015 sky130_fd_pr__pfet_01v8_hvt
XM$16 VPWR \$I14183 \$4142 VPWR sky130_fd_pr__pfet_01v8_hvt L=150000 W=2000000
+ AS=337650000000 AD=270000000000 PS=2995000 PD=2540000
* device instance $18 r0 *1 115.48,270.305 sky130_fd_pr__pfet_01v8_hvt
XM$18 VPWR \$27 \$I14189 VPWR sky130_fd_pr__pfet_01v8_hvt L=150000 W=420000
+ AS=168350000000 AD=69300000000 PS=1495000 PD=750000
* device instance $19 r0 *1 115.96,270.305 sky130_fd_pr__pfet_01v8_hvt
XM$19 \$I14189 \$340 \$I13718 VPWR sky130_fd_pr__pfet_01v8_hvt L=150000
+ W=420000 AS=69300000000 AD=44100000000 PS=750000 PD=630000
* device instance $20 r0 *1 116.32,270.305 sky130_fd_pr__pfet_01v8_hvt
XM$20 \$I13718 \$425 \$I13846 VPWR sky130_fd_pr__pfet_01v8_hvt L=150000
+ W=420000 AS=44100000000 AD=69300000000 PS=630000 PD=750000
* device instance $21 r0 *1 116.8,270.305 sky130_fd_pr__pfet_01v8_hvt
XM$21 \$I13846 \$I14177 \$I14183 VPWR sky130_fd_pr__pfet_01v8_hvt L=150000
+ W=420000 AS=69300000000 AD=109200000000 PS=750000 PD=1360000
* device instance $22 r0 *1 117.34,226.785 sky130_fd_pr__pfet_01v8_hvt
XM$22 \$I13979 \$I13985 \$I13707 VPWR sky130_fd_pr__pfet_01v8_hvt L=150000
+ W=420000 AS=109200000000 AD=69300000000 PS=1360000 PD=750000
* device instance $23 r0 *1 117.82,226.785 sky130_fd_pr__pfet_01v8_hvt
XM$23 \$I13707 \$864 \$I13715 VPWR sky130_fd_pr__pfet_01v8_hvt L=150000
+ W=420000 AS=69300000000 AD=44100000000 PS=750000 PD=630000
* device instance $24 r0 *1 118.18,226.785 sky130_fd_pr__pfet_01v8_hvt
XM$24 \$I13715 \$340 \$I13973 VPWR sky130_fd_pr__pfet_01v8_hvt L=150000
+ W=420000 AS=44100000000 AD=69300000000 PS=630000 PD=750000
* device instance $25 r0 *1 118.66,226.785 sky130_fd_pr__pfet_01v8_hvt
XM$25 VPWR \$27 \$I13973 VPWR sky130_fd_pr__pfet_01v8_hvt L=150000 W=420000
+ AS=168350000000 AD=69300000000 PS=1495000 PD=750000
* device instance $26 r0 *1 119.145,226.495 sky130_fd_pr__pfet_01v8_hvt
XM$26 VPWR \$I13979 \$3728 VPWR sky130_fd_pr__pfet_01v8_hvt L=150000 W=2000000
+ AS=337650000000 AD=270000000000 PS=2995000 PD=2540000
* device instance $28 r0 *1 120.05,226.785 sky130_fd_pr__pfet_01v8_hvt
XM$28 VPWR \$425 \$I13985 VPWR sky130_fd_pr__pfet_01v8_hvt L=150000 W=420000
+ AS=169300000000 AD=109200000000 PS=1500000 PD=1360000
* device instance $29 r0 *1 164.72,251.935 sky130_fd_pr__pfet_01v8_hvt
XM$29 \$I13766 \$I13783 \$I13713 VPWR sky130_fd_pr__pfet_01v8_hvt L=150000
+ W=420000 AS=109200000000 AD=69300000000 PS=1360000 PD=750000
* device instance $30 r0 *1 165.2,251.935 sky130_fd_pr__pfet_01v8_hvt
XM$30 \$I13713 or4b_85_c \$I13721 VPWR sky130_fd_pr__pfet_01v8_hvt L=150000
+ W=420000 AS=69300000000 AD=44100000000 PS=750000 PD=630000
* device instance $31 r0 *1 165.56,251.935 sky130_fd_pr__pfet_01v8_hvt
XM$31 \$I13721 success \$I13745 VPWR sky130_fd_pr__pfet_01v8_hvt L=150000
+ W=420000 AS=44100000000 AD=69300000000 PS=630000 PD=750000
* device instance $32 r0 *1 166.04,251.935 sky130_fd_pr__pfet_01v8_hvt
XM$32 \$I13745 \$737 VPWR VPWR sky130_fd_pr__pfet_01v8_hvt L=150000 W=420000
+ AS=69300000000 AD=168350000000 PS=750000 PD=1495000
* device instance $33 r0 *1 167.43,251.935 sky130_fd_pr__pfet_01v8_hvt
XM$33 VPWR \$3967 \$I13783 VPWR sky130_fd_pr__pfet_01v8_hvt L=150000 W=420000
+ AS=169300000000 AD=109200000000 PS=1500000 PD=1360000
* device instance $34 r0 *1 166.525,252.225 sky130_fd_pr__pfet_01v8_hvt
XM$34 VPWR \$I13766 \$3905 VPWR sky130_fd_pr__pfet_01v8_hvt L=150000 W=2000000
+ AS=303350000000 AD=304300000000 PS=2765000 PD=2770000
* device instance $36 r0 *1 118.72,61.535 sky130_fd_pr__pfet_01v8_hvt
XM$36 \$I87 \$I93 \$I43 VPWR sky130_fd_pr__pfet_01v8_hvt L=150000 W=420000
+ AS=109200000000 AD=69300000000 PS=1360000 PD=750000
* device instance $37 r0 *1 119.2,61.535 sky130_fd_pr__pfet_01v8_hvt
XM$37 \$I43 \$984 \$I52 VPWR sky130_fd_pr__pfet_01v8_hvt L=150000 W=420000
+ AS=69300000000 AD=44100000000 PS=750000 PD=630000
* device instance $38 r0 *1 119.56,61.535 sky130_fd_pr__pfet_01v8_hvt
XM$38 \$I52 \$1050 \$I18 VPWR sky130_fd_pr__pfet_01v8_hvt L=150000 W=420000
+ AS=44100000000 AD=69300000000 PS=630000 PD=750000
* device instance $39 r0 *1 120.04,61.535 sky130_fd_pr__pfet_01v8_hvt
XM$39 \$I18 \$899 VPWR VPWR sky130_fd_pr__pfet_01v8_hvt L=150000 W=420000
+ AS=69300000000 AD=168350000000 PS=750000 PD=1495000
* device instance $40 r0 *1 121.43,61.535 sky130_fd_pr__pfet_01v8_hvt
XM$40 VPWR \$760 \$I93 VPWR sky130_fd_pr__pfet_01v8_hvt L=150000 W=420000
+ AS=169300000000 AD=109200000000 PS=1500000 PD=1360000
* device instance $41 r0 *1 120.525,61.825 sky130_fd_pr__pfet_01v8_hvt
XM$41 VPWR \$I87 \$1143 VPWR sky130_fd_pr__pfet_01v8_hvt L=150000 W=2000000
+ AS=303350000000 AD=304300000000 PS=2765000 PD=2770000
* device instance $43 r0 *1 114.09,199.585 sky130_fd_pr__pfet_01v8_hvt
XM$43 VPWR \$340 \$I13845 VPWR sky130_fd_pr__pfet_01v8_hvt L=150000 W=420000
+ AS=169300000000 AD=109200000000 PS=1500000 PD=1360000
* device instance $44 r0 *1 114.575,199.295 sky130_fd_pr__pfet_01v8_hvt
XM$44 VPWR \$I13849 \$3158 VPWR sky130_fd_pr__pfet_01v8_hvt L=150000 W=2000000
+ AS=337650000000 AD=270000000000 PS=2995000 PD=2540000
* device instance $46 r0 *1 115.48,199.585 sky130_fd_pr__pfet_01v8_hvt
XM$46 VPWR \$27 \$I13733 VPWR sky130_fd_pr__pfet_01v8_hvt L=150000 W=420000
+ AS=168350000000 AD=69300000000 PS=1495000 PD=750000
* device instance $47 r0 *1 115.96,199.585 sky130_fd_pr__pfet_01v8_hvt
XM$47 \$I13733 \$864 \$I13717 VPWR sky130_fd_pr__pfet_01v8_hvt L=150000
+ W=420000 AS=69300000000 AD=44100000000 PS=750000 PD=630000
* device instance $48 r0 *1 116.32,199.585 sky130_fd_pr__pfet_01v8_hvt
XM$48 \$I13717 \$425 \$I13847 VPWR sky130_fd_pr__pfet_01v8_hvt L=150000
+ W=420000 AS=44100000000 AD=69300000000 PS=630000 PD=750000
* device instance $49 r0 *1 116.8,199.585 sky130_fd_pr__pfet_01v8_hvt
XM$49 \$I13847 \$I13845 \$I13849 VPWR sky130_fd_pr__pfet_01v8_hvt L=150000
+ W=420000 AS=69300000000 AD=109200000000 PS=750000 PD=1360000
* device instance $50 r0 *1 111.79,72.415 sky130_fd_pr__pfet_01v8_hvt
XM$50 \$I13690 \$899 VPWR VPWR sky130_fd_pr__pfet_01v8_hvt L=150000 W=420000
+ AS=109200000000 AD=169300000000 PS=1360000 PD=1500000
* device instance $51 r0 *1 113.18,72.415 sky130_fd_pr__pfet_01v8_hvt
XM$51 VPWR \$760 \$I13730 VPWR sky130_fd_pr__pfet_01v8_hvt L=150000 W=420000
+ AS=168350000000 AD=69300000000 PS=1495000 PD=750000
* device instance $52 r0 *1 113.66,72.415 sky130_fd_pr__pfet_01v8_hvt
XM$52 \$I13730 \$1050 \$I13714 VPWR sky130_fd_pr__pfet_01v8_hvt L=150000
+ W=420000 AS=69300000000 AD=44100000000 PS=750000 PD=630000
* device instance $53 r0 *1 114.02,72.415 sky130_fd_pr__pfet_01v8_hvt
XM$53 \$I13714 \$984 \$I13706 VPWR sky130_fd_pr__pfet_01v8_hvt L=150000
+ W=420000 AS=44100000000 AD=69300000000 PS=630000 PD=750000
* device instance $54 r0 *1 114.5,72.415 sky130_fd_pr__pfet_01v8_hvt
XM$54 \$I13706 \$I13690 \$I13698 VPWR sky130_fd_pr__pfet_01v8_hvt L=150000
+ W=420000 AS=69300000000 AD=109200000000 PS=750000 PD=1360000
* device instance $55 r0 *1 112.275,72.705 sky130_fd_pr__pfet_01v8_hvt
XM$55 VPWR \$I13698 \$1273 VPWR sky130_fd_pr__pfet_01v8_hvt L=150000 W=2000000
+ AS=304300000000 AD=303350000000 PS=2770000 PD=2765000
* device instance $57 r0 *1 115.5,85.345 sky130_fd_pr__pfet_01v8_hvt
XM$57 \$I13700 \$I13692 \$I13708 VPWR sky130_fd_pr__pfet_01v8_hvt L=150000
+ W=420000 AS=109200000000 AD=69300000000 PS=1360000 PD=750000
* device instance $58 r0 *1 115.98,85.345 sky130_fd_pr__pfet_01v8_hvt
XM$58 \$I13708 \$1050 \$I13716 VPWR sky130_fd_pr__pfet_01v8_hvt L=150000
+ W=420000 AS=69300000000 AD=44100000000 PS=750000 PD=630000
* device instance $59 r0 *1 116.34,85.345 sky130_fd_pr__pfet_01v8_hvt
XM$59 \$I13716 \$760 \$I13732 VPWR sky130_fd_pr__pfet_01v8_hvt L=150000
+ W=420000 AS=44100000000 AD=69300000000 PS=630000 PD=750000
* device instance $60 r0 *1 116.82,85.345 sky130_fd_pr__pfet_01v8_hvt
XM$60 VPWR \$899 \$I13732 VPWR sky130_fd_pr__pfet_01v8_hvt L=150000 W=420000
+ AS=168350000000 AD=69300000000 PS=1495000 PD=750000
* device instance $61 r0 *1 117.305,85.055 sky130_fd_pr__pfet_01v8_hvt
XM$61 VPWR \$I13700 \$1404 VPWR sky130_fd_pr__pfet_01v8_hvt L=150000 W=2000000
+ AS=337650000000 AD=270000000000 PS=2995000 PD=2540000
* device instance $63 r0 *1 118.21,85.345 sky130_fd_pr__pfet_01v8_hvt
XM$63 VPWR \$984 \$I13692 VPWR sky130_fd_pr__pfet_01v8_hvt L=150000 W=420000
+ AS=169300000000 AD=109200000000 PS=1500000 PD=1360000
* device instance $64 r0 *1 175.68,154.305 sky130_fd_pr__pfet_01v8_hvt
XM$64 \$I14211 \$1413 VPWR VPWR sky130_fd_pr__pfet_01v8_hvt L=150000 W=2000000
+ AS=420000000000 AD=475000000000 PS=3840000 PD=3950000
* device instance $65 r0 *1 176.11,154.305 sky130_fd_pr__pfet_01v8_hvt
XM$65 VPWR \$1362 \$I14211 VPWR sky130_fd_pr__pfet_01v8_hvt L=150000 W=2000000
+ AS=280000000000 AD=300000000000 PS=2560000 PD=2600000
* device instance $68 r0 *1 172.54,154.305 sky130_fd_pr__pfet_01v8_hvt
XM$68 \$I14210 \$2314 \$I14212 VPWR sky130_fd_pr__pfet_01v8_hvt L=150000
+ W=1000000 AS=285000000000 AD=140000000000 PS=2570000 PD=1280000
* device instance $69 r0 *1 172.97,154.305 sky130_fd_pr__pfet_01v8_hvt
XM$69 \$I14212 \$2497 \$2475 VPWR sky130_fd_pr__pfet_01v8_hvt L=150000
+ W=1000000 AS=140000000000 AD=140000000000 PS=1280000 PD=1280000
* device instance $70 r0 *1 173.4,154.305 sky130_fd_pr__pfet_01v8_hvt
XM$70 \$2475 \$2497 \$I14213 VPWR sky130_fd_pr__pfet_01v8_hvt L=150000
+ W=1000000 AS=140000000000 AD=140000000000 PS=1280000 PD=1280000
* device instance $71 r0 *1 173.83,154.305 sky130_fd_pr__pfet_01v8_hvt
XM$71 \$I14213 \$2314 \$I14210 VPWR sky130_fd_pr__pfet_01v8_hvt L=150000
+ W=1000000 AS=140000000000 AD=160000000000 PS=1280000 PD=1320000
* device instance $72 r0 *1 174.3,154.305 sky130_fd_pr__pfet_01v8_hvt
XM$72 \$I14210 \$1527 \$I14211 VPWR sky130_fd_pr__pfet_01v8_hvt L=150000
+ W=2000000 AS=300000000000 AD=400000000000 PS=2600000 PD=3800000
* device instance $74 r0 *1 172.54,152.88 sky130_fd_pr__nfet_01v8
XM$74 \$2475 \$2314 VGND VGND sky130_fd_pr__nfet_01v8 L=150000 W=1300000
+ AS=312000000000 AD=196625000000 PS=2910000 PD=1905000
* device instance $75 r0 *1 172.97,152.88 sky130_fd_pr__nfet_01v8
XM$75 VGND \$2497 \$2475 VGND sky130_fd_pr__nfet_01v8 L=150000 W=1300000
+ AS=182000000000 AD=217750000000 PS=1860000 PD=1970000
* device instance $78 r0 *1 174.415,152.88 sky130_fd_pr__nfet_01v8
XM$78 \$2475 \$1527 VGND VGND sky130_fd_pr__nfet_01v8 L=150000 W=1300000
+ AS=232375000000 AD=217750000000 PS=2015000 PD=1970000
* device instance $80 r0 *1 175.385,152.88 sky130_fd_pr__nfet_01v8
XM$80 \$2475 \$1413 \$I14209 VGND sky130_fd_pr__nfet_01v8 L=150000 W=650000
+ AS=91000000000 AD=178750000000 PS=930000 PD=1200000
* device instance $81 r0 *1 176.085,152.88 sky130_fd_pr__nfet_01v8
XM$81 \$I14209 \$1362 VGND VGND sky130_fd_pr__nfet_01v8 L=150000 W=650000
+ AS=178750000000 AD=112125000000 PS=1200000 PD=995000
* device instance $82 r0 *1 176.58,152.88 sky130_fd_pr__nfet_01v8
XM$82 VGND \$1362 \$I14208 VGND sky130_fd_pr__nfet_01v8 L=150000 W=650000
+ AS=112125000000 AD=91000000000 PS=995000 PD=930000
* device instance $83 r0 *1 177.01,152.88 sky130_fd_pr__nfet_01v8
XM$83 \$I14208 \$1413 \$2475 VGND sky130_fd_pr__nfet_01v8 L=150000 W=650000
+ AS=91000000000 AD=172250000000 PS=930000 PD=1830000
* device instance $84 m90 *1 167.43,250.715 sky130_fd_pr__nfet_01v8
XM$84 VGND \$3967 \$I13783 VGND sky130_fd_pr__nfet_01v8 L=150000 W=420000
+ AS=100250000000 AD=109200000000 PS=985000 PD=1360000
* device instance $85 m90 *1 166.04,250.715 sky130_fd_pr__nfet_01v8
XM$85 VGND \$737 \$I13766 VGND sky130_fd_pr__nfet_01v8 L=150000 W=420000
+ AS=100250000000 AD=69300000000 PS=985000 PD=750000
* device instance $86 m90 *1 165.56,250.715 sky130_fd_pr__nfet_01v8
XM$86 \$I13766 success VGND VGND sky130_fd_pr__nfet_01v8 L=150000 W=420000
+ AS=69300000000 AD=56700000000 PS=750000 PD=690000
* device instance $87 m90 *1 165.14,250.715 sky130_fd_pr__nfet_01v8
XM$87 VGND or4b_85_c \$I13766 VGND sky130_fd_pr__nfet_01v8 L=150000 W=420000
+ AS=56700000000 AD=56700000000 PS=690000 PD=690000
* device instance $88 m90 *1 164.72,250.715 sky130_fd_pr__nfet_01v8
XM$88 \$I13766 \$I13783 VGND VGND sky130_fd_pr__nfet_01v8 L=150000 W=420000
+ AS=56700000000 AD=109200000000 PS=690000 PD=1360000
* device instance $89 m90 *1 166.945,250.8 sky130_fd_pr__nfet_01v8
XM$89 VGND \$I13766 \$3905 VGND sky130_fd_pr__nfet_01v8 L=150000 W=1300000
+ AS=188000000000 AD=188000000000 PS=1905000 PD=1905000
* device instance $91 m90 *1 123.73,141.915 sky130_fd_pr__nfet_01v8
XM$91 VGND \$1050 \$I13784 VGND sky130_fd_pr__nfet_01v8 L=150000 W=420000
+ AS=100250000000 AD=109200000000 PS=985000 PD=1360000
* device instance $92 m90 *1 122.34,141.915 sky130_fd_pr__nfet_01v8
XM$92 VGND \$899 \$I13767 VGND sky130_fd_pr__nfet_01v8 L=150000 W=420000
+ AS=100250000000 AD=69300000000 PS=985000 PD=750000
* device instance $93 m90 *1 121.86,141.915 sky130_fd_pr__nfet_01v8
XM$93 \$I13767 \$760 VGND VGND sky130_fd_pr__nfet_01v8 L=150000 W=420000
+ AS=69300000000 AD=56700000000 PS=750000 PD=690000
* device instance $94 m90 *1 121.44,141.915 sky130_fd_pr__nfet_01v8
XM$94 VGND \$984 \$I13767 VGND sky130_fd_pr__nfet_01v8 L=150000 W=420000
+ AS=56700000000 AD=56700000000 PS=690000 PD=690000
* device instance $95 m90 *1 121.02,141.915 sky130_fd_pr__nfet_01v8
XM$95 \$I13767 \$I13784 VGND VGND sky130_fd_pr__nfet_01v8 L=150000 W=420000
+ AS=56700000000 AD=109200000000 PS=690000 PD=1360000
* device instance $96 m90 *1 123.245,142 sky130_fd_pr__nfet_01v8
XM$96 VGND \$I13767 \$2068 VGND sky130_fd_pr__nfet_01v8 L=150000 W=1300000
+ AS=188000000000 AD=188000000000 PS=1905000 PD=1905000
* device instance $98 m90 *1 115.45,207.195 sky130_fd_pr__nfet_01v8
XM$98 VGND \$27 \$I13785 VGND sky130_fd_pr__nfet_01v8 L=150000 W=420000
+ AS=100250000000 AD=109200000000 PS=985000 PD=1360000
* device instance $99 m90 *1 114.06,207.195 sky130_fd_pr__nfet_01v8
XM$99 VGND \$340 \$I13765 VGND sky130_fd_pr__nfet_01v8 L=150000 W=420000
+ AS=100250000000 AD=69300000000 PS=985000 PD=750000
* device instance $100 m90 *1 113.58,207.195 sky130_fd_pr__nfet_01v8
XM$100 \$I13765 \$864 VGND VGND sky130_fd_pr__nfet_01v8 L=150000 W=420000
+ AS=69300000000 AD=56700000000 PS=750000 PD=690000
* device instance $101 m90 *1 113.16,207.195 sky130_fd_pr__nfet_01v8
XM$101 VGND \$425 \$I13765 VGND sky130_fd_pr__nfet_01v8 L=150000 W=420000
+ AS=56700000000 AD=56700000000 PS=690000 PD=690000
* device instance $102 m90 *1 112.74,207.195 sky130_fd_pr__nfet_01v8
XM$102 \$I13765 \$I13785 VGND VGND sky130_fd_pr__nfet_01v8 L=150000 W=420000
+ AS=56700000000 AD=109200000000 PS=690000 PD=1360000
* device instance $103 m90 *1 114.965,207.28 sky130_fd_pr__nfet_01v8
XM$103 VGND \$I13765 \$3276 VGND sky130_fd_pr__nfet_01v8 L=150000 W=1300000
+ AS=188000000000 AD=188000000000 PS=1905000 PD=1905000
* device instance $105 m0 *1 114.09,271.525 sky130_fd_pr__nfet_01v8
XM$105 VGND \$864 \$I14177 VGND sky130_fd_pr__nfet_01v8 L=150000 W=420000
+ AS=100250000000 AD=109200000000 PS=985000 PD=1360000
* device instance $106 m0 *1 115.48,271.525 sky130_fd_pr__nfet_01v8
XM$106 VGND \$27 \$I14183 VGND sky130_fd_pr__nfet_01v8 L=150000 W=420000
+ AS=100250000000 AD=69300000000 PS=985000 PD=750000
* device instance $107 m0 *1 115.96,271.525 sky130_fd_pr__nfet_01v8
XM$107 \$I14183 \$340 VGND VGND sky130_fd_pr__nfet_01v8 L=150000 W=420000
+ AS=69300000000 AD=56700000000 PS=750000 PD=690000
* device instance $108 m0 *1 116.38,271.525 sky130_fd_pr__nfet_01v8
XM$108 VGND \$425 \$I14183 VGND sky130_fd_pr__nfet_01v8 L=150000 W=420000
+ AS=56700000000 AD=56700000000 PS=690000 PD=690000
* device instance $109 m0 *1 116.8,271.525 sky130_fd_pr__nfet_01v8
XM$109 \$I14183 \$I14177 VGND VGND sky130_fd_pr__nfet_01v8 L=150000 W=420000
+ AS=56700000000 AD=109200000000 PS=690000 PD=1360000
* device instance $110 m0 *1 114.575,271.44 sky130_fd_pr__nfet_01v8
XM$110 VGND \$I14183 \$4142 VGND sky130_fd_pr__nfet_01v8 L=150000 W=1300000
+ AS=188000000000 AD=188000000000 PS=1905000 PD=1905000
* device instance $112 m0 *1 114.09,200.805 sky130_fd_pr__nfet_01v8
XM$112 VGND \$340 \$I13845 VGND sky130_fd_pr__nfet_01v8 L=150000 W=420000
+ AS=100250000000 AD=109200000000 PS=985000 PD=1360000
* device instance $113 m0 *1 115.48,200.805 sky130_fd_pr__nfet_01v8
XM$113 VGND \$27 \$I13849 VGND sky130_fd_pr__nfet_01v8 L=150000 W=420000
+ AS=100250000000 AD=69300000000 PS=985000 PD=750000
* device instance $114 m0 *1 115.96,200.805 sky130_fd_pr__nfet_01v8
XM$114 \$I13849 \$864 VGND VGND sky130_fd_pr__nfet_01v8 L=150000 W=420000
+ AS=69300000000 AD=56700000000 PS=750000 PD=690000
* device instance $115 m0 *1 116.38,200.805 sky130_fd_pr__nfet_01v8
XM$115 VGND \$425 \$I13849 VGND sky130_fd_pr__nfet_01v8 L=150000 W=420000
+ AS=56700000000 AD=56700000000 PS=690000 PD=690000
* device instance $116 m0 *1 116.8,200.805 sky130_fd_pr__nfet_01v8
XM$116 \$I13849 \$I13845 VGND VGND sky130_fd_pr__nfet_01v8 L=150000 W=420000
+ AS=56700000000 AD=109200000000 PS=690000 PD=1360000
* device instance $117 m0 *1 114.575,200.72 sky130_fd_pr__nfet_01v8
XM$117 VGND \$I13849 \$3158 VGND sky130_fd_pr__nfet_01v8 L=150000 W=1300000
+ AS=188000000000 AD=188000000000 PS=1905000 PD=1905000
* device instance $119 r180 *1 118.21,86.565 sky130_fd_pr__nfet_01v8
XM$119 VGND \$984 \$I13692 VGND sky130_fd_pr__nfet_01v8 L=150000 W=420000
+ AS=100250000000 AD=109200000000 PS=985000 PD=1360000
* device instance $120 r180 *1 116.82,86.565 sky130_fd_pr__nfet_01v8
XM$120 VGND \$899 \$I13700 VGND sky130_fd_pr__nfet_01v8 L=150000 W=420000
+ AS=100250000000 AD=69300000000 PS=985000 PD=750000
* device instance $121 r180 *1 116.34,86.565 sky130_fd_pr__nfet_01v8
XM$121 \$I13700 \$760 VGND VGND sky130_fd_pr__nfet_01v8 L=150000 W=420000
+ AS=69300000000 AD=56700000000 PS=750000 PD=690000
* device instance $122 r180 *1 115.92,86.565 sky130_fd_pr__nfet_01v8
XM$122 VGND \$1050 \$I13700 VGND sky130_fd_pr__nfet_01v8 L=150000 W=420000
+ AS=56700000000 AD=56700000000 PS=690000 PD=690000
* device instance $123 r180 *1 115.5,86.565 sky130_fd_pr__nfet_01v8
XM$123 \$I13700 \$I13692 VGND VGND sky130_fd_pr__nfet_01v8 L=150000 W=420000
+ AS=56700000000 AD=109200000000 PS=690000 PD=1360000
* device instance $124 r180 *1 117.725,86.48 sky130_fd_pr__nfet_01v8
XM$124 VGND \$I13700 \$1404 VGND sky130_fd_pr__nfet_01v8 L=150000 W=1300000
+ AS=188000000000 AD=188000000000 PS=1905000 PD=1905000
* device instance $126 r180 *1 120.05,228.005 sky130_fd_pr__nfet_01v8
XM$126 VGND \$425 \$I13985 VGND sky130_fd_pr__nfet_01v8 L=150000 W=420000
+ AS=100250000000 AD=109200000000 PS=985000 PD=1360000
* device instance $127 r180 *1 118.66,228.005 sky130_fd_pr__nfet_01v8
XM$127 VGND \$27 \$I13979 VGND sky130_fd_pr__nfet_01v8 L=150000 W=420000
+ AS=100250000000 AD=69300000000 PS=985000 PD=750000
* device instance $128 r180 *1 118.18,228.005 sky130_fd_pr__nfet_01v8
XM$128 \$I13979 \$340 VGND VGND sky130_fd_pr__nfet_01v8 L=150000 W=420000
+ AS=69300000000 AD=56700000000 PS=750000 PD=690000
* device instance $129 r180 *1 117.76,228.005 sky130_fd_pr__nfet_01v8
XM$129 VGND \$864 \$I13979 VGND sky130_fd_pr__nfet_01v8 L=150000 W=420000
+ AS=56700000000 AD=56700000000 PS=690000 PD=690000
* device instance $130 r180 *1 117.34,228.005 sky130_fd_pr__nfet_01v8
XM$130 \$I13979 \$I13985 VGND VGND sky130_fd_pr__nfet_01v8 L=150000 W=420000
+ AS=56700000000 AD=109200000000 PS=690000 PD=1360000
* device instance $131 r180 *1 119.565,227.92 sky130_fd_pr__nfet_01v8
XM$131 VGND \$I13979 \$3728 VGND sky130_fd_pr__nfet_01v8 L=150000 W=1300000
+ AS=188000000000 AD=188000000000 PS=1905000 PD=1905000
* device instance $133 r0 *1 111.79,71.195 sky130_fd_pr__nfet_01v8
XM$133 VGND \$899 \$I13690 VGND sky130_fd_pr__nfet_01v8 L=150000 W=420000
+ AS=100250000000 AD=109200000000 PS=985000 PD=1360000
* device instance $134 r0 *1 113.18,71.195 sky130_fd_pr__nfet_01v8
XM$134 VGND \$760 \$I13698 VGND sky130_fd_pr__nfet_01v8 L=150000 W=420000
+ AS=100250000000 AD=69300000000 PS=985000 PD=750000
* device instance $135 r0 *1 113.66,71.195 sky130_fd_pr__nfet_01v8
XM$135 \$I13698 \$1050 VGND VGND sky130_fd_pr__nfet_01v8 L=150000 W=420000
+ AS=69300000000 AD=56700000000 PS=750000 PD=690000
* device instance $136 r0 *1 114.08,71.195 sky130_fd_pr__nfet_01v8
XM$136 VGND \$984 \$I13698 VGND sky130_fd_pr__nfet_01v8 L=150000 W=420000
+ AS=56700000000 AD=56700000000 PS=690000 PD=690000
* device instance $137 r0 *1 114.5,71.195 sky130_fd_pr__nfet_01v8
XM$137 \$I13698 \$I13690 VGND VGND sky130_fd_pr__nfet_01v8 L=150000 W=420000
+ AS=56700000000 AD=109200000000 PS=690000 PD=1360000
* device instance $138 r0 *1 112.275,71.28 sky130_fd_pr__nfet_01v8
XM$138 VGND \$I13698 \$1273 VGND sky130_fd_pr__nfet_01v8 L=150000 W=1300000
+ AS=188000000000 AD=188000000000 PS=1905000 PD=1905000
* device instance $140 m90 *1 121.43,60.315 sky130_fd_pr__nfet_01v8
XM$140 VGND \$760 \$I93 VGND sky130_fd_pr__nfet_01v8 L=150000 W=420000
+ AS=100250000000 AD=109200000000 PS=985000 PD=1360000
* device instance $141 m90 *1 120.04,60.315 sky130_fd_pr__nfet_01v8
XM$141 VGND \$899 \$I87 VGND sky130_fd_pr__nfet_01v8 L=150000 W=420000
+ AS=100250000000 AD=69300000000 PS=985000 PD=750000
* device instance $142 m90 *1 119.56,60.315 sky130_fd_pr__nfet_01v8
XM$142 \$I87 \$1050 VGND VGND sky130_fd_pr__nfet_01v8 L=150000 W=420000
+ AS=69300000000 AD=56700000000 PS=750000 PD=690000
* device instance $143 m90 *1 119.14,60.315 sky130_fd_pr__nfet_01v8
XM$143 VGND \$984 \$I87 VGND sky130_fd_pr__nfet_01v8 L=150000 W=420000
+ AS=56700000000 AD=56700000000 PS=690000 PD=690000
* device instance $144 m90 *1 118.72,60.315 sky130_fd_pr__nfet_01v8
XM$144 \$I87 \$I93 VGND VGND sky130_fd_pr__nfet_01v8 L=150000 W=420000
+ AS=56700000000 AD=109200000000 PS=690000 PD=1360000
* device instance $145 m90 *1 120.945,60.4 sky130_fd_pr__nfet_01v8
XM$145 VGND \$I87 \$1143 VGND sky130_fd_pr__nfet_01v8 L=150000 W=1300000
+ AS=188000000000 AD=188000000000 PS=1905000 PD=1905000
* device instance $147 m90 *1 180.74,252.225 sky130_fd_pr__pfet_01v8_hvt
XM$147 \$I14217 \$I14214 \$3986 VPWR sky130_fd_pr__pfet_01v8_hvt L=150000
+ W=2000000 AS=395000000000 AD=270000000000 PS=3790000 PD=2540000
* device instance $149 m90 *1 179.9,252.225 sky130_fd_pr__pfet_01v8_hvt
XM$149 \$I14217 \$3933 VPWR VPWR sky130_fd_pr__pfet_01v8_hvt L=150000 W=2000000
+ AS=275000000000 AD=420000000000 PS=2550000 PD=3840000
* device instance $150 m90 *1 179.48,252.225 sky130_fd_pr__pfet_01v8_hvt
XM$150 VPWR \$3850 \$I14217 VPWR sky130_fd_pr__pfet_01v8_hvt L=150000 W=2000000
+ AS=275000000000 AD=280000000000 PS=2550000 PD=2560000
* device instance $153 m90 *1 181.685,252.34 sky130_fd_pr__pfet_01v8_hvt
XM$153 VPWR \$3846 \$I14214 VPWR sky130_fd_pr__pfet_01v8_hvt L=150000 W=420000
+ AS=111300000000 AD=111300000000 PS=1370000 PD=1370000
* device instance $154 m90 *1 181.48,250.685 sky130_fd_pr__nfet_01v8
XM$154 \$I14214 \$3846 VGND VGND sky130_fd_pr__nfet_01v8 L=150000 W=420000
+ AS=126000000000 AD=183125000000 PS=1440000 PD=1240000
* device instance $155 m90 *1 180.74,250.8 sky130_fd_pr__nfet_01v8
XM$155 VGND \$I14214 \$3986 VGND sky130_fd_pr__nfet_01v8 L=150000 W=1300000
+ AS=270875000000 AD=195000000000 PS=2160000 PD=1900000
* device instance $157 m90 *1 179.84,250.8 sky130_fd_pr__nfet_01v8
XM$157 VGND \$3933 \$I14216 VGND sky130_fd_pr__nfet_01v8 L=150000 W=650000
+ AS=107250000000 AD=68250000000 PS=980000 PD=860000
* device instance $158 m90 *1 179.48,250.8 sky130_fd_pr__nfet_01v8
XM$158 \$I14216 \$3850 \$3986 VGND sky130_fd_pr__nfet_01v8 L=150000 W=650000
+ AS=68250000000 AD=91000000000 PS=860000 PD=930000
* device instance $159 m90 *1 179.05,250.8 sky130_fd_pr__nfet_01v8
XM$159 \$3986 \$3850 \$I14215 VGND sky130_fd_pr__nfet_01v8 L=150000 W=650000
+ AS=91000000000 AD=91000000000 PS=930000 PD=930000
* device instance $160 m90 *1 178.62,250.8 sky130_fd_pr__nfet_01v8
XM$160 \$I14215 \$3933 VGND VGND sky130_fd_pr__nfet_01v8 L=150000 W=650000
+ AS=91000000000 AD=185250000000 PS=930000 PD=1870000
* device instance $161 m90 *1 173.84,241.345 sky130_fd_pr__pfet_01v8_hvt
XM$161 \$I14221 \$I14218 \$3865 VPWR sky130_fd_pr__pfet_01v8_hvt L=150000
+ W=2000000 AS=395000000000 AD=270000000000 PS=3790000 PD=2540000
* device instance $163 m90 *1 173,241.345 sky130_fd_pr__pfet_01v8_hvt
XM$163 \$I14221 \$3842 VPWR VPWR sky130_fd_pr__pfet_01v8_hvt L=150000 W=2000000
+ AS=275000000000 AD=420000000000 PS=2550000 PD=3840000
* device instance $164 m90 *1 172.58,241.345 sky130_fd_pr__pfet_01v8_hvt
XM$164 VPWR \$3864 \$I14221 VPWR sky130_fd_pr__pfet_01v8_hvt L=150000 W=2000000
+ AS=275000000000 AD=280000000000 PS=2550000 PD=2560000
* device instance $167 m90 *1 174.785,241.46 sky130_fd_pr__pfet_01v8_hvt
XM$167 VPWR \$3846 \$I14218 VPWR sky130_fd_pr__pfet_01v8_hvt L=150000 W=420000
+ AS=111300000000 AD=111300000000 PS=1370000 PD=1370000
* device instance $168 m90 *1 174.58,239.805 sky130_fd_pr__nfet_01v8
XM$168 \$I14218 \$3846 VGND VGND sky130_fd_pr__nfet_01v8 L=150000 W=420000
+ AS=126000000000 AD=183125000000 PS=1440000 PD=1240000
* device instance $169 m90 *1 173.84,239.92 sky130_fd_pr__nfet_01v8
XM$169 VGND \$I14218 \$3865 VGND sky130_fd_pr__nfet_01v8 L=150000 W=1300000
+ AS=270875000000 AD=195000000000 PS=2160000 PD=1900000
* device instance $171 m90 *1 172.94,239.92 sky130_fd_pr__nfet_01v8
XM$171 VGND \$3842 \$I14220 VGND sky130_fd_pr__nfet_01v8 L=150000 W=650000
+ AS=107250000000 AD=68250000000 PS=980000 PD=860000
* device instance $172 m90 *1 172.58,239.92 sky130_fd_pr__nfet_01v8
XM$172 \$I14220 \$3864 \$3865 VGND sky130_fd_pr__nfet_01v8 L=150000 W=650000
+ AS=68250000000 AD=91000000000 PS=860000 PD=930000
* device instance $173 m90 *1 172.15,239.92 sky130_fd_pr__nfet_01v8
XM$173 \$3865 \$3864 \$I14219 VGND sky130_fd_pr__nfet_01v8 L=150000 W=650000
+ AS=91000000000 AD=91000000000 PS=930000 PD=930000
* device instance $174 m90 *1 171.72,239.92 sky130_fd_pr__nfet_01v8
XM$174 \$I14219 \$3842 VGND VGND sky130_fd_pr__nfet_01v8 L=150000 W=650000
+ AS=91000000000 AD=185250000000 PS=930000 PD=1870000
* device instance $175 m90 *1 173.84,257.665 sky130_fd_pr__pfet_01v8_hvt
XM$175 \$I14225 \$I14222 \$3914 \$I14138 sky130_fd_pr__pfet_01v8_hvt L=150000
+ W=2000000 AS=395000000000 AD=270000000000 PS=3790000 PD=2540000
* device instance $177 m90 *1 173,257.665 sky130_fd_pr__pfet_01v8_hvt
XM$177 \$I14225 \$3850 VPWR \$I14138 sky130_fd_pr__pfet_01v8_hvt L=150000
+ W=2000000 AS=275000000000 AD=420000000000 PS=2550000 PD=3840000
* device instance $178 m90 *1 172.58,257.665 sky130_fd_pr__pfet_01v8_hvt
XM$178 VPWR \$1413 \$I14225 \$I14138 sky130_fd_pr__pfet_01v8_hvt L=150000
+ W=2000000 AS=275000000000 AD=280000000000 PS=2550000 PD=2560000
* device instance $181 m90 *1 174.785,257.78 sky130_fd_pr__pfet_01v8_hvt
XM$181 VPWR \$3846 \$I14222 \$I14138 sky130_fd_pr__pfet_01v8_hvt L=150000
+ W=420000 AS=111300000000 AD=111300000000 PS=1370000 PD=1370000
* device instance $182 m90 *1 174.58,256.125 sky130_fd_pr__nfet_01v8
XM$182 \$I14222 \$3846 VGND VGND sky130_fd_pr__nfet_01v8 L=150000 W=420000
+ AS=126000000000 AD=183125000000 PS=1440000 PD=1240000
* device instance $183 m90 *1 173.84,256.24 sky130_fd_pr__nfet_01v8
XM$183 VGND \$I14222 \$3914 VGND sky130_fd_pr__nfet_01v8 L=150000 W=1300000
+ AS=270875000000 AD=195000000000 PS=2160000 PD=1900000
* device instance $185 m90 *1 172.94,256.24 sky130_fd_pr__nfet_01v8
XM$185 VGND \$3850 \$I14224 VGND sky130_fd_pr__nfet_01v8 L=150000 W=650000
+ AS=107250000000 AD=68250000000 PS=980000 PD=860000
* device instance $186 m90 *1 172.58,256.24 sky130_fd_pr__nfet_01v8
XM$186 \$I14224 \$1413 \$3914 VGND sky130_fd_pr__nfet_01v8 L=150000 W=650000
+ AS=68250000000 AD=91000000000 PS=860000 PD=930000
* device instance $187 m90 *1 172.15,256.24 sky130_fd_pr__nfet_01v8
XM$187 \$3914 \$1413 \$I14223 VGND sky130_fd_pr__nfet_01v8 L=150000 W=650000
+ AS=91000000000 AD=91000000000 PS=930000 PD=930000
* device instance $188 m90 *1 171.72,256.24 sky130_fd_pr__nfet_01v8
XM$188 \$I14223 \$3850 VGND VGND sky130_fd_pr__nfet_01v8 L=150000 W=650000
+ AS=91000000000 AD=185250000000 PS=930000 PD=1870000
* device instance $189 m0 *1 174.38,166.655 sky130_fd_pr__pfet_01v8_hvt
XM$189 \$I14229 \$I14226 \$2589 \$I11849 sky130_fd_pr__pfet_01v8_hvt L=150000
+ W=2000000 AS=395000000000 AD=270000000000 PS=3790000 PD=2540000
* device instance $191 m0 *1 175.22,166.655 sky130_fd_pr__pfet_01v8_hvt
XM$191 \$I14229 \$2566 VPWR \$I11849 sky130_fd_pr__pfet_01v8_hvt L=150000
+ W=2000000 AS=275000000000 AD=420000000000 PS=2550000 PD=3840000
* device instance $192 m0 *1 175.64,166.655 sky130_fd_pr__pfet_01v8_hvt
XM$192 VPWR I \$I14229 \$I11849 sky130_fd_pr__pfet_01v8_hvt L=150000 W=2000000
+ AS=275000000000 AD=280000000000 PS=2550000 PD=2560000
* device instance $195 m0 *1 173.435,166.54 sky130_fd_pr__pfet_01v8_hvt
XM$195 VPWR select \$I14226 \$I11849 sky130_fd_pr__pfet_01v8_hvt L=150000
+ W=420000 AS=111300000000 AD=111300000000 PS=1370000 PD=1370000
* device instance $196 m0 *1 173.64,168.195 sky130_fd_pr__nfet_01v8
XM$196 \$I14226 select VGND VGND sky130_fd_pr__nfet_01v8 L=150000 W=420000
+ AS=126000000000 AD=183125000000 PS=1440000 PD=1240000
* device instance $197 m0 *1 174.38,168.08 sky130_fd_pr__nfet_01v8
XM$197 VGND \$I14226 \$2589 VGND sky130_fd_pr__nfet_01v8 L=150000 W=1300000
+ AS=270875000000 AD=195000000000 PS=2160000 PD=1900000
* device instance $199 m0 *1 175.28,168.08 sky130_fd_pr__nfet_01v8
XM$199 VGND \$2566 \$I14228 VGND sky130_fd_pr__nfet_01v8 L=150000 W=650000
+ AS=107250000000 AD=68250000000 PS=980000 PD=860000
* device instance $200 m0 *1 175.64,168.08 sky130_fd_pr__nfet_01v8
XM$200 \$I14228 I \$2589 VGND sky130_fd_pr__nfet_01v8 L=150000 W=650000
+ AS=68250000000 AD=91000000000 PS=860000 PD=930000
* device instance $201 m0 *1 176.07,168.08 sky130_fd_pr__nfet_01v8
XM$201 \$2589 I \$I14227 VGND sky130_fd_pr__nfet_01v8 L=150000 W=650000
+ AS=91000000000 AD=91000000000 PS=930000 PD=930000
* device instance $202 m0 *1 176.5,168.08 sky130_fd_pr__nfet_01v8
XM$202 \$I14227 \$2566 VGND VGND sky130_fd_pr__nfet_01v8 L=150000 W=650000
+ AS=91000000000 AD=185250000000 PS=930000 PD=1870000
* device instance $203 m90 *1 168.79,50.945 sky130_fd_pr__pfet_01v8_hvt
XM$203 \$I14230 \$986 VPWR VPWR sky130_fd_pr__pfet_01v8_hvt L=150000 W=2000000
+ AS=415000000000 AD=275000000000 PS=3830000 PD=2550000
* device instance $204 m90 *1 168.36,50.945 sky130_fd_pr__pfet_01v8_hvt
XM$204 VPWR \$865 \$I14230 VPWR sky130_fd_pr__pfet_01v8_hvt L=150000 W=2000000
+ AS=280000000000 AD=275000000000 PS=2560000 PD=2550000
* device instance $207 m90 *1 167.09,50.945 sky130_fd_pr__pfet_01v8_hvt
XM$207 \$I14230 \$866 \$1008 VPWR sky130_fd_pr__pfet_01v8_hvt L=150000
+ W=2000000 AS=270000000000 AD=495000000000 PS=2540000 PD=3990000
* device instance $209 m90 *1 168.785,49.52 sky130_fd_pr__nfet_01v8
XM$209 VGND \$986 \$I14231 VGND sky130_fd_pr__nfet_01v8 L=150000 W=650000
+ AS=185250000000 AD=89375000000 PS=1870000 PD=925000
* device instance $210 m90 *1 168.36,49.52 sky130_fd_pr__nfet_01v8
XM$210 \$I14231 \$865 \$1008 VGND sky130_fd_pr__nfet_01v8 L=150000 W=650000
+ AS=89375000000 AD=91000000000 PS=925000 PD=930000
* device instance $211 m90 *1 167.93,49.52 sky130_fd_pr__nfet_01v8
XM$211 \$1008 \$865 \$I14232 VGND sky130_fd_pr__nfet_01v8 L=150000 W=650000
+ AS=91000000000 AD=68250000000 PS=930000 PD=860000
* device instance $212 m90 *1 167.57,49.52 sky130_fd_pr__nfet_01v8
XM$212 \$I14232 \$986 VGND VGND sky130_fd_pr__nfet_01v8 L=150000 W=650000
+ AS=68250000000 AD=107250000000 PS=860000 PD=980000
* device instance $213 m90 *1 167.09,49.52 sky130_fd_pr__nfet_01v8
XM$213 VGND \$866 \$1008 VGND sky130_fd_pr__nfet_01v8 L=150000 W=1300000
+ AS=195000000000 AD=347750000000 PS=1900000 PD=3020000
* device instance $215 m90 *1 80.47,56.385 sky130_fd_pr__pfet_01v8_hvt
XM$215 \$I14233 select VPWR VPWR sky130_fd_pr__pfet_01v8_hvt L=150000 W=2000000
+ AS=415000000000 AD=275000000000 PS=3830000 PD=2550000
* device instance $216 m90 *1 80.04,56.385 sky130_fd_pr__pfet_01v8_hvt
XM$216 VPWR I \$I14233 VPWR sky130_fd_pr__pfet_01v8_hvt L=150000 W=2000000
+ AS=280000000000 AD=275000000000 PS=2560000 PD=2550000
* device instance $219 m90 *1 78.77,56.385 sky130_fd_pr__pfet_01v8_hvt
XM$219 \$I14233 \$1126 \$1082 VPWR sky130_fd_pr__pfet_01v8_hvt L=150000
+ W=2000000 AS=270000000000 AD=495000000000 PS=2540000 PD=3990000
* device instance $221 m90 *1 80.465,54.96 sky130_fd_pr__nfet_01v8
XM$221 VGND select \$I14234 VGND sky130_fd_pr__nfet_01v8 L=150000 W=650000
+ AS=185250000000 AD=89375000000 PS=1870000 PD=925000
* device instance $222 m90 *1 80.04,54.96 sky130_fd_pr__nfet_01v8
XM$222 \$I14234 I \$1082 VGND sky130_fd_pr__nfet_01v8 L=150000 W=650000
+ AS=89375000000 AD=91000000000 PS=925000 PD=930000
* device instance $223 m90 *1 79.61,54.96 sky130_fd_pr__nfet_01v8
XM$223 \$1082 I \$I14235 VGND sky130_fd_pr__nfet_01v8 L=150000 W=650000
+ AS=91000000000 AD=68250000000 PS=930000 PD=860000
* device instance $224 m90 *1 79.25,54.96 sky130_fd_pr__nfet_01v8
XM$224 \$I14235 select VGND VGND sky130_fd_pr__nfet_01v8 L=150000 W=650000
+ AS=68250000000 AD=107250000000 PS=860000 PD=980000
* device instance $225 m90 *1 78.77,54.96 sky130_fd_pr__nfet_01v8
XM$225 VGND \$1126 \$1082 VGND sky130_fd_pr__nfet_01v8 L=150000 W=1300000
+ AS=195000000000 AD=347750000000 PS=1900000 PD=3020000
* device instance $227 m90 *1 81.39,99.905 sky130_fd_pr__pfet_01v8_hvt
XM$227 \$I14236 \$1650 VPWR VPWR sky130_fd_pr__pfet_01v8_hvt L=150000 W=2000000
+ AS=415000000000 AD=275000000000 PS=3830000 PD=2550000
* device instance $228 m90 *1 80.96,99.905 sky130_fd_pr__pfet_01v8_hvt
XM$228 VPWR \$1773 \$I14236 VPWR sky130_fd_pr__pfet_01v8_hvt L=150000 W=2000000
+ AS=280000000000 AD=275000000000 PS=2560000 PD=2550000
* device instance $231 m90 *1 79.69,99.905 sky130_fd_pr__pfet_01v8_hvt
XM$231 \$I14236 \$1695 \$1571 VPWR sky130_fd_pr__pfet_01v8_hvt L=150000
+ W=2000000 AS=270000000000 AD=495000000000 PS=2540000 PD=3990000
* device instance $233 m90 *1 81.385,98.48 sky130_fd_pr__nfet_01v8
XM$233 VGND \$1650 \$I14237 VGND sky130_fd_pr__nfet_01v8 L=150000 W=650000
+ AS=185250000000 AD=89375000000 PS=1870000 PD=925000
* device instance $234 m90 *1 80.96,98.48 sky130_fd_pr__nfet_01v8
XM$234 \$I14237 \$1773 \$1571 VGND sky130_fd_pr__nfet_01v8 L=150000 W=650000
+ AS=89375000000 AD=91000000000 PS=925000 PD=930000
* device instance $235 m90 *1 80.53,98.48 sky130_fd_pr__nfet_01v8
XM$235 \$1571 \$1773 \$I14238 VGND sky130_fd_pr__nfet_01v8 L=150000 W=650000
+ AS=91000000000 AD=68250000000 PS=930000 PD=860000
* device instance $236 m90 *1 80.17,98.48 sky130_fd_pr__nfet_01v8
XM$236 \$I14238 \$1650 VGND VGND sky130_fd_pr__nfet_01v8 L=150000 W=650000
+ AS=68250000000 AD=107250000000 PS=860000 PD=980000
* device instance $237 m90 *1 79.69,98.48 sky130_fd_pr__nfet_01v8
XM$237 VGND \$1695 \$1571 VGND sky130_fd_pr__nfet_01v8 L=150000 W=1300000
+ AS=195000000000 AD=347750000000 PS=1900000 PD=3020000
* device instance $239 m90 *1 167.41,219.585 sky130_fd_pr__pfet_01v8_hvt
XM$239 \$I14239 \$3490 VPWR VPWR sky130_fd_pr__pfet_01v8_hvt L=150000 W=2000000
+ AS=415000000000 AD=275000000000 PS=3830000 PD=2550000
* device instance $240 m90 *1 166.98,219.585 sky130_fd_pr__pfet_01v8_hvt
XM$240 VPWR \$3385 \$I14239 VPWR sky130_fd_pr__pfet_01v8_hvt L=150000 W=2000000
+ AS=280000000000 AD=275000000000 PS=2560000 PD=2550000
* device instance $243 m90 *1 165.71,219.585 sky130_fd_pr__pfet_01v8_hvt
XM$243 \$I14239 \$3435 \$3305 VPWR sky130_fd_pr__pfet_01v8_hvt L=150000
+ W=2000000 AS=270000000000 AD=495000000000 PS=2540000 PD=3990000
* device instance $245 m90 *1 167.405,218.16 sky130_fd_pr__nfet_01v8
XM$245 VGND \$3490 \$I14240 VGND sky130_fd_pr__nfet_01v8 L=150000 W=650000
+ AS=185250000000 AD=89375000000 PS=1870000 PD=925000
* device instance $246 m90 *1 166.98,218.16 sky130_fd_pr__nfet_01v8
XM$246 \$I14240 \$3385 \$3305 VGND sky130_fd_pr__nfet_01v8 L=150000 W=650000
+ AS=89375000000 AD=91000000000 PS=925000 PD=930000
* device instance $247 m90 *1 166.55,218.16 sky130_fd_pr__nfet_01v8
XM$247 \$3305 \$3385 \$I14241 VGND sky130_fd_pr__nfet_01v8 L=150000 W=650000
+ AS=91000000000 AD=68250000000 PS=930000 PD=860000
* device instance $248 m90 *1 166.19,218.16 sky130_fd_pr__nfet_01v8
XM$248 \$I14241 \$3490 VGND VGND sky130_fd_pr__nfet_01v8 L=150000 W=650000
+ AS=68250000000 AD=107250000000 PS=860000 PD=980000
* device instance $249 m90 *1 165.71,218.16 sky130_fd_pr__nfet_01v8
XM$249 VGND \$3435 \$3305 VGND sky130_fd_pr__nfet_01v8 L=150000 W=1300000
+ AS=195000000000 AD=347750000000 PS=1900000 PD=3020000
* device instance $251 m90 *1 180.75,203.265 sky130_fd_pr__pfet_01v8_hvt
XM$251 \$I14242 \$3085 VPWR VPWR sky130_fd_pr__pfet_01v8_hvt L=150000 W=2000000
+ AS=415000000000 AD=275000000000 PS=3830000 PD=2550000
* device instance $252 m90 *1 180.32,203.265 sky130_fd_pr__pfet_01v8_hvt
XM$252 VPWR \$3103 \$I14242 VPWR sky130_fd_pr__pfet_01v8_hvt L=150000 W=2000000
+ AS=280000000000 AD=275000000000 PS=2560000 PD=2550000
* device instance $255 m90 *1 179.05,203.265 sky130_fd_pr__pfet_01v8_hvt
XM$255 \$I14242 \$2681 \$3195 VPWR sky130_fd_pr__pfet_01v8_hvt L=150000
+ W=2000000 AS=270000000000 AD=495000000000 PS=2540000 PD=3990000
* device instance $257 m90 *1 180.745,201.84 sky130_fd_pr__nfet_01v8
XM$257 VGND \$3085 \$I14243 VGND sky130_fd_pr__nfet_01v8 L=150000 W=650000
+ AS=185250000000 AD=89375000000 PS=1870000 PD=925000
* device instance $258 m90 *1 180.32,201.84 sky130_fd_pr__nfet_01v8
XM$258 \$I14243 \$3103 \$3195 VGND sky130_fd_pr__nfet_01v8 L=150000 W=650000
+ AS=89375000000 AD=91000000000 PS=925000 PD=930000
* device instance $259 m90 *1 179.89,201.84 sky130_fd_pr__nfet_01v8
XM$259 \$3195 \$3103 \$I14244 VGND sky130_fd_pr__nfet_01v8 L=150000 W=650000
+ AS=91000000000 AD=68250000000 PS=930000 PD=860000
* device instance $260 m90 *1 179.53,201.84 sky130_fd_pr__nfet_01v8
XM$260 \$I14244 \$3085 VGND VGND sky130_fd_pr__nfet_01v8 L=150000 W=650000
+ AS=68250000000 AD=107250000000 PS=860000 PD=980000
* device instance $261 m90 *1 179.05,201.84 sky130_fd_pr__nfet_01v8
XM$261 VGND \$2681 \$3195 VGND sky130_fd_pr__nfet_01v8 L=150000 W=1300000
+ AS=195000000000 AD=347750000000 PS=1900000 PD=3020000
* device instance $263 m0 *1 158.27,36.095 sky130_fd_pr__pfet_01v8_hvt
XM$263 \$I14245 \$418 VPWR VPWR sky130_fd_pr__pfet_01v8_hvt L=150000 W=2000000
+ AS=415000000000 AD=275000000000 PS=3830000 PD=2550000
* device instance $264 m0 *1 158.7,36.095 sky130_fd_pr__pfet_01v8_hvt
XM$264 VPWR \$416 \$I14245 VPWR sky130_fd_pr__pfet_01v8_hvt L=150000 W=2000000
+ AS=280000000000 AD=275000000000 PS=2560000 PD=2550000
* device instance $267 m0 *1 159.97,36.095 sky130_fd_pr__pfet_01v8_hvt
XM$267 \$I14245 \$417 \$684 VPWR sky130_fd_pr__pfet_01v8_hvt L=150000 W=2000000
+ AS=270000000000 AD=495000000000 PS=2540000 PD=3990000
* device instance $269 m0 *1 158.275,37.52 sky130_fd_pr__nfet_01v8
XM$269 VGND \$418 \$I14246 VGND sky130_fd_pr__nfet_01v8 L=150000 W=650000
+ AS=185250000000 AD=89375000000 PS=1870000 PD=925000
* device instance $270 m0 *1 158.7,37.52 sky130_fd_pr__nfet_01v8
XM$270 \$I14246 \$416 \$684 VGND sky130_fd_pr__nfet_01v8 L=150000 W=650000
+ AS=89375000000 AD=91000000000 PS=925000 PD=930000
* device instance $271 m0 *1 159.13,37.52 sky130_fd_pr__nfet_01v8
XM$271 \$684 \$416 \$I14247 VGND sky130_fd_pr__nfet_01v8 L=150000 W=650000
+ AS=91000000000 AD=68250000000 PS=930000 PD=860000
* device instance $272 m0 *1 159.49,37.52 sky130_fd_pr__nfet_01v8
XM$272 \$I14247 \$418 VGND VGND sky130_fd_pr__nfet_01v8 L=150000 W=650000
+ AS=68250000000 AD=107250000000 PS=860000 PD=980000
* device instance $273 m0 *1 159.97,37.52 sky130_fd_pr__nfet_01v8
XM$273 VGND \$417 \$684 VGND sky130_fd_pr__nfet_01v8 L=150000 W=1300000
+ AS=195000000000 AD=347750000000 PS=1900000 PD=3020000
* device instance $275 m0 *1 172.53,155.775 sky130_fd_pr__pfet_01v8_hvt
XM$275 \$I14248 \$2314 VPWR VPWR sky130_fd_pr__pfet_01v8_hvt L=150000 W=2000000
+ AS=415000000000 AD=275000000000 PS=3830000 PD=2550000
* device instance $276 m0 *1 172.96,155.775 sky130_fd_pr__pfet_01v8_hvt
XM$276 VPWR \$1413 \$I14248 VPWR sky130_fd_pr__pfet_01v8_hvt L=150000 W=2000000
+ AS=280000000000 AD=275000000000 PS=2560000 PD=2550000
* device instance $279 m0 *1 174.23,155.775 sky130_fd_pr__pfet_01v8_hvt
XM$279 \$I14248 \$1527 \$2503 VPWR sky130_fd_pr__pfet_01v8_hvt L=150000
+ W=2000000 AS=270000000000 AD=495000000000 PS=2540000 PD=3990000
* device instance $281 m0 *1 172.535,157.2 sky130_fd_pr__nfet_01v8
XM$281 VGND \$2314 \$I14249 VGND sky130_fd_pr__nfet_01v8 L=150000 W=650000
+ AS=185250000000 AD=89375000000 PS=1870000 PD=925000
* device instance $282 m0 *1 172.96,157.2 sky130_fd_pr__nfet_01v8
XM$282 \$I14249 \$1413 \$2503 VGND sky130_fd_pr__nfet_01v8 L=150000 W=650000
+ AS=89375000000 AD=91000000000 PS=925000 PD=930000
* device instance $283 m0 *1 173.39,157.2 sky130_fd_pr__nfet_01v8
XM$283 \$2503 \$1413 \$I14250 VGND sky130_fd_pr__nfet_01v8 L=150000 W=650000
+ AS=91000000000 AD=68250000000 PS=930000 PD=860000
* device instance $284 m0 *1 173.75,157.2 sky130_fd_pr__nfet_01v8
XM$284 \$I14250 \$2314 VGND VGND sky130_fd_pr__nfet_01v8 L=150000 W=650000
+ AS=68250000000 AD=107250000000 PS=860000 PD=980000
* device instance $285 m0 *1 174.23,157.2 sky130_fd_pr__nfet_01v8
XM$285 VGND \$1527 \$2503 VGND sky130_fd_pr__nfet_01v8 L=150000 W=1300000
+ AS=195000000000 AD=347750000000 PS=1900000 PD=3020000
* device instance $287 m0 *1 177.13,112.255 sky130_fd_pr__pfet_01v8_hvt
XM$287 \$I14251 \$1363 VPWR VPWR sky130_fd_pr__pfet_01v8_hvt L=150000 W=2000000
+ AS=415000000000 AD=275000000000 PS=3830000 PD=2550000
* device instance $288 m0 *1 177.56,112.255 sky130_fd_pr__pfet_01v8_hvt
XM$288 VPWR \$1413 \$I14251 VPWR sky130_fd_pr__pfet_01v8_hvt L=150000 W=2000000
+ AS=280000000000 AD=275000000000 PS=2560000 PD=2550000
* device instance $291 m0 *1 178.83,112.255 sky130_fd_pr__pfet_01v8_hvt
XM$291 \$I14251 \$1527 \$1902 VPWR sky130_fd_pr__pfet_01v8_hvt L=150000
+ W=2000000 AS=270000000000 AD=495000000000 PS=2540000 PD=3990000
* device instance $293 m0 *1 177.135,113.68 sky130_fd_pr__nfet_01v8
XM$293 VGND \$1363 \$I14252 VGND sky130_fd_pr__nfet_01v8 L=150000 W=650000
+ AS=185250000000 AD=89375000000 PS=1870000 PD=925000
* device instance $294 m0 *1 177.56,113.68 sky130_fd_pr__nfet_01v8
XM$294 \$I14252 \$1413 \$1902 VGND sky130_fd_pr__nfet_01v8 L=150000 W=650000
+ AS=89375000000 AD=91000000000 PS=925000 PD=930000
* device instance $295 m0 *1 177.99,113.68 sky130_fd_pr__nfet_01v8
XM$295 \$1902 \$1413 \$I14253 VGND sky130_fd_pr__nfet_01v8 L=150000 W=650000
+ AS=91000000000 AD=68250000000 PS=930000 PD=860000
* device instance $296 m0 *1 178.35,113.68 sky130_fd_pr__nfet_01v8
XM$296 \$I14253 \$1363 VGND VGND sky130_fd_pr__nfet_01v8 L=150000 W=650000
+ AS=68250000000 AD=107250000000 PS=860000 PD=980000
* device instance $297 m0 *1 178.83,113.68 sky130_fd_pr__nfet_01v8
XM$297 VGND \$1527 \$1902 VGND sky130_fd_pr__nfet_01v8 L=150000 W=1300000
+ AS=195000000000 AD=347750000000 PS=1900000 PD=3020000
* device instance $299 r180 *1 39.07,150.335 sky130_fd_pr__pfet_01v8_hvt
XM$299 \$I14254 select VPWR VPWR sky130_fd_pr__pfet_01v8_hvt L=150000 W=2000000
+ AS=415000000000 AD=275000000000 PS=3830000 PD=2550000
* device instance $300 r180 *1 38.64,150.335 sky130_fd_pr__pfet_01v8_hvt
XM$300 VPWR \$340 \$I14254 VPWR sky130_fd_pr__pfet_01v8_hvt L=150000 W=2000000
+ AS=280000000000 AD=275000000000 PS=2560000 PD=2550000
* device instance $303 r180 *1 37.37,150.335 sky130_fd_pr__pfet_01v8_hvt
XM$303 \$I14254 \$27 \$2406 VPWR sky130_fd_pr__pfet_01v8_hvt L=150000 W=2000000
+ AS=270000000000 AD=495000000000 PS=2540000 PD=3990000
* device instance $305 r180 *1 39.065,151.76 sky130_fd_pr__nfet_01v8
XM$305 VGND select \$I14255 VGND sky130_fd_pr__nfet_01v8 L=150000 W=650000
+ AS=185250000000 AD=89375000000 PS=1870000 PD=925000
* device instance $306 r180 *1 38.64,151.76 sky130_fd_pr__nfet_01v8
XM$306 \$I14255 \$340 \$2406 VGND sky130_fd_pr__nfet_01v8 L=150000 W=650000
+ AS=89375000000 AD=91000000000 PS=925000 PD=930000
* device instance $307 r180 *1 38.21,151.76 sky130_fd_pr__nfet_01v8
XM$307 \$2406 \$340 \$I14256 VGND sky130_fd_pr__nfet_01v8 L=150000 W=650000
+ AS=91000000000 AD=68250000000 PS=930000 PD=860000
* device instance $308 r180 *1 37.85,151.76 sky130_fd_pr__nfet_01v8
XM$308 \$I14256 select VGND VGND sky130_fd_pr__nfet_01v8 L=150000 W=650000
+ AS=68250000000 AD=107250000000 PS=860000 PD=980000
* device instance $309 r180 *1 37.37,151.76 sky130_fd_pr__nfet_01v8
XM$309 VGND \$27 \$2406 VGND sky130_fd_pr__nfet_01v8 L=150000 W=1300000
+ AS=195000000000 AD=347750000000 PS=1900000 PD=3020000
* device instance $311 r180 *1 188.11,36.095 sky130_fd_pr__pfet_01v8_hvt
XM$311 \$I14257 \$157 VPWR VPWR sky130_fd_pr__pfet_01v8_hvt L=150000 W=2000000
+ AS=415000000000 AD=275000000000 PS=3830000 PD=2550000
* device instance $312 r180 *1 187.68,36.095 sky130_fd_pr__pfet_01v8_hvt
XM$312 VPWR \$413 \$I14257 VPWR sky130_fd_pr__pfet_01v8_hvt L=150000 W=2000000
+ AS=280000000000 AD=275000000000 PS=2560000 PD=2550000
* device instance $315 r180 *1 186.41,36.095 sky130_fd_pr__pfet_01v8_hvt
XM$315 \$I14257 \$147 \$635 VPWR sky130_fd_pr__pfet_01v8_hvt L=150000 W=2000000
+ AS=270000000000 AD=495000000000 PS=2540000 PD=3990000
* device instance $317 r180 *1 188.105,37.52 sky130_fd_pr__nfet_01v8
XM$317 VGND \$157 \$I14258 VGND sky130_fd_pr__nfet_01v8 L=150000 W=650000
+ AS=185250000000 AD=89375000000 PS=1870000 PD=925000
* device instance $318 r180 *1 187.68,37.52 sky130_fd_pr__nfet_01v8
XM$318 \$I14258 \$413 \$635 VGND sky130_fd_pr__nfet_01v8 L=150000 W=650000
+ AS=89375000000 AD=91000000000 PS=925000 PD=930000
* device instance $319 r180 *1 187.25,37.52 sky130_fd_pr__nfet_01v8
XM$319 \$635 \$413 \$I14259 VGND sky130_fd_pr__nfet_01v8 L=150000 W=650000
+ AS=91000000000 AD=68250000000 PS=930000 PD=860000
* device instance $320 r180 *1 186.89,37.52 sky130_fd_pr__nfet_01v8
XM$320 \$I14259 \$157 VGND VGND sky130_fd_pr__nfet_01v8 L=150000 W=650000
+ AS=68250000000 AD=107250000000 PS=860000 PD=980000
* device instance $321 r180 *1 186.41,37.52 sky130_fd_pr__nfet_01v8
XM$321 VGND \$147 \$635 VGND sky130_fd_pr__nfet_01v8 L=150000 W=1300000
+ AS=195000000000 AD=347750000000 PS=1900000 PD=3020000
* device instance $323 r180 *1 160.97,41.535 sky130_fd_pr__pfet_01v8_hvt
XM$323 \$I14260 \$653 VPWR VPWR sky130_fd_pr__pfet_01v8_hvt L=150000 W=2000000
+ AS=415000000000 AD=275000000000 PS=3830000 PD=2550000
* device instance $324 r180 *1 160.54,41.535 sky130_fd_pr__pfet_01v8_hvt
XM$324 VPWR \$589 \$I14260 VPWR sky130_fd_pr__pfet_01v8_hvt L=150000 W=2000000
+ AS=280000000000 AD=275000000000 PS=2560000 PD=2550000
* device instance $327 r180 *1 159.27,41.535 sky130_fd_pr__pfet_01v8_hvt
XM$327 \$I14260 \$427 \$791 VPWR sky130_fd_pr__pfet_01v8_hvt L=150000 W=2000000
+ AS=270000000000 AD=495000000000 PS=2540000 PD=3990000
* device instance $329 r180 *1 160.965,42.96 sky130_fd_pr__nfet_01v8
XM$329 VGND \$653 \$I14261 VGND sky130_fd_pr__nfet_01v8 L=150000 W=650000
+ AS=185250000000 AD=89375000000 PS=1870000 PD=925000
* device instance $330 r180 *1 160.54,42.96 sky130_fd_pr__nfet_01v8
XM$330 \$I14261 \$589 \$791 VGND sky130_fd_pr__nfet_01v8 L=150000 W=650000
+ AS=89375000000 AD=91000000000 PS=925000 PD=930000
* device instance $331 r180 *1 160.11,42.96 sky130_fd_pr__nfet_01v8
XM$331 \$791 \$589 \$I14262 VGND sky130_fd_pr__nfet_01v8 L=150000 W=650000
+ AS=91000000000 AD=68250000000 PS=930000 PD=860000
* device instance $332 r180 *1 159.75,42.96 sky130_fd_pr__nfet_01v8
XM$332 \$I14262 \$653 VGND VGND sky130_fd_pr__nfet_01v8 L=150000 W=650000
+ AS=68250000000 AD=107250000000 PS=860000 PD=980000
* device instance $333 r180 *1 159.27,42.96 sky130_fd_pr__nfet_01v8
XM$333 VGND \$427 \$791 VGND sky130_fd_pr__nfet_01v8 L=150000 W=1300000
+ AS=195000000000 AD=347750000000 PS=1900000 PD=3020000
* device instance $335 r180 *1 170.63,128.575 sky130_fd_pr__pfet_01v8_hvt
XM$335 \$I14263 \$2029 VPWR VPWR sky130_fd_pr__pfet_01v8_hvt L=150000 W=2000000
+ AS=415000000000 AD=275000000000 PS=3830000 PD=2550000
* device instance $336 r180 *1 170.2,128.575 sky130_fd_pr__pfet_01v8_hvt
XM$336 VPWR \$2043 \$I14263 VPWR sky130_fd_pr__pfet_01v8_hvt L=150000 W=2000000
+ AS=280000000000 AD=275000000000 PS=2560000 PD=2550000
* device instance $339 r180 *1 168.93,128.575 sky130_fd_pr__pfet_01v8_hvt
XM$339 \$I14263 \$2048 \$2049 VPWR sky130_fd_pr__pfet_01v8_hvt L=150000
+ W=2000000 AS=270000000000 AD=495000000000 PS=2540000 PD=3990000
* device instance $341 r180 *1 170.625,130 sky130_fd_pr__nfet_01v8
XM$341 VGND \$2029 \$I14264 VGND sky130_fd_pr__nfet_01v8 L=150000 W=650000
+ AS=185250000000 AD=89375000000 PS=1870000 PD=925000
* device instance $342 r180 *1 170.2,130 sky130_fd_pr__nfet_01v8
XM$342 \$I14264 \$2043 \$2049 VGND sky130_fd_pr__nfet_01v8 L=150000 W=650000
+ AS=89375000000 AD=91000000000 PS=925000 PD=930000
* device instance $343 r180 *1 169.77,130 sky130_fd_pr__nfet_01v8
XM$343 \$2049 \$2043 \$I14265 VGND sky130_fd_pr__nfet_01v8 L=150000 W=650000
+ AS=91000000000 AD=68250000000 PS=930000 PD=860000
* device instance $344 r180 *1 169.41,130 sky130_fd_pr__nfet_01v8
XM$344 \$I14265 \$2029 VGND VGND sky130_fd_pr__nfet_01v8 L=150000 W=650000
+ AS=68250000000 AD=107250000000 PS=860000 PD=980000
* device instance $345 r180 *1 168.93,130 sky130_fd_pr__nfet_01v8
XM$345 VGND \$2048 \$2049 VGND sky130_fd_pr__nfet_01v8 L=150000 W=1300000
+ AS=195000000000 AD=347750000000 PS=1900000 PD=3020000
* device instance $347 r0 *1 182.65,45.505 sky130_fd_pr__pfet_01v8_hvt
XM$347 \$I14266 \$443 VPWR VPWR sky130_fd_pr__pfet_01v8_hvt L=150000 W=2000000
+ AS=415000000000 AD=275000000000 PS=3830000 PD=2550000
* device instance $348 r0 *1 183.08,45.505 sky130_fd_pr__pfet_01v8_hvt
XM$348 VPWR \$572 \$I14266 VPWR sky130_fd_pr__pfet_01v8_hvt L=150000 W=2000000
+ AS=280000000000 AD=275000000000 PS=2560000 PD=2550000
* device instance $351 r0 *1 184.35,45.505 sky130_fd_pr__pfet_01v8_hvt
XM$351 \$I14266 \$49 \$795 VPWR sky130_fd_pr__pfet_01v8_hvt L=150000 W=2000000
+ AS=270000000000 AD=495000000000 PS=2540000 PD=3990000
* device instance $353 r0 *1 182.655,44.08 sky130_fd_pr__nfet_01v8
XM$353 VGND \$443 \$I14267 VGND sky130_fd_pr__nfet_01v8 L=150000 W=650000
+ AS=185250000000 AD=89375000000 PS=1870000 PD=925000
* device instance $354 r0 *1 183.08,44.08 sky130_fd_pr__nfet_01v8
XM$354 \$I14267 \$572 \$795 VGND sky130_fd_pr__nfet_01v8 L=150000 W=650000
+ AS=89375000000 AD=91000000000 PS=925000 PD=930000
* device instance $355 r0 *1 183.51,44.08 sky130_fd_pr__nfet_01v8
XM$355 \$795 \$572 \$I14268 VGND sky130_fd_pr__nfet_01v8 L=150000 W=650000
+ AS=91000000000 AD=68250000000 PS=930000 PD=860000
* device instance $356 r0 *1 183.87,44.08 sky130_fd_pr__nfet_01v8
XM$356 \$I14268 \$443 VGND VGND sky130_fd_pr__nfet_01v8 L=150000 W=650000
+ AS=68250000000 AD=107250000000 PS=860000 PD=980000
* device instance $357 r0 *1 184.35,44.08 sky130_fd_pr__nfet_01v8
XM$357 VGND \$49 \$795 VGND sky130_fd_pr__nfet_01v8 L=150000 W=1300000
+ AS=195000000000 AD=347750000000 PS=1900000 PD=3020000
* device instance $359 r0 *1 157.81,40.065 sky130_fd_pr__pfet_01v8_hvt
XM$359 \$I14269 \$654 VPWR VPWR sky130_fd_pr__pfet_01v8_hvt L=150000 W=2000000
+ AS=415000000000 AD=275000000000 PS=3830000 PD=2550000
* device instance $360 r0 *1 158.24,40.065 sky130_fd_pr__pfet_01v8_hvt
XM$360 VPWR \$418 \$I14269 VPWR sky130_fd_pr__pfet_01v8_hvt L=150000 W=2000000
+ AS=280000000000 AD=275000000000 PS=2560000 PD=2550000
* device instance $363 r0 *1 159.51,40.065 sky130_fd_pr__pfet_01v8_hvt
XM$363 \$I14269 \$606 \$702 VPWR sky130_fd_pr__pfet_01v8_hvt L=150000 W=2000000
+ AS=270000000000 AD=495000000000 PS=2540000 PD=3990000
* device instance $365 r0 *1 157.815,38.64 sky130_fd_pr__nfet_01v8
XM$365 VGND \$654 \$I14270 VGND sky130_fd_pr__nfet_01v8 L=150000 W=650000
+ AS=185250000000 AD=89375000000 PS=1870000 PD=925000
* device instance $366 r0 *1 158.24,38.64 sky130_fd_pr__nfet_01v8
XM$366 \$I14270 \$418 \$702 VGND sky130_fd_pr__nfet_01v8 L=150000 W=650000
+ AS=89375000000 AD=91000000000 PS=925000 PD=930000
* device instance $367 r0 *1 158.67,38.64 sky130_fd_pr__nfet_01v8
XM$367 \$702 \$418 \$I14271 VGND sky130_fd_pr__nfet_01v8 L=150000 W=650000
+ AS=91000000000 AD=68250000000 PS=930000 PD=860000
* device instance $368 r0 *1 159.03,38.64 sky130_fd_pr__nfet_01v8
XM$368 \$I14271 \$654 VGND VGND sky130_fd_pr__nfet_01v8 L=150000 W=650000
+ AS=68250000000 AD=107250000000 PS=860000 PD=980000
* device instance $369 r0 *1 159.51,38.64 sky130_fd_pr__nfet_01v8
XM$369 VGND \$606 \$702 VGND sky130_fd_pr__nfet_01v8 L=150000 W=1300000
+ AS=195000000000 AD=347750000000 PS=1900000 PD=3020000
* device instance $371 r0 *1 155.97,34.625 sky130_fd_pr__pfet_01v8_hvt
XM$371 \$I14272 \$486 VPWR VPWR sky130_fd_pr__pfet_01v8_hvt L=150000 W=2000000
+ AS=415000000000 AD=275000000000 PS=3830000 PD=2550000
* device instance $372 r0 *1 156.4,34.625 sky130_fd_pr__pfet_01v8_hvt
XM$372 VPWR \$416 \$I14272 VPWR sky130_fd_pr__pfet_01v8_hvt L=150000 W=2000000
+ AS=280000000000 AD=275000000000 PS=2560000 PD=2550000
* device instance $375 r0 *1 157.67,34.625 sky130_fd_pr__pfet_01v8_hvt
XM$375 \$I14272 \$351 \$382 VPWR sky130_fd_pr__pfet_01v8_hvt L=150000 W=2000000
+ AS=270000000000 AD=495000000000 PS=2540000 PD=3990000
* device instance $377 r0 *1 155.975,33.2 sky130_fd_pr__nfet_01v8
XM$377 VGND \$486 \$I14273 VGND sky130_fd_pr__nfet_01v8 L=150000 W=650000
+ AS=185250000000 AD=89375000000 PS=1870000 PD=925000
* device instance $378 r0 *1 156.4,33.2 sky130_fd_pr__nfet_01v8
XM$378 \$I14273 \$416 \$382 VGND sky130_fd_pr__nfet_01v8 L=150000 W=650000
+ AS=89375000000 AD=91000000000 PS=925000 PD=930000
* device instance $379 r0 *1 156.83,33.2 sky130_fd_pr__nfet_01v8
XM$379 \$382 \$416 \$I14274 VGND sky130_fd_pr__nfet_01v8 L=150000 W=650000
+ AS=91000000000 AD=68250000000 PS=930000 PD=860000
* device instance $380 r0 *1 157.19,33.2 sky130_fd_pr__nfet_01v8
XM$380 \$I14274 \$486 VGND VGND sky130_fd_pr__nfet_01v8 L=150000 W=650000
+ AS=68250000000 AD=107250000000 PS=860000 PD=980000
* device instance $381 r0 *1 157.67,33.2 sky130_fd_pr__nfet_01v8
XM$381 VGND \$351 \$382 VGND sky130_fd_pr__nfet_01v8 L=150000 W=1300000
+ AS=195000000000 AD=347750000000 PS=1900000 PD=3020000
* device instance $383 r0 *1 158.27,176.065 sky130_fd_pr__pfet_01v8_hvt
XM$383 \$I14275 \$2714 VPWR VPWR sky130_fd_pr__pfet_01v8_hvt L=150000 W=2000000
+ AS=415000000000 AD=275000000000 PS=3830000 PD=2550000
* device instance $384 r0 *1 158.7,176.065 sky130_fd_pr__pfet_01v8_hvt
XM$384 VPWR \$2705 \$I14275 VPWR sky130_fd_pr__pfet_01v8_hvt L=150000 W=2000000
+ AS=280000000000 AD=275000000000 PS=2560000 PD=2550000
* device instance $387 r0 *1 159.97,176.065 sky130_fd_pr__pfet_01v8_hvt
XM$387 \$I14275 \$2657 \$2704 VPWR sky130_fd_pr__pfet_01v8_hvt L=150000
+ W=2000000 AS=270000000000 AD=495000000000 PS=2540000 PD=3990000
* device instance $389 r0 *1 158.275,174.64 sky130_fd_pr__nfet_01v8
XM$389 VGND \$2714 \$I14276 VGND sky130_fd_pr__nfet_01v8 L=150000 W=650000
+ AS=185250000000 AD=89375000000 PS=1870000 PD=925000
* device instance $390 r0 *1 158.7,174.64 sky130_fd_pr__nfet_01v8
XM$390 \$I14276 \$2705 \$2704 VGND sky130_fd_pr__nfet_01v8 L=150000 W=650000
+ AS=89375000000 AD=91000000000 PS=925000 PD=930000
* device instance $391 r0 *1 159.13,174.64 sky130_fd_pr__nfet_01v8
XM$391 \$2704 \$2705 \$I14277 VGND sky130_fd_pr__nfet_01v8 L=150000 W=650000
+ AS=91000000000 AD=68250000000 PS=930000 PD=860000
* device instance $392 r0 *1 159.49,174.64 sky130_fd_pr__nfet_01v8
XM$392 \$I14277 \$2714 VGND VGND sky130_fd_pr__nfet_01v8 L=150000 W=650000
+ AS=68250000000 AD=107250000000 PS=860000 PD=980000
* device instance $393 r0 *1 159.97,174.64 sky130_fd_pr__nfet_01v8
XM$393 VGND \$2657 \$2704 VGND sky130_fd_pr__nfet_01v8 L=150000 W=1300000
+ AS=195000000000 AD=347750000000 PS=1900000 PD=3020000
* device instance $395 r0 *1 159.65,29.185 sky130_fd_pr__pfet_01v8_hvt
XM$395 \$I14278 \$181 VPWR VPWR sky130_fd_pr__pfet_01v8_hvt L=150000 W=2000000
+ AS=415000000000 AD=275000000000 PS=3830000 PD=2550000
* device instance $396 r0 *1 160.08,29.185 sky130_fd_pr__pfet_01v8_hvt
XM$396 VPWR \$31 \$I14278 VPWR sky130_fd_pr__pfet_01v8_hvt L=150000 W=2000000
+ AS=280000000000 AD=275000000000 PS=2560000 PD=2550000
* device instance $399 r0 *1 161.35,29.185 sky130_fd_pr__pfet_01v8_hvt
XM$399 \$I14278 \$49 \$169 VPWR sky130_fd_pr__pfet_01v8_hvt L=150000 W=2000000
+ AS=270000000000 AD=495000000000 PS=2540000 PD=3990000
* device instance $401 r0 *1 159.655,27.76 sky130_fd_pr__nfet_01v8
XM$401 VGND \$181 \$I14279 VGND sky130_fd_pr__nfet_01v8 L=150000 W=650000
+ AS=185250000000 AD=89375000000 PS=1870000 PD=925000
* device instance $402 r0 *1 160.08,27.76 sky130_fd_pr__nfet_01v8
XM$402 \$I14279 \$31 \$169 VGND sky130_fd_pr__nfet_01v8 L=150000 W=650000
+ AS=89375000000 AD=91000000000 PS=925000 PD=930000
* device instance $403 r0 *1 160.51,27.76 sky130_fd_pr__nfet_01v8
XM$403 \$169 \$31 \$I14280 VGND sky130_fd_pr__nfet_01v8 L=150000 W=650000
+ AS=91000000000 AD=68250000000 PS=930000 PD=860000
* device instance $404 r0 *1 160.87,27.76 sky130_fd_pr__nfet_01v8
XM$404 \$I14280 \$181 VGND VGND sky130_fd_pr__nfet_01v8 L=150000 W=650000
+ AS=68250000000 AD=107250000000 PS=860000 PD=980000
* device instance $405 r0 *1 161.35,27.76 sky130_fd_pr__nfet_01v8
XM$405 VGND \$49 \$169 VGND sky130_fd_pr__nfet_01v8 L=150000 W=1300000
+ AS=195000000000 AD=347750000000 PS=1900000 PD=3020000
* device instance $407 r0 *1 168.39,132.545 sky130_fd_pr__pfet_01v8_hvt
XM$407 \$I14281 \$1527 VPWR VPWR sky130_fd_pr__pfet_01v8_hvt L=150000 W=2000000
+ AS=415000000000 AD=275000000000 PS=3830000 PD=2550000
* device instance $408 r0 *1 168.82,132.545 sky130_fd_pr__pfet_01v8_hvt
XM$408 VPWR \$1413 \$I14281 VPWR sky130_fd_pr__pfet_01v8_hvt L=150000 W=2000000
+ AS=280000000000 AD=275000000000 PS=2560000 PD=2550000
* device instance $411 r0 *1 170.09,132.545 sky130_fd_pr__pfet_01v8_hvt
XM$411 \$I14281 \$1362 \$2084 VPWR sky130_fd_pr__pfet_01v8_hvt L=150000
+ W=2000000 AS=270000000000 AD=495000000000 PS=2540000 PD=3990000
* device instance $413 r0 *1 168.395,131.12 sky130_fd_pr__nfet_01v8
XM$413 VGND \$1527 \$I14282 VGND sky130_fd_pr__nfet_01v8 L=150000 W=650000
+ AS=185250000000 AD=89375000000 PS=1870000 PD=925000
* device instance $414 r0 *1 168.82,131.12 sky130_fd_pr__nfet_01v8
XM$414 \$I14282 \$1413 \$2084 VGND sky130_fd_pr__nfet_01v8 L=150000 W=650000
+ AS=89375000000 AD=91000000000 PS=925000 PD=930000
* device instance $415 r0 *1 169.25,131.12 sky130_fd_pr__nfet_01v8
XM$415 \$2084 \$1413 \$I14283 VGND sky130_fd_pr__nfet_01v8 L=150000 W=650000
+ AS=91000000000 AD=68250000000 PS=930000 PD=860000
* device instance $416 r0 *1 169.61,131.12 sky130_fd_pr__nfet_01v8
XM$416 \$I14283 \$1527 VGND VGND sky130_fd_pr__nfet_01v8 L=150000 W=650000
+ AS=68250000000 AD=107250000000 PS=860000 PD=980000
* device instance $417 r0 *1 170.09,131.12 sky130_fd_pr__nfet_01v8
XM$417 VGND \$1362 \$2084 VGND sky130_fd_pr__nfet_01v8 L=150000 W=1300000
+ AS=195000000000 AD=347750000000 PS=1900000 PD=3020000
* device instance $419 r0 *1 178.51,94.465 sky130_fd_pr__pfet_01v8_hvt
XM$419 \$I14284 \$1363 VPWR VPWR sky130_fd_pr__pfet_01v8_hvt L=150000 W=2000000
+ AS=415000000000 AD=275000000000 PS=3830000 PD=2550000
* device instance $420 r0 *1 178.94,94.465 sky130_fd_pr__pfet_01v8_hvt
XM$420 VPWR \$1413 \$I14284 VPWR sky130_fd_pr__pfet_01v8_hvt L=150000 W=2000000
+ AS=280000000000 AD=275000000000 PS=2560000 PD=2550000
* device instance $423 r0 *1 180.21,94.465 sky130_fd_pr__pfet_01v8_hvt
XM$423 \$I14284 \$1527 \$1469 VPWR sky130_fd_pr__pfet_01v8_hvt L=150000
+ W=2000000 AS=270000000000 AD=495000000000 PS=2540000 PD=3990000
* device instance $425 r0 *1 178.515,93.04 sky130_fd_pr__nfet_01v8
XM$425 VGND \$1363 \$I14285 VGND sky130_fd_pr__nfet_01v8 L=150000 W=650000
+ AS=185250000000 AD=89375000000 PS=1870000 PD=925000
* device instance $426 r0 *1 178.94,93.04 sky130_fd_pr__nfet_01v8
XM$426 \$I14285 \$1413 \$1469 VGND sky130_fd_pr__nfet_01v8 L=150000 W=650000
+ AS=89375000000 AD=91000000000 PS=925000 PD=930000
* device instance $427 r0 *1 179.37,93.04 sky130_fd_pr__nfet_01v8
XM$427 \$1469 \$1413 \$I14286 VGND sky130_fd_pr__nfet_01v8 L=150000 W=650000
+ AS=91000000000 AD=68250000000 PS=930000 PD=860000
* device instance $428 r0 *1 179.73,93.04 sky130_fd_pr__nfet_01v8
XM$428 \$I14286 \$1363 VGND VGND sky130_fd_pr__nfet_01v8 L=150000 W=650000
+ AS=68250000000 AD=107250000000 PS=860000 PD=980000
* device instance $429 r0 *1 180.21,93.04 sky130_fd_pr__nfet_01v8
XM$429 VGND \$1527 \$1469 VGND sky130_fd_pr__nfet_01v8 L=150000 W=1300000
+ AS=195000000000 AD=347750000000 PS=1900000 PD=3020000
* device instance $431 m0 *1 178.05,14.335 sky130_fd_pr__pfet_01v8_hvt
XM$431 \$I14287 \$100 VPWR VPWR sky130_fd_pr__pfet_01v8_hvt L=150000 W=2000000
+ AS=415000000000 AD=275000000000 PS=3830000 PD=2550000
* device instance $432 m0 *1 178.48,14.335 sky130_fd_pr__pfet_01v8_hvt
XM$432 VPWR \$35 \$I14287 VPWR sky130_fd_pr__pfet_01v8_hvt L=150000 W=2000000
+ AS=280000000000 AD=275000000000 PS=2560000 PD=2550000
* device instance $435 m0 *1 179.75,14.335 sky130_fd_pr__pfet_01v8_hvt
XM$435 \$I14287 \$58 \$55 VPWR sky130_fd_pr__pfet_01v8_hvt L=150000 W=2000000
+ AS=270000000000 AD=495000000000 PS=2540000 PD=3990000
* device instance $437 m0 *1 178.055,15.76 sky130_fd_pr__nfet_01v8
XM$437 VGND \$100 \$I14288 VGND sky130_fd_pr__nfet_01v8 L=150000 W=650000
+ AS=185250000000 AD=89375000000 PS=1870000 PD=925000
* device instance $438 m0 *1 178.48,15.76 sky130_fd_pr__nfet_01v8
XM$438 \$I14288 \$35 \$55 VGND sky130_fd_pr__nfet_01v8 L=150000 W=650000
+ AS=89375000000 AD=91000000000 PS=925000 PD=930000
* device instance $439 m0 *1 178.91,15.76 sky130_fd_pr__nfet_01v8
XM$439 \$55 \$35 \$I14289 VGND sky130_fd_pr__nfet_01v8 L=150000 W=650000
+ AS=91000000000 AD=68250000000 PS=930000 PD=860000
* device instance $440 m0 *1 179.27,15.76 sky130_fd_pr__nfet_01v8
XM$440 \$I14289 \$100 VGND VGND sky130_fd_pr__nfet_01v8 L=150000 W=650000
+ AS=68250000000 AD=107250000000 PS=860000 PD=980000
* device instance $441 m0 *1 179.75,15.76 sky130_fd_pr__nfet_01v8
XM$441 VGND \$58 \$55 VGND sky130_fd_pr__nfet_01v8 L=150000 W=1300000
+ AS=195000000000 AD=347750000000 PS=1900000 PD=3020000
.ENDS puzzle

* cell sky130_fd_sc_hd__o31ai_2
* pin VGND
* pin A1
* pin A2
* pin A3
* pin Y
* pin B1
* pin VPWR
* pin VPB
* pin sky130_gnd
.SUBCKT sky130_fd_sc_hd__o31ai_2 VGND A1 A2 A3 Y B1 VPWR VPB sky130_gnd
* device instance $1 r0 *1 2.71,1.985 sky130_fd_pr__pfet_01v8_hvt
XM$1 Y A3 \$12 VPB sky130_fd_pr__pfet_01v8_hvt L=150000 W=2000000
+ AS=415000000000 AD=270000000000 PS=3830000 PD=2540000
* device instance $3 r0 *1 3.55,1.985 sky130_fd_pr__pfet_01v8_hvt
XM$3 Y B1 VPWR VPB sky130_fd_pr__pfet_01v8_hvt L=150000 W=2000000
+ AS=330000000000 AD=455000000000 PS=2660000 PD=3910000
* device instance $5 r0 *1 0.49,1.985 sky130_fd_pr__pfet_01v8_hvt
XM$5 \$9 A1 VPWR VPB sky130_fd_pr__pfet_01v8_hvt L=150000 W=2000000
+ AS=415000000000 AD=270000000000 PS=3830000 PD=2540000
* device instance $7 r0 *1 1.33,1.985 sky130_fd_pr__pfet_01v8_hvt
XM$7 \$9 A2 \$12 VPB sky130_fd_pr__pfet_01v8_hvt L=150000 W=2000000
+ AS=270000000000 AD=395000000000 PS=2540000 PD=3790000
* device instance $9 r0 *1 0.49,0.56 sky130_fd_pr__nfet_01v8
XM$9 \$3 A1 VGND sky130_gnd sky130_fd_pr__nfet_01v8 L=150000 W=1300000
+ AS=269750000000 AD=175500000000 PS=2780000 PD=1840000
* device instance $11 r0 *1 1.33,0.56 sky130_fd_pr__nfet_01v8
XM$11 \$3 A2 VGND sky130_gnd sky130_fd_pr__nfet_01v8 L=150000 W=1300000
+ AS=286000000000 AD=325000000000 PS=2180000 PD=2300000
* device instance $13 r0 *1 2.63,0.56 sky130_fd_pr__nfet_01v8
XM$13 \$3 A3 VGND sky130_gnd sky130_fd_pr__nfet_01v8 L=150000 W=1300000
+ AS=240500000000 AD=201500000000 PS=2040000 PD=1920000
* device instance $15 r0 *1 3.55,0.56 sky130_fd_pr__nfet_01v8
XM$15 \$3 B1 Y sky130_gnd sky130_fd_pr__nfet_01v8 L=150000 W=1300000
+ AS=214500000000 AD=295750000000 PS=1960000 PD=2860000
.ENDS sky130_fd_sc_hd__o31ai_2

* cell sky130_fd_sc_hd__a21bo_2
* pin VPB
* pin VPWR
* pin VGND
* pin X
* pin B1_N
* pin A1
* pin A2
* pin sky130_gnd
.SUBCKT sky130_fd_sc_hd__a21bo_2 VPB VPWR VGND X B1_N A1 A2 sky130_gnd
* device instance $1 r0 *1 2.35,1.985 sky130_fd_pr__pfet_01v8_hvt
XM$1 \$8 \$7 \$2 VPB sky130_fd_pr__pfet_01v8_hvt L=150000 W=1000000
+ AS=260000000000 AD=135000000000 PS=2520000 PD=1270000
* device instance $2 r0 *1 2.77,1.985 sky130_fd_pr__pfet_01v8_hvt
XM$2 \$2 A1 VPWR VPB sky130_fd_pr__pfet_01v8_hvt L=150000 W=1000000
+ AS=135000000000 AD=135000000000 PS=1270000 PD=1270000
* device instance $3 r0 *1 3.19,1.985 sky130_fd_pr__pfet_01v8_hvt
XM$3 VPWR A2 \$2 VPB sky130_fd_pr__pfet_01v8_hvt L=150000 W=1000000
+ AS=135000000000 AD=260000000000 PS=1270000 PD=2520000
* device instance $4 r0 *1 1.41,1.695 sky130_fd_pr__pfet_01v8_hvt
XM$4 VPWR B1_N \$7 VPB sky130_fd_pr__pfet_01v8_hvt L=150000 W=420000
+ AS=181500000000 AD=109200000000 PS=1510000 PD=1360000
* device instance $5 r0 *1 0.47,1.985 sky130_fd_pr__pfet_01v8_hvt
XM$5 VPWR \$8 X VPB sky130_fd_pr__pfet_01v8_hvt L=150000 W=2000000
+ AS=400000000000 AD=321500000000 PS=3800000 PD=2790000
* device instance $7 r0 *1 2.35,0.56 sky130_fd_pr__nfet_01v8
XM$7 VGND \$7 \$8 sky130_gnd sky130_fd_pr__nfet_01v8 L=150000 W=650000
+ AS=169000000000 AD=107250000000 PS=1820000 PD=980000
* device instance $8 r0 *1 2.83,0.56 sky130_fd_pr__nfet_01v8
XM$8 \$8 A1 \$12 sky130_gnd sky130_fd_pr__nfet_01v8 L=150000 W=650000
+ AS=107250000000 AD=68250000000 PS=980000 PD=860000
* device instance $9 r0 *1 3.19,0.56 sky130_fd_pr__nfet_01v8
XM$9 \$12 A2 VGND sky130_gnd sky130_fd_pr__nfet_01v8 L=150000 W=650000
+ AS=68250000000 AD=169000000000 PS=860000 PD=1820000
* device instance $10 r0 *1 0.47,0.56 sky130_fd_pr__nfet_01v8
XM$10 VGND \$8 X sky130_gnd sky130_fd_pr__nfet_01v8 L=150000 W=1300000
+ AS=260000000000 AD=199375000000 PS=2750000 PD=1940000
* device instance $12 r0 *1 1.41,0.675 sky130_fd_pr__nfet_01v8
XM$12 VGND B1_N \$7 sky130_gnd sky130_fd_pr__nfet_01v8 L=150000 W=420000
+ AS=108375000000 AD=109200000000 PS=1010000 PD=1360000
.ENDS sky130_fd_sc_hd__a21bo_2

* cell sky130_fd_sc_hd__o211ai_2
* pin VGND
* pin Y
* pin A1
* pin C1
* pin B1
* pin A2
* pin VPWR
* pin VPB
* pin sky130_gnd
.SUBCKT sky130_fd_sc_hd__o211ai_2 VGND Y A1 C1 B1 A2 VPWR VPB sky130_gnd
* device instance $1 r0 *1 2.775,1.985 sky130_fd_pr__pfet_01v8_hvt
XM$1 \$10 A2 Y VPB sky130_fd_pr__pfet_01v8_hvt L=150000 W=2000000
+ AS=405000000000 AD=280000000000 PS=3810000 PD=2560000
* device instance $3 r0 *1 3.635,1.985 sky130_fd_pr__pfet_01v8_hvt
XM$3 \$10 A1 VPWR VPB sky130_fd_pr__pfet_01v8_hvt L=150000 W=2000000
+ AS=280000000000 AD=405000000000 PS=2560000 PD=3810000
* device instance $5 r0 *1 0.495,1.985 sky130_fd_pr__pfet_01v8_hvt
XM$5 VPWR C1 Y VPB sky130_fd_pr__pfet_01v8_hvt L=150000 W=2000000
+ AS=405000000000 AD=280000000000 PS=3810000 PD=2560000
* device instance $7 r0 *1 1.355,1.985 sky130_fd_pr__pfet_01v8_hvt
XM$7 VPWR B1 Y VPB sky130_fd_pr__pfet_01v8_hvt L=150000 W=2000000
+ AS=280000000000 AD=405000000000 PS=2560000 PD=3810000
* device instance $9 r0 *1 2.775,0.56 sky130_fd_pr__nfet_01v8
XM$9 VGND A2 \$5 sky130_gnd sky130_fd_pr__nfet_01v8 L=150000 W=1300000
+ AS=276250000000 AD=182000000000 PS=2800000 PD=1860000
* device instance $11 r0 *1 3.635,0.56 sky130_fd_pr__nfet_01v8
XM$11 VGND A1 \$5 sky130_gnd sky130_fd_pr__nfet_01v8 L=150000 W=1300000
+ AS=182000000000 AD=276250000000 PS=1860000 PD=2800000
* device instance $13 r0 *1 0.495,0.56 sky130_fd_pr__nfet_01v8
XM$13 \$3 C1 Y sky130_gnd sky130_fd_pr__nfet_01v8 L=150000 W=1300000
+ AS=276250000000 AD=182000000000 PS=2800000 PD=1860000
* device instance $15 r0 *1 1.355,0.56 sky130_fd_pr__nfet_01v8
XM$15 \$3 B1 \$5 sky130_gnd sky130_fd_pr__nfet_01v8 L=150000 W=1300000
+ AS=182000000000 AD=276250000000 PS=1860000 PD=2800000
.ENDS sky130_fd_sc_hd__o211ai_2

* cell sky130_fd_sc_hd__o21bai_2
* pin VGND
* pin B1_N
* pin Y
* pin A2
* pin A1
* pin VPWR
* pin VPB
* pin sky130_gnd
.SUBCKT sky130_fd_sc_hd__o21bai_2 VGND B1_N Y A2 A1 VPWR VPB sky130_gnd
* device instance $1 r0 *1 0.475,1.695 sky130_fd_pr__pfet_01v8_hvt
XM$1 \$3 B1_N VPWR VPB sky130_fd_pr__pfet_01v8_hvt L=150000 W=420000
+ AS=109200000000 AD=145750000000 PS=1360000 PD=1335000
* device instance $2 r0 *1 0.96,1.985 sky130_fd_pr__pfet_01v8_hvt
XM$2 VPWR \$3 Y VPB sky130_fd_pr__pfet_01v8_hvt L=150000 W=2000000
+ AS=280750000000 AD=395000000000 PS=2605000 PD=3790000
* device instance $4 r0 *1 2.32,1.985 sky130_fd_pr__pfet_01v8_hvt
XM$4 \$9 A2 Y VPB sky130_fd_pr__pfet_01v8_hvt L=150000 W=2000000
+ AS=395000000000 AD=270000000000 PS=3790000 PD=2540000
* device instance $6 r0 *1 3.16,1.985 sky130_fd_pr__pfet_01v8_hvt
XM$6 \$9 A1 VPWR VPB sky130_fd_pr__pfet_01v8_hvt L=150000 W=2000000
+ AS=270000000000 AD=415000000000 PS=2540000 PD=3830000
* device instance $8 r0 *1 1.48,0.56 sky130_fd_pr__nfet_01v8
XM$8 \$4 \$3 Y sky130_gnd sky130_fd_pr__nfet_01v8 L=150000 W=1300000
+ AS=256750000000 AD=175500000000 PS=2740000 PD=1840000
* device instance $10 r0 *1 2.32,0.56 sky130_fd_pr__nfet_01v8
XM$10 \$4 A2 VGND sky130_gnd sky130_fd_pr__nfet_01v8 L=150000 W=1300000
+ AS=175500000000 AD=175500000000 PS=1840000 PD=1840000
* device instance $12 r0 *1 3.16,0.56 sky130_fd_pr__nfet_01v8
XM$12 \$4 A1 VGND sky130_gnd sky130_fd_pr__nfet_01v8 L=150000 W=1300000
+ AS=175500000000 AD=269750000000 PS=1840000 PD=2780000
* device instance $14 r0 *1 0.475,0.675 sky130_fd_pr__nfet_01v8
XM$14 VGND B1_N \$3 sky130_gnd sky130_fd_pr__nfet_01v8 L=150000 W=420000
+ AS=109200000000 AD=109200000000 PS=1360000 PD=1360000
.ENDS sky130_fd_sc_hd__o21bai_2

* cell sky130_fd_sc_hd__a311o_2
* pin VGND
* pin X
* pin A3
* pin A2
* pin A1
* pin B1
* pin C1
* pin VPWR
* pin VPB
* pin sky130_gnd
.SUBCKT sky130_fd_sc_hd__a311o_2 VGND X A3 A2 A1 B1 C1 VPWR VPB sky130_gnd
* device instance $1 r0 *1 0.47,1.985 sky130_fd_pr__pfet_01v8_hvt
XM$1 VPWR \$4 X VPB sky130_fd_pr__pfet_01v8_hvt L=150000 W=2000000
+ AS=395000000000 AD=375000000000 PS=3790000 PD=2750000
* device instance $3 r0 *1 1.52,1.985 sky130_fd_pr__pfet_01v8_hvt
XM$3 VPWR A3 \$13 VPB sky130_fd_pr__pfet_01v8_hvt L=150000 W=1000000
+ AS=240000000000 AD=170000000000 PS=1480000 PD=1340000
* device instance $4 r0 *1 2.01,1.985 sky130_fd_pr__pfet_01v8_hvt
XM$4 \$13 A2 VPWR VPB sky130_fd_pr__pfet_01v8_hvt L=150000 W=1000000
+ AS=170000000000 AD=185000000000 PS=1340000 PD=1370000
* device instance $5 r0 *1 2.53,1.985 sky130_fd_pr__pfet_01v8_hvt
XM$5 VPWR A1 \$13 VPB sky130_fd_pr__pfet_01v8_hvt L=150000 W=1000000
+ AS=185000000000 AD=210000000000 PS=1370000 PD=1420000
* device instance $6 r0 *1 3.1,1.985 sky130_fd_pr__pfet_01v8_hvt
XM$6 \$13 B1 \$15 VPB sky130_fd_pr__pfet_01v8_hvt L=150000 W=1000000
+ AS=210000000000 AD=210000000000 PS=1420000 PD=1420000
* device instance $7 r0 *1 3.67,1.985 sky130_fd_pr__pfet_01v8_hvt
XM$7 \$15 C1 \$4 VPB sky130_fd_pr__pfet_01v8_hvt L=150000 W=1000000
+ AS=210000000000 AD=260000000000 PS=1420000 PD=2520000
* device instance $8 r0 *1 0.47,0.56 sky130_fd_pr__nfet_01v8
XM$8 VGND \$4 X sky130_gnd sky130_fd_pr__nfet_01v8 L=150000 W=1300000
+ AS=256750000000 AD=243750000000 PS=2740000 PD=2050000
* device instance $10 r0 *1 1.52,0.56 sky130_fd_pr__nfet_01v8
XM$10 VGND A3 \$6 sky130_gnd sky130_fd_pr__nfet_01v8 L=150000 W=650000
+ AS=156000000000 AD=110500000000 PS=1130000 PD=990000
* device instance $11 r0 *1 2.01,0.56 sky130_fd_pr__nfet_01v8
XM$11 \$6 A2 \$5 sky130_gnd sky130_fd_pr__nfet_01v8 L=150000 W=650000
+ AS=110500000000 AD=120250000000 PS=990000 PD=1020000
* device instance $12 r0 *1 2.53,0.56 sky130_fd_pr__nfet_01v8
XM$12 \$5 A1 \$4 sky130_gnd sky130_fd_pr__nfet_01v8 L=150000 W=650000
+ AS=120250000000 AD=133250000000 PS=1020000 PD=1060000
* device instance $13 r0 *1 3.09,0.56 sky130_fd_pr__nfet_01v8
XM$13 \$4 B1 VGND sky130_gnd sky130_fd_pr__nfet_01v8 L=150000 W=650000
+ AS=133250000000 AD=139750000000 PS=1060000 PD=1080000
* device instance $14 r0 *1 3.67,0.56 sky130_fd_pr__nfet_01v8
XM$14 VGND C1 \$4 sky130_gnd sky130_fd_pr__nfet_01v8 L=150000 W=650000
+ AS=139750000000 AD=169000000000 PS=1080000 PD=1820000
.ENDS sky130_fd_sc_hd__a311o_2

* cell sky130_fd_sc_hd__o32ai_2
* pin VGND
* pin A3
* pin Y
* pin B2
* pin B1
* pin A2
* pin A1
* pin VPWR
* pin VPB
* pin sky130_gnd
.SUBCKT sky130_fd_sc_hd__o32ai_2 VGND A3 Y B2 B1 A2 A1 VPWR VPB sky130_gnd
* device instance $1 r0 *1 4.95,1.985 sky130_fd_pr__pfet_01v8_hvt
XM$1 VPWR A1 \$12 VPB sky130_fd_pr__pfet_01v8_hvt L=150000 W=2000000
+ AS=395000000000 AD=415000000000 PS=3790000 PD=3830000
* device instance $3 r0 *1 2.73,1.985 sky130_fd_pr__pfet_01v8_hvt
XM$3 \$11 A3 Y VPB sky130_fd_pr__pfet_01v8_hvt L=150000 W=2000000
+ AS=415000000000 AD=270000000000 PS=3830000 PD=2540000
* device instance $5 r0 *1 3.57,1.985 sky130_fd_pr__pfet_01v8_hvt
XM$5 \$11 A2 \$12 VPB sky130_fd_pr__pfet_01v8_hvt L=150000 W=2000000
+ AS=270000000000 AD=415000000000 PS=2540000 PD=3830000
* device instance $7 r0 *1 0.47,1.985 sky130_fd_pr__pfet_01v8_hvt
XM$7 \$10 B2 Y VPB sky130_fd_pr__pfet_01v8_hvt L=150000 W=2000000
+ AS=395000000000 AD=270000000000 PS=3790000 PD=2540000
* device instance $9 r0 *1 1.31,1.985 sky130_fd_pr__pfet_01v8_hvt
XM$9 \$10 B1 VPWR VPB sky130_fd_pr__pfet_01v8_hvt L=150000 W=2000000
+ AS=270000000000 AD=395000000000 PS=2540000 PD=3790000
* device instance $11 r0 *1 0.47,0.56 sky130_fd_pr__nfet_01v8
XM$11 \$4 B2 Y sky130_gnd sky130_fd_pr__nfet_01v8 L=150000 W=1300000
+ AS=256750000000 AD=175500000000 PS=2740000 PD=1840000
* device instance $13 r0 *1 1.31,0.56 sky130_fd_pr__nfet_01v8
XM$13 \$4 B1 Y sky130_gnd sky130_fd_pr__nfet_01v8 L=150000 W=1300000
+ AS=175500000000 AD=175500000000 PS=1840000 PD=1840000
* device instance $15 r0 *1 2.15,0.56 sky130_fd_pr__nfet_01v8
XM$15 \$4 A3 VGND sky130_gnd sky130_fd_pr__nfet_01v8 L=150000 W=1300000
+ AS=344500000000 AD=344500000000 PS=2360000 PD=2360000
* device instance $17 r0 *1 3.51,0.56 sky130_fd_pr__nfet_01v8
XM$17 \$4 A2 VGND sky130_gnd sky130_fd_pr__nfet_01v8 L=150000 W=1300000
+ AS=175500000000 AD=344500000000 PS=1840000 PD=2360000
* device instance $19 r0 *1 4.87,0.56 sky130_fd_pr__nfet_01v8
XM$19 \$4 A1 VGND sky130_gnd sky130_fd_pr__nfet_01v8 L=150000 W=1300000
+ AS=344500000000 AD=315250000000 PS=2360000 PD=2920000
.ENDS sky130_fd_sc_hd__o32ai_2

* cell sky130_fd_sc_hd__a31oi_2
* pin VGND
* pin Y
* pin A3
* pin A2
* pin A1
* pin B1
* pin VPWR
* pin VPB
* pin sky130_gnd
.SUBCKT sky130_fd_sc_hd__a31oi_2 VGND Y A3 A2 A1 B1 VPWR VPB sky130_gnd
* device instance $1 r0 *1 0.47,1.985 sky130_fd_pr__pfet_01v8_hvt
XM$1 \$11 A3 VPWR VPB sky130_fd_pr__pfet_01v8_hvt L=150000 W=2000000
+ AS=395000000000 AD=270000000000 PS=3790000 PD=2540000
* device instance $3 r0 *1 1.31,1.985 sky130_fd_pr__pfet_01v8_hvt
XM$3 \$11 A2 VPWR VPB sky130_fd_pr__pfet_01v8_hvt L=150000 W=2000000
+ AS=270000000000 AD=270000000000 PS=2540000 PD=2540000
* device instance $5 r0 *1 2.15,1.985 sky130_fd_pr__pfet_01v8_hvt
XM$5 \$11 A1 VPWR VPB sky130_fd_pr__pfet_01v8_hvt L=150000 W=2000000
+ AS=545000000000 AD=590000000000 PS=3090000 PD=3180000
* device instance $7 r0 *1 3.63,1.985 sky130_fd_pr__pfet_01v8_hvt
XM$7 \$11 B1 Y VPB sky130_fd_pr__pfet_01v8_hvt L=150000 W=2000000
+ AS=355000000000 AD=435000000000 PS=2710000 PD=3870000
* device instance $9 r0 *1 2.67,0.56 sky130_fd_pr__nfet_01v8
XM$9 Y A1 \$4 sky130_gnd sky130_fd_pr__nfet_01v8 L=150000 W=1300000
+ AS=266500000000 AD=214500000000 PS=2770000 PD=1960000
* device instance $11 r0 *1 3.63,0.56 sky130_fd_pr__nfet_01v8
XM$11 Y B1 VGND sky130_gnd sky130_fd_pr__nfet_01v8 L=150000 W=1300000
+ AS=230750000000 AD=282750000000 PS=2010000 PD=2820000
* device instance $13 r0 *1 0.47,0.56 sky130_fd_pr__nfet_01v8
XM$13 \$3 A3 VGND sky130_gnd sky130_fd_pr__nfet_01v8 L=150000 W=1300000
+ AS=256750000000 AD=175500000000 PS=2740000 PD=1840000
* device instance $15 r0 *1 1.31,0.56 sky130_fd_pr__nfet_01v8
XM$15 \$3 A2 \$4 sky130_gnd sky130_fd_pr__nfet_01v8 L=150000 W=1300000
+ AS=175500000000 AD=256750000000 PS=1840000 PD=2740000
.ENDS sky130_fd_sc_hd__a31oi_2

* cell sky130_fd_sc_hd__o22ai_2
* pin VGND
* pin Y
* pin B1
* pin B2
* pin A2
* pin A1
* pin VPWR
* pin VPB
* pin sky130_gnd
.SUBCKT sky130_fd_sc_hd__o22ai_2 VGND Y B1 B2 A2 A1 VPWR VPB sky130_gnd
* device instance $1 r0 *1 2.73,1.985 sky130_fd_pr__pfet_01v8_hvt
XM$1 \$10 A2 Y VPB sky130_fd_pr__pfet_01v8_hvt L=150000 W=2000000
+ AS=415000000000 AD=270000000000 PS=3830000 PD=2540000
* device instance $3 r0 *1 3.57,1.985 sky130_fd_pr__pfet_01v8_hvt
XM$3 \$10 A1 VPWR VPB sky130_fd_pr__pfet_01v8_hvt L=150000 W=2000000
+ AS=270000000000 AD=415000000000 PS=2540000 PD=3830000
* device instance $5 r0 *1 0.49,1.985 sky130_fd_pr__pfet_01v8_hvt
XM$5 \$9 B1 VPWR VPB sky130_fd_pr__pfet_01v8_hvt L=150000 W=2000000
+ AS=415000000000 AD=270000000000 PS=3830000 PD=2540000
* device instance $7 r0 *1 1.33,1.985 sky130_fd_pr__pfet_01v8_hvt
XM$7 \$9 B2 Y VPB sky130_fd_pr__pfet_01v8_hvt L=150000 W=2000000
+ AS=270000000000 AD=415000000000 PS=2540000 PD=3830000
* device instance $9 r0 *1 0.49,0.56 sky130_fd_pr__nfet_01v8
XM$9 \$3 B1 Y sky130_gnd sky130_fd_pr__nfet_01v8 L=150000 W=1300000
+ AS=269750000000 AD=175500000000 PS=2780000 PD=1840000
* device instance $11 r0 *1 1.33,0.56 sky130_fd_pr__nfet_01v8
XM$11 \$3 B2 Y sky130_gnd sky130_fd_pr__nfet_01v8 L=150000 W=1300000
+ AS=175500000000 AD=357500000000 PS=1840000 PD=2400000
* device instance $13 r0 *1 2.73,0.56 sky130_fd_pr__nfet_01v8
XM$13 \$3 A2 VGND sky130_gnd sky130_fd_pr__nfet_01v8 L=150000 W=1300000
+ AS=357500000000 AD=175500000000 PS=2400000 PD=1840000
* device instance $15 r0 *1 3.57,0.56 sky130_fd_pr__nfet_01v8
XM$15 \$3 A1 VGND sky130_gnd sky130_fd_pr__nfet_01v8 L=150000 W=1300000
+ AS=175500000000 AD=256750000000 PS=1840000 PD=2740000
.ENDS sky130_fd_sc_hd__o22ai_2

* cell sky130_fd_sc_hd__o2bb2a_2
* pin VGND
* pin X
* pin A2_N
* pin A1_N
* pin B2
* pin B1
* pin VPWR
* pin VPB
* pin sky130_gnd
.SUBCKT sky130_fd_sc_hd__o2bb2a_2 VGND X A2_N A1_N B2 B1 VPWR VPB sky130_gnd
* device instance $1 r0 *1 0.495,1.985 sky130_fd_pr__pfet_01v8_hvt
XM$1 VPWR \$8 X VPB sky130_fd_pr__pfet_01v8_hvt L=150000 W=2000000
+ AS=420000000000 AD=289000000000 PS=3840000 PD=2605000
* device instance $3 r0 *1 1.4,2.165 sky130_fd_pr__pfet_01v8_hvt
XM$3 VPWR A1_N \$5 VPB sky130_fd_pr__pfet_01v8_hvt L=150000 W=640000
+ AS=154000000000 AD=173000000000 PS=1335000 PD=1400000
* device instance $4 r0 *1 1.95,2.165 sky130_fd_pr__pfet_01v8_hvt
XM$4 \$5 A2_N VPWR VPB sky130_fd_pr__pfet_01v8_hvt L=150000 W=640000
+ AS=173000000000 AD=227200000000 PS=1400000 PD=1350000
* device instance $5 r0 *1 2.81,2.165 sky130_fd_pr__pfet_01v8_hvt
XM$5 VPWR \$5 \$8 VPB sky130_fd_pr__pfet_01v8_hvt L=150000 W=640000
+ AS=227200000000 AD=92800000000 PS=1350000 PD=930000
* device instance $6 r0 *1 3.25,2.165 sky130_fd_pr__pfet_01v8_hvt
XM$6 \$8 B2 \$13 VPB sky130_fd_pr__pfet_01v8_hvt L=150000 W=640000
+ AS=92800000000 AD=86400000000 PS=930000 PD=910000
* device instance $7 r0 *1 3.67,2.165 sky130_fd_pr__pfet_01v8_hvt
XM$7 \$13 B1 VPWR VPB sky130_fd_pr__pfet_01v8_hvt L=150000 W=640000
+ AS=86400000000 AD=166400000000 PS=910000 PD=1800000
* device instance $8 r0 *1 1.395,0.445 sky130_fd_pr__nfet_01v8
XM$8 VGND A1_N \$7 sky130_gnd sky130_fd_pr__nfet_01v8 L=150000 W=420000
+ AS=98625000000 AD=66150000000 PS=980000 PD=735000
* device instance $9 r0 *1 1.86,0.445 sky130_fd_pr__nfet_01v8
XM$9 \$7 A2_N \$5 sky130_gnd sky130_fd_pr__nfet_01v8 L=150000 W=420000
+ AS=66150000000 AD=109200000000 PS=735000 PD=1360000
* device instance $10 r0 *1 0.495,0.56 sky130_fd_pr__nfet_01v8
XM$10 VGND \$8 X sky130_gnd sky130_fd_pr__nfet_01v8 L=150000 W=1300000
+ AS=273000000000 AD=186375000000 PS=2790000 PD=1900000
* device instance $12 r0 *1 2.83,0.445 sky130_fd_pr__nfet_01v8
XM$12 \$8 \$5 \$6 sky130_gnd sky130_fd_pr__nfet_01v8 L=150000 W=420000
+ AS=109200000000 AD=56700000000 PS=1360000 PD=690000
* device instance $13 r0 *1 3.25,0.445 sky130_fd_pr__nfet_01v8
XM$13 \$6 B2 VGND sky130_gnd sky130_fd_pr__nfet_01v8 L=150000 W=420000
+ AS=56700000000 AD=56700000000 PS=690000 PD=690000
* device instance $14 r0 *1 3.67,0.445 sky130_fd_pr__nfet_01v8
XM$14 VGND B1 \$6 sky130_gnd sky130_fd_pr__nfet_01v8 L=150000 W=420000
+ AS=56700000000 AD=109200000000 PS=690000 PD=1360000
.ENDS sky130_fd_sc_hd__o2bb2a_2

* cell sky130_fd_sc_hd__nand3b_2
* pin VGND
* pin A_N
* pin C
* pin B
* pin Y
* pin VPWR
* pin VPB
* pin sky130_gnd
.SUBCKT sky130_fd_sc_hd__nand3b_2 VGND A_N C B Y VPWR VPB sky130_gnd
* device instance $1 r0 *1 3.215,1.985 sky130_fd_pr__pfet_01v8_hvt
XM$1 VPWR \$3 Y VPB sky130_fd_pr__pfet_01v8_hvt L=150000 W=2000000
+ AS=395000000000 AD=395000000000 PS=3790000 PD=3790000
* device instance $3 r0 *1 0.47,2.275 sky130_fd_pr__pfet_01v8_hvt
XM$3 VPWR A_N \$3 VPB sky130_fd_pr__pfet_01v8_hvt L=150000 W=420000
+ AS=175750000000 AD=109200000000 PS=1395000 PD=1360000
* device instance $4 r0 *1 1.015,1.985 sky130_fd_pr__pfet_01v8_hvt
XM$4 VPWR C Y VPB sky130_fd_pr__pfet_01v8_hvt L=150000 W=2000000
+ AS=310750000000 AD=270000000000 PS=2665000 PD=2540000
* device instance $6 r0 *1 1.855,1.985 sky130_fd_pr__pfet_01v8_hvt
XM$6 VPWR B Y VPB sky130_fd_pr__pfet_01v8_hvt L=150000 W=2000000
+ AS=270000000000 AD=395000000000 PS=2540000 PD=3790000
* device instance $8 r0 *1 2.375,0.56 sky130_fd_pr__nfet_01v8
XM$8 \$5 B \$4 sky130_gnd sky130_fd_pr__nfet_01v8 L=150000 W=1300000
+ AS=256750000000 AD=175500000000 PS=2740000 PD=1840000
* device instance $10 r0 *1 3.215,0.56 sky130_fd_pr__nfet_01v8
XM$10 \$5 \$3 Y sky130_gnd sky130_fd_pr__nfet_01v8 L=150000 W=1300000
+ AS=175500000000 AD=256750000000 PS=1840000 PD=2740000
* device instance $12 r0 *1 0.47,0.445 sky130_fd_pr__nfet_01v8
XM$12 \$3 A_N VGND sky130_gnd sky130_fd_pr__nfet_01v8 L=150000 W=420000
+ AS=109200000000 AD=119750000000 PS=1360000 PD=1045000
* device instance $13 r0 *1 1.015,0.56 sky130_fd_pr__nfet_01v8
XM$13 VGND C \$4 sky130_gnd sky130_fd_pr__nfet_01v8 L=150000 W=1300000
+ AS=207500000000 AD=256750000000 PS=1965000 PD=2740000
.ENDS sky130_fd_sc_hd__nand3b_2

* cell sky130_fd_sc_hd__o311a_2
* pin VGND
* pin X
* pin A1
* pin A2
* pin A3
* pin B1
* pin C1
* pin VPWR
* pin VPB
* pin sky130_gnd
.SUBCKT sky130_fd_sc_hd__o311a_2 VGND X A1 A2 A3 B1 C1 VPWR VPB sky130_gnd
* device instance $1 r0 *1 0.53,1.985 sky130_fd_pr__pfet_01v8_hvt
XM$1 VPWR \$5 X VPB sky130_fd_pr__pfet_01v8_hvt L=150000 W=2000000
+ AS=455000000000 AD=447500000000 PS=3910000 PD=2895000
* device instance $3 r0 *1 1.725,1.985 sky130_fd_pr__pfet_01v8_hvt
XM$3 VPWR A1 \$14 VPB sky130_fd_pr__pfet_01v8_hvt L=150000 W=1000000
+ AS=312500000000 AD=175000000000 PS=1625000 PD=1350000
* device instance $4 r0 *1 2.225,1.985 sky130_fd_pr__pfet_01v8_hvt
XM$4 \$14 A2 \$15 VPB sky130_fd_pr__pfet_01v8_hvt L=150000 W=1000000
+ AS=175000000000 AD=210000000000 PS=1350000 PD=1420000
* device instance $5 r0 *1 2.795,1.985 sky130_fd_pr__pfet_01v8_hvt
XM$5 \$15 A3 \$5 VPB sky130_fd_pr__pfet_01v8_hvt L=150000 W=1000000
+ AS=210000000000 AD=137500000000 PS=1420000 PD=1275000
* device instance $6 r0 *1 3.22,1.985 sky130_fd_pr__pfet_01v8_hvt
XM$6 \$5 B1 VPWR VPB sky130_fd_pr__pfet_01v8_hvt L=150000 W=1000000
+ AS=137500000000 AD=150000000000 PS=1275000 PD=1300000
* device instance $7 r0 *1 3.67,1.985 sky130_fd_pr__pfet_01v8_hvt
XM$7 VPWR C1 \$5 VPB sky130_fd_pr__pfet_01v8_hvt L=150000 W=1000000
+ AS=150000000000 AD=260000000000 PS=1300000 PD=2520000
* device instance $8 r0 *1 0.53,0.56 sky130_fd_pr__nfet_01v8
XM$8 VGND \$5 X sky130_gnd sky130_fd_pr__nfet_01v8 L=150000 W=1300000
+ AS=295750000000 AD=290875000000 PS=2860000 PD=2195000
* device instance $10 r0 *1 1.725,0.56 sky130_fd_pr__nfet_01v8
XM$10 VGND A1 \$4 sky130_gnd sky130_fd_pr__nfet_01v8 L=150000 W=650000
+ AS=203125000000 AD=113750000000 PS=1275000 PD=1000000
* device instance $11 r0 *1 2.225,0.56 sky130_fd_pr__nfet_01v8
XM$11 \$4 A2 VGND sky130_gnd sky130_fd_pr__nfet_01v8 L=150000 W=650000
+ AS=113750000000 AD=136500000000 PS=1000000 PD=1070000
* device instance $12 r0 *1 2.795,0.56 sky130_fd_pr__nfet_01v8
XM$12 VGND A3 \$4 sky130_gnd sky130_fd_pr__nfet_01v8 L=150000 W=650000
+ AS=136500000000 AD=118625000000 PS=1070000 PD=1015000
* device instance $13 r0 *1 3.31,0.56 sky130_fd_pr__nfet_01v8
XM$13 \$4 B1 \$11 sky130_gnd sky130_fd_pr__nfet_01v8 L=150000 W=650000
+ AS=118625000000 AD=68250000000 PS=1015000 PD=860000
* device instance $14 r0 *1 3.67,0.56 sky130_fd_pr__nfet_01v8
XM$14 \$11 C1 \$5 sky130_gnd sky130_fd_pr__nfet_01v8 L=150000 W=650000
+ AS=68250000000 AD=169000000000 PS=860000 PD=1820000
.ENDS sky130_fd_sc_hd__o311a_2

* cell sky130_fd_sc_hd__nor4b_2
* pin VGND
* pin Y
* pin A
* pin B
* pin C
* pin D_N
* pin VPWR
* pin VPB
* pin sky130_gnd
.SUBCKT sky130_fd_sc_hd__nor4b_2 VGND Y A B C D_N VPWR VPB sky130_gnd
* device instance $1 r0 *1 4.905,2.275 sky130_fd_pr__pfet_01v8_hvt
XM$1 \$4 D_N VPWR VPB sky130_fd_pr__pfet_01v8_hvt L=150000 W=420000
+ AS=109200000000 AD=109200000000 PS=1360000 PD=1360000
* device instance $2 r0 *1 2.705,1.985 sky130_fd_pr__pfet_01v8_hvt
XM$2 \$12 C \$11 VPB sky130_fd_pr__pfet_01v8_hvt L=150000 W=2000000
+ AS=395000000000 AD=270000000000 PS=3790000 PD=2540000
* device instance $4 r0 *1 3.545,1.985 sky130_fd_pr__pfet_01v8_hvt
XM$4 \$12 \$4 Y VPB sky130_fd_pr__pfet_01v8_hvt L=150000 W=2000000
+ AS=270000000000 AD=395000000000 PS=2540000 PD=3790000
* device instance $6 r0 *1 0.47,1.985 sky130_fd_pr__pfet_01v8_hvt
XM$6 \$9 A VPWR VPB sky130_fd_pr__pfet_01v8_hvt L=150000 W=2000000
+ AS=395000000000 AD=270000000000 PS=3790000 PD=2540000
* device instance $8 r0 *1 1.31,1.985 sky130_fd_pr__pfet_01v8_hvt
XM$8 \$9 B \$11 VPB sky130_fd_pr__pfet_01v8_hvt L=150000 W=2000000
+ AS=270000000000 AD=395000000000 PS=2540000 PD=3790000
* device instance $10 r0 *1 4.905,0.675 sky130_fd_pr__nfet_01v8
XM$10 \$4 D_N VGND sky130_gnd sky130_fd_pr__nfet_01v8 L=150000 W=420000
+ AS=109200000000 AD=109200000000 PS=1360000 PD=1360000
* device instance $11 r0 *1 2.705,0.56 sky130_fd_pr__nfet_01v8
XM$11 VGND C Y sky130_gnd sky130_fd_pr__nfet_01v8 L=150000 W=1300000
+ AS=256750000000 AD=175500000000 PS=2740000 PD=1840000
* device instance $13 r0 *1 3.545,0.56 sky130_fd_pr__nfet_01v8
XM$13 VGND \$4 Y sky130_gnd sky130_fd_pr__nfet_01v8 L=150000 W=1300000
+ AS=175500000000 AD=256750000000 PS=1840000 PD=2740000
* device instance $15 r0 *1 0.47,0.56 sky130_fd_pr__nfet_01v8
XM$15 VGND A Y sky130_gnd sky130_fd_pr__nfet_01v8 L=150000 W=1300000
+ AS=256750000000 AD=175500000000 PS=2740000 PD=1840000
* device instance $17 r0 *1 1.31,0.56 sky130_fd_pr__nfet_01v8
XM$17 VGND B Y sky130_gnd sky130_fd_pr__nfet_01v8 L=150000 W=1300000
+ AS=175500000000 AD=256750000000 PS=1840000 PD=2740000
.ENDS sky130_fd_sc_hd__nor4b_2

* cell sky130_fd_sc_hd__buf_2
* pin VPB
* pin VGND
* pin X
* pin VPWR
* pin A
* pin sky130_gnd
.SUBCKT sky130_fd_sc_hd__buf_2 VPB VGND X VPWR A sky130_gnd
* device instance $1 r0 *1 0.47,2.125 sky130_fd_pr__pfet_01v8_hvt
XM$1 VPWR A \$3 VPB sky130_fd_pr__pfet_01v8_hvt L=150000 W=640000
+ AS=149000000000 AD=166400000000 PS=1325000 PD=1800000
* device instance $2 r0 *1 0.945,1.985 sky130_fd_pr__pfet_01v8_hvt
XM$2 VPWR \$3 X VPB sky130_fd_pr__pfet_01v8_hvt L=150000 W=2000000
+ AS=284000000000 AD=400000000000 PS=2595000 PD=3800000
* device instance $4 r0 *1 0.47,0.445 sky130_fd_pr__nfet_01v8
XM$4 \$3 A VGND sky130_gnd sky130_fd_pr__nfet_01v8 L=150000 W=420000
+ AS=109200000000 AD=97000000000 PS=1360000 PD=975000
* device instance $5 r0 *1 0.945,0.56 sky130_fd_pr__nfet_01v8
XM$5 VGND \$3 X sky130_gnd sky130_fd_pr__nfet_01v8 L=150000 W=1300000
+ AS=184750000000 AD=260000000000 PS=1895000 PD=2750000
.ENDS sky130_fd_sc_hd__buf_2

* cell sky130_fd_sc_hd__or4bb_2
* pin VGND
* pin X
* pin C_N
* pin D_N
* pin A
* pin VPWR
* pin B
* pin VPB
* pin sky130_gnd
.SUBCKT sky130_fd_sc_hd__or4bb_2 VGND X C_N D_N A VPWR B VPB sky130_gnd
* device instance $1 r0 *1 2.395,1.695 sky130_fd_pr__pfet_01v8_hvt
XM$1 \$14 \$8 \$11 VPB sky130_fd_pr__pfet_01v8_hvt L=150000 W=420000
+ AS=121500000000 AD=44100000000 PS=1330000 PD=630000
* device instance $2 r0 *1 2.755,1.695 sky130_fd_pr__pfet_01v8_hvt
XM$2 \$11 B \$10 VPB sky130_fd_pr__pfet_01v8_hvt L=150000 W=420000
+ AS=44100000000 AD=59850000000 PS=630000 PD=705000
* device instance $3 r0 *1 3.19,1.695 sky130_fd_pr__pfet_01v8_hvt
XM$3 \$10 A VPWR VPB sky130_fd_pr__pfet_01v8_hvt L=150000 W=420000
+ AS=59850000000 AD=148250000000 PS=705000 PD=1340000
* device instance $4 r0 *1 1.915,2.275 sky130_fd_pr__pfet_01v8_hvt
XM$4 \$14 \$7 \$3 VPB sky130_fd_pr__pfet_01v8_hvt L=150000 W=420000
+ AS=121500000000 AD=109200000000 PS=1330000 PD=1360000
* device instance $5 r0 *1 3.68,1.985 sky130_fd_pr__pfet_01v8_hvt
XM$5 VPWR \$3 X VPB sky130_fd_pr__pfet_01v8_hvt L=150000 W=2000000
+ AS=283250000000 AD=420000000000 PS=2610000 PD=3840000
* device instance $7 r0 *1 0.955,1.695 sky130_fd_pr__pfet_01v8_hvt
XM$7 VPWR D_N \$7 VPB sky130_fd_pr__pfet_01v8_hvt L=150000 W=420000
+ AS=122612500000 AD=117600000000 PS=1320000 PD=1400000
* device instance $8 r0 *1 0.47,2.26 sky130_fd_pr__pfet_01v8_hvt
XM$8 VPWR C_N \$8 VPB sky130_fd_pr__pfet_01v8_hvt L=150000 W=420000
+ AS=122612500000 AD=109200000000 PS=1320000 PD=1360000
* device instance $9 r0 *1 1.895,0.445 sky130_fd_pr__nfet_01v8
XM$9 VGND \$7 \$3 sky130_gnd sky130_fd_pr__nfet_01v8 L=150000 W=420000
+ AS=109200000000 AD=64050000000 PS=1360000 PD=725000
* device instance $10 r0 *1 2.35,0.445 sky130_fd_pr__nfet_01v8
XM$10 \$3 \$8 VGND sky130_gnd sky130_fd_pr__nfet_01v8 L=150000 W=420000
+ AS=64050000000 AD=56700000000 PS=725000 PD=690000
* device instance $11 r0 *1 2.77,0.445 sky130_fd_pr__nfet_01v8
XM$11 VGND B \$3 sky130_gnd sky130_fd_pr__nfet_01v8 L=150000 W=420000
+ AS=56700000000 AD=56700000000 PS=690000 PD=690000
* device instance $12 r0 *1 3.19,0.445 sky130_fd_pr__nfet_01v8
XM$12 \$3 A VGND sky130_gnd sky130_fd_pr__nfet_01v8 L=150000 W=420000
+ AS=56700000000 AD=101875000000 PS=690000 PD=990000
* device instance $13 r0 *1 3.68,0.56 sky130_fd_pr__nfet_01v8
XM$13 VGND \$3 X sky130_gnd sky130_fd_pr__nfet_01v8 L=150000 W=1300000
+ AS=189625000000 AD=273000000000 PS=1910000 PD=2790000
* device instance $15 r0 *1 0.51,0.675 sky130_fd_pr__nfet_01v8
XM$15 \$8 C_N VGND sky130_gnd sky130_fd_pr__nfet_01v8 L=150000 W=420000
+ AS=109200000000 AD=61950000000 PS=1360000 PD=715000
* device instance $16 r0 *1 0.955,0.675 sky130_fd_pr__nfet_01v8
XM$16 VGND D_N \$7 sky130_gnd sky130_fd_pr__nfet_01v8 L=150000 W=420000
+ AS=61950000000 AD=109200000000 PS=715000 PD=1360000
.ENDS sky130_fd_sc_hd__or4bb_2

* cell sky130_fd_sc_hd__and4_2
* pin VPB
* pin B
* pin VPWR
* pin C
* pin D
* pin X
* pin A
* pin VGND
* pin sky130_gnd
.SUBCKT sky130_fd_sc_hd__and4_2 VPB B VPWR C D X A VGND sky130_gnd
* device instance $1 r0 *1 0.47,2.275 sky130_fd_pr__pfet_01v8_hvt
XM$1 VPWR A \$7 VPB sky130_fd_pr__pfet_01v8_hvt L=150000 W=420000
+ AS=109200000000 AD=74550000000 PS=1360000 PD=775000
* device instance $2 r0 *1 0.975,2.275 sky130_fd_pr__pfet_01v8_hvt
XM$2 \$7 B VPWR VPB sky130_fd_pr__pfet_01v8_hvt L=150000 W=420000
+ AS=74550000000 AD=77700000000 PS=775000 PD=790000
* device instance $3 r0 *1 1.495,2.275 sky130_fd_pr__pfet_01v8_hvt
XM$3 VPWR C \$7 VPB sky130_fd_pr__pfet_01v8_hvt L=150000 W=420000
+ AS=77700000000 AD=58800000000 PS=790000 PD=700000
* device instance $4 r0 *1 1.925,2.275 sky130_fd_pr__pfet_01v8_hvt
XM$4 VPWR D \$7 VPB sky130_fd_pr__pfet_01v8_hvt L=150000 W=420000
+ AS=279950000000 AD=58800000000 PS=1615000 PD=700000
* device instance $5 r0 *1 2.69,1.985 sky130_fd_pr__pfet_01v8_hvt
XM$5 VPWR \$7 X VPB sky130_fd_pr__pfet_01v8_hvt L=150000 W=2000000
+ AS=444950000000 AD=465000000000 PS=2945000 PD=3930000
* device instance $7 r0 *1 0.47,0.445 sky130_fd_pr__nfet_01v8
XM$7 \$7 A \$13 sky130_gnd sky130_fd_pr__nfet_01v8 L=150000 W=420000
+ AS=109200000000 AD=61950000000 PS=1360000 PD=715000
* device instance $8 r0 *1 0.915,0.445 sky130_fd_pr__nfet_01v8
XM$8 \$13 B \$12 sky130_gnd sky130_fd_pr__nfet_01v8 L=150000 W=420000
+ AS=61950000000 AD=79800000000 PS=715000 PD=800000
* device instance $9 r0 *1 1.445,0.445 sky130_fd_pr__nfet_01v8
XM$9 \$12 C \$11 sky130_gnd sky130_fd_pr__nfet_01v8 L=150000 W=420000
+ AS=79800000000 AD=69300000000 PS=800000 PD=750000
* device instance $10 r0 *1 1.925,0.445 sky130_fd_pr__nfet_01v8
XM$10 \$11 D VGND sky130_gnd sky130_fd_pr__nfet_01v8 L=150000 W=420000
+ AS=69300000000 AD=175150000000 PS=750000 PD=1265000
* device instance $11 r0 *1 2.69,0.56 sky130_fd_pr__nfet_01v8
XM$11 VGND \$7 X sky130_gnd sky130_fd_pr__nfet_01v8 L=150000 W=1300000
+ AS=282400000000 AD=302250000000 PS=2245000 PD=2880000
.ENDS sky130_fd_sc_hd__and4_2

* cell sky130_fd_sc_hd__a41oi_2
* pin VGND
* pin Y
* pin A4
* pin B1
* pin A1
* pin A2
* pin A3
* pin VPWR
* pin VPB
* pin sky130_gnd
.SUBCKT sky130_fd_sc_hd__a41oi_2 VGND Y A4 B1 A1 A2 A3 VPWR VPB sky130_gnd
* device instance $1 r0 *1 1.08,1.985 sky130_fd_pr__pfet_01v8_hvt
XM$1 \$12 B1 Y VPB sky130_fd_pr__pfet_01v8_hvt L=150000 W=2000000
+ AS=395000000000 AD=270000000000 PS=3790000 PD=2540000
* device instance $3 r0 *1 1.92,1.985 sky130_fd_pr__pfet_01v8_hvt
XM$3 \$12 A1 VPWR VPB sky130_fd_pr__pfet_01v8_hvt L=150000 W=2000000
+ AS=270000000000 AD=270000000000 PS=2540000 PD=2540000
* device instance $5 r0 *1 2.76,1.985 sky130_fd_pr__pfet_01v8_hvt
XM$5 \$12 A2 VPWR VPB sky130_fd_pr__pfet_01v8_hvt L=150000 W=2000000
+ AS=270000000000 AD=280000000000 PS=2540000 PD=2560000
* device instance $7 r0 *1 3.62,1.985 sky130_fd_pr__pfet_01v8_hvt
XM$7 \$12 A3 VPWR VPB sky130_fd_pr__pfet_01v8_hvt L=150000 W=2000000
+ AS=530000000000 AD=520000000000 PS=3060000 PD=3040000
* device instance $9 r0 *1 4.96,1.985 sky130_fd_pr__pfet_01v8_hvt
XM$9 \$12 A4 VPWR VPB sky130_fd_pr__pfet_01v8_hvt L=150000 W=2000000
+ AS=270000000000 AD=395000000000 PS=2540000 PD=3790000
* device instance $11 r0 *1 4.12,0.56 sky130_fd_pr__nfet_01v8
XM$11 \$6 A3 \$5 sky130_gnd sky130_fd_pr__nfet_01v8 L=150000 W=1300000
+ AS=256750000000 AD=175500000000 PS=2740000 PD=1840000
* device instance $13 r0 *1 4.96,0.56 sky130_fd_pr__nfet_01v8
XM$13 \$6 A4 VGND sky130_gnd sky130_fd_pr__nfet_01v8 L=150000 W=1300000
+ AS=175500000000 AD=256750000000 PS=1840000 PD=2740000
* device instance $15 r0 *1 1.92,0.56 sky130_fd_pr__nfet_01v8
XM$15 \$4 A1 Y sky130_gnd sky130_fd_pr__nfet_01v8 L=150000 W=1300000
+ AS=256750000000 AD=175500000000 PS=2740000 PD=1840000
* device instance $17 r0 *1 2.76,0.56 sky130_fd_pr__nfet_01v8
XM$17 \$4 A2 \$5 sky130_gnd sky130_fd_pr__nfet_01v8 L=150000 W=1300000
+ AS=175500000000 AD=256750000000 PS=1840000 PD=2740000
* device instance $19 r0 *1 0.56,0.56 sky130_fd_pr__nfet_01v8
XM$19 VGND B1 Y sky130_gnd sky130_fd_pr__nfet_01v8 L=150000 W=1300000
+ AS=256750000000 AD=256750000000 PS=2740000 PD=2740000
.ENDS sky130_fd_sc_hd__a41oi_2

* cell sky130_fd_sc_hd__a221oi_2
* pin VGND
* pin C1
* pin Y
* pin B2
* pin B1
* pin A2
* pin A1
* pin VPWR
* pin VPB
* pin sky130_gnd
.SUBCKT sky130_fd_sc_hd__a221oi_2 VGND C1 Y B2 B1 A2 A1 VPWR VPB sky130_gnd
* device instance $1 r0 *1 1.84,1.985 sky130_fd_pr__pfet_01v8_hvt
XM$1 \$13 B2 \$11 VPB sky130_fd_pr__pfet_01v8_hvt L=150000 W=2000000
+ AS=395000000000 AD=310000000000 PS=3790000 PD=2620000
* device instance $2 r0 *1 2.26,1.985 sky130_fd_pr__pfet_01v8_hvt
XM$2 \$11 B1 \$13 VPB sky130_fd_pr__pfet_01v8_hvt L=150000 W=2000000
+ AS=270000000000 AD=270000000000 PS=2540000 PD=2540000
* device instance $5 r0 *1 3.6,1.985 sky130_fd_pr__pfet_01v8_hvt
XM$5 \$13 A2 VPWR VPB sky130_fd_pr__pfet_01v8_hvt L=150000 W=2000000
+ AS=310000000000 AD=420000000000 PS=2620000 PD=3840000
* device instance $6 r0 *1 4.02,1.985 sky130_fd_pr__pfet_01v8_hvt
XM$6 VPWR A1 \$13 VPB sky130_fd_pr__pfet_01v8_hvt L=150000 W=2000000
+ AS=270000000000 AD=270000000000 PS=2540000 PD=2540000
* device instance $9 r0 *1 0.48,1.985 sky130_fd_pr__pfet_01v8_hvt
XM$9 \$11 C1 Y VPB sky130_fd_pr__pfet_01v8_hvt L=150000 W=2000000
+ AS=405000000000 AD=395000000000 PS=3810000 PD=3790000
* device instance $11 r0 *1 0.48,0.56 sky130_fd_pr__nfet_01v8
XM$11 VGND C1 Y sky130_gnd sky130_fd_pr__nfet_01v8 L=150000 W=1300000
+ AS=263250000000 AD=344500000000 PS=2760000 PD=2360000
* device instance $13 r0 *1 1.84,0.56 sky130_fd_pr__nfet_01v8
XM$13 VGND B2 \$6 sky130_gnd sky130_fd_pr__nfet_01v8 L=150000 W=1300000
+ AS=344500000000 AD=201500000000 PS=2360000 PD=1920000
* device instance $14 r0 *1 2.26,0.56 sky130_fd_pr__nfet_01v8
XM$14 \$6 B1 Y sky130_gnd sky130_fd_pr__nfet_01v8 L=150000 W=1300000
+ AS=175500000000 AD=175500000000 PS=1840000 PD=1840000
* device instance $17 r0 *1 3.6,0.56 sky130_fd_pr__nfet_01v8
XM$17 VGND A2 \$9 sky130_gnd sky130_fd_pr__nfet_01v8 L=150000 W=1300000
+ AS=201500000000 AD=256750000000 PS=1920000 PD=2740000
* device instance $18 r0 *1 4.02,0.56 sky130_fd_pr__nfet_01v8
XM$18 \$9 A1 Y sky130_gnd sky130_fd_pr__nfet_01v8 L=150000 W=1300000
+ AS=175500000000 AD=175500000000 PS=1840000 PD=1840000
.ENDS sky130_fd_sc_hd__a221oi_2

* cell sky130_fd_sc_hd__mux2_1
* pin VGND
* pin X
* pin A1
* pin A0
* pin S
* pin VPWR
* pin VPB
* pin sky130_gnd
.SUBCKT sky130_fd_sc_hd__mux2_1 VGND X A1 A0 S VPWR VPB sky130_gnd
* device instance $1 r0 *1 1.015,2.08 sky130_fd_pr__pfet_01v8_hvt
XM$1 VPWR S \$13 VPB sky130_fd_pr__pfet_01v8_hvt L=150000 W=420000
+ AS=158350000000 AD=76650000000 PS=1395000 PD=785000
* device instance $2 r0 *1 1.53,2.08 sky130_fd_pr__pfet_01v8_hvt
XM$2 \$13 A0 \$5 VPB sky130_fd_pr__pfet_01v8_hvt L=150000 W=420000
+ AS=76650000000 AD=193200000000 PS=785000 PD=1340000
* device instance $3 r0 *1 2.6,2.08 sky130_fd_pr__pfet_01v8_hvt
XM$3 \$5 A1 \$14 VPB sky130_fd_pr__pfet_01v8_hvt L=150000 W=420000
+ AS=193200000000 AD=44100000000 PS=1340000 PD=630000
* device instance $4 r0 *1 2.96,2.08 sky130_fd_pr__pfet_01v8_hvt
XM$4 \$14 \$7 VPWR VPB sky130_fd_pr__pfet_01v8_hvt L=150000 W=420000
+ AS=44100000000 AD=69300000000 PS=630000 PD=750000
* device instance $5 r0 *1 3.44,2.08 sky130_fd_pr__pfet_01v8_hvt
XM$5 VPWR S \$7 VPB sky130_fd_pr__pfet_01v8_hvt L=150000 W=420000
+ AS=69300000000 AD=117600000000 PS=750000 PD=1400000
* device instance $6 r0 *1 0.47,1.985 sky130_fd_pr__pfet_01v8_hvt
XM$6 X \$5 VPWR VPB sky130_fd_pr__pfet_01v8_hvt L=150000 W=1000000
+ AS=260000000000 AD=158350000000 PS=2520000 PD=1395000
* device instance $7 r0 *1 1.015,0.445 sky130_fd_pr__nfet_01v8
XM$7 VGND S \$8 sky130_gnd sky130_fd_pr__nfet_01v8 L=150000 W=420000
+ AS=112850000000 AD=69300000000 PS=1045000 PD=750000
* device instance $8 r0 *1 1.495,0.445 sky130_fd_pr__nfet_01v8
XM$8 \$8 A1 \$5 sky130_gnd sky130_fd_pr__nfet_01v8 L=150000 W=420000
+ AS=69300000000 AD=99750000000 PS=750000 PD=895000
* device instance $9 r0 *1 2.12,0.445 sky130_fd_pr__nfet_01v8
XM$9 \$5 A0 \$9 sky130_gnd sky130_fd_pr__nfet_01v8 L=150000 W=420000
+ AS=99750000000 AD=69300000000 PS=895000 PD=750000
* device instance $10 r0 *1 2.6,0.445 sky130_fd_pr__nfet_01v8
XM$10 \$9 \$7 VGND sky130_gnd sky130_fd_pr__nfet_01v8 L=150000 W=420000
+ AS=69300000000 AD=144900000000 PS=750000 PD=1110000
* device instance $11 r0 *1 3.44,0.445 sky130_fd_pr__nfet_01v8
XM$11 VGND S \$7 sky130_gnd sky130_fd_pr__nfet_01v8 L=150000 W=420000
+ AS=144900000000 AD=109200000000 PS=1110000 PD=1360000
* device instance $12 r0 *1 0.47,0.56 sky130_fd_pr__nfet_01v8
XM$12 X \$5 VGND sky130_gnd sky130_fd_pr__nfet_01v8 L=150000 W=650000
+ AS=169000000000 AD=112850000000 PS=1820000 PD=1045000
.ENDS sky130_fd_sc_hd__mux2_1

* cell sky130_fd_sc_hd__conb_1
* pin VPB
* pin HI,VPWR
* pin LO,VGND
.SUBCKT sky130_fd_sc_hd__conb_1 VPB HI|VPWR LO|VGND
.ENDS sky130_fd_sc_hd__conb_1

* cell sky130_fd_sc_hd__or3b_2
* pin VPB
* pin X
* pin B
* pin A
* pin VGND
* pin VPWR
* pin C_N
* pin sky130_gnd
.SUBCKT sky130_fd_sc_hd__or3b_2 VPB X B A VGND VPWR C_N sky130_gnd
* device instance $1 r0 *1 1.865,1.695 sky130_fd_pr__pfet_01v8_hvt
XM$1 VPWR A \$12 VPB sky130_fd_pr__pfet_01v8_hvt L=150000 W=420000
+ AS=148250000000 AD=56700000000 PS=1340000 PD=690000
* device instance $2 r0 *1 2.285,1.695 sky130_fd_pr__pfet_01v8_hvt
XM$2 \$12 B \$11 VPB sky130_fd_pr__pfet_01v8_hvt L=150000 W=420000
+ AS=56700000000 AD=56700000000 PS=690000 PD=690000
* device instance $3 r0 *1 2.705,1.695 sky130_fd_pr__pfet_01v8_hvt
XM$3 \$11 \$4 \$5 VPB sky130_fd_pr__pfet_01v8_hvt L=150000 W=420000
+ AS=56700000000 AD=109200000000 PS=690000 PD=1360000
* device instance $4 r0 *1 0.47,2.01 sky130_fd_pr__pfet_01v8_hvt
XM$4 VPWR C_N \$4 VPB sky130_fd_pr__pfet_01v8_hvt L=150000 W=420000
+ AS=145750000000 AD=109200000000 PS=1335000 PD=1360000
* device instance $5 r0 *1 0.955,1.985 sky130_fd_pr__pfet_01v8_hvt
XM$5 VPWR \$5 X VPB sky130_fd_pr__pfet_01v8_hvt L=150000 W=2000000
+ AS=280750000000 AD=283250000000 PS=2605000 PD=2610000
* device instance $7 r0 *1 0.47,0.445 sky130_fd_pr__nfet_01v8
XM$7 \$4 C_N VGND sky130_gnd sky130_fd_pr__nfet_01v8 L=150000 W=420000
+ AS=109200000000 AD=100250000000 PS=1360000 PD=985000
* device instance $8 r0 *1 1.865,0.475 sky130_fd_pr__nfet_01v8
XM$8 VGND A \$5 sky130_gnd sky130_fd_pr__nfet_01v8 L=150000 W=420000
+ AS=101875000000 AD=56700000000 PS=990000 PD=690000
* device instance $9 r0 *1 2.285,0.475 sky130_fd_pr__nfet_01v8
XM$9 \$5 B VGND sky130_gnd sky130_fd_pr__nfet_01v8 L=150000 W=420000
+ AS=56700000000 AD=56700000000 PS=690000 PD=690000
* device instance $10 r0 *1 2.705,0.475 sky130_fd_pr__nfet_01v8
XM$10 VGND \$4 \$5 sky130_gnd sky130_fd_pr__nfet_01v8 L=150000 W=420000
+ AS=56700000000 AD=109200000000 PS=690000 PD=1360000
* device instance $11 r0 *1 0.955,0.56 sky130_fd_pr__nfet_01v8
XM$11 VGND \$5 X sky130_gnd sky130_fd_pr__nfet_01v8 L=150000 W=1300000
+ AS=188000000000 AD=189625000000 PS=1905000 PD=1910000
.ENDS sky130_fd_sc_hd__or3b_2

* cell sky130_fd_sc_hd__o32a_2
* pin VGND
* pin X
* pin A1
* pin A2
* pin A3
* pin B2
* pin B1
* pin VPWR
* pin VPB
* pin sky130_gnd
.SUBCKT sky130_fd_sc_hd__o32a_2 VGND X A1 A2 A3 B2 B1 VPWR VPB sky130_gnd
* device instance $1 r0 *1 0.47,1.985 sky130_fd_pr__pfet_01v8_hvt
XM$1 VPWR \$5 X VPB sky130_fd_pr__pfet_01v8_hvt L=150000 W=2000000
+ AS=395000000000 AD=440000000000 PS=3790000 PD=2880000
* device instance $3 r0 *1 1.65,1.985 sky130_fd_pr__pfet_01v8_hvt
XM$3 VPWR A1 \$12 VPB sky130_fd_pr__pfet_01v8_hvt L=150000 W=1000000
+ AS=305000000000 AD=135000000000 PS=1610000 PD=1270000
* device instance $4 r0 *1 2.07,1.985 sky130_fd_pr__pfet_01v8_hvt
XM$4 \$12 A2 \$13 VPB sky130_fd_pr__pfet_01v8_hvt L=150000 W=1000000
+ AS=135000000000 AD=215000000000 PS=1270000 PD=1430000
* device instance $5 r0 *1 2.65,1.985 sky130_fd_pr__pfet_01v8_hvt
XM$5 \$13 A3 \$5 VPB sky130_fd_pr__pfet_01v8_hvt L=150000 W=1000000
+ AS=215000000000 AD=135000000000 PS=1430000 PD=1270000
* device instance $6 r0 *1 3.07,1.985 sky130_fd_pr__pfet_01v8_hvt
XM$6 \$5 B2 \$14 VPB sky130_fd_pr__pfet_01v8_hvt L=150000 W=1000000
+ AS=135000000000 AD=190000000000 PS=1270000 PD=1380000
* device instance $7 r0 *1 3.6,1.985 sky130_fd_pr__pfet_01v8_hvt
XM$7 \$14 B1 VPWR VPB sky130_fd_pr__pfet_01v8_hvt L=150000 W=1000000
+ AS=190000000000 AD=330000000000 PS=1380000 PD=2660000
* device instance $8 r0 *1 0.47,0.56 sky130_fd_pr__nfet_01v8
XM$8 VGND \$5 X sky130_gnd sky130_fd_pr__nfet_01v8 L=150000 W=1300000
+ AS=256750000000 AD=286000000000 PS=2740000 PD=2180000
* device instance $10 r0 *1 1.65,0.56 sky130_fd_pr__nfet_01v8
XM$10 VGND A1 \$4 sky130_gnd sky130_fd_pr__nfet_01v8 L=150000 W=650000
+ AS=198250000000 AD=87750000000 PS=1260000 PD=920000
* device instance $11 r0 *1 2.07,0.56 sky130_fd_pr__nfet_01v8
XM$11 \$4 A2 VGND sky130_gnd sky130_fd_pr__nfet_01v8 L=150000 W=650000
+ AS=87750000000 AD=139750000000 PS=920000 PD=1080000
* device instance $12 r0 *1 2.65,0.56 sky130_fd_pr__nfet_01v8
XM$12 VGND A3 \$4 sky130_gnd sky130_fd_pr__nfet_01v8 L=150000 W=650000
+ AS=139750000000 AD=87750000000 PS=1080000 PD=920000
* device instance $13 r0 *1 3.07,0.56 sky130_fd_pr__nfet_01v8
XM$13 \$4 B2 \$5 sky130_gnd sky130_fd_pr__nfet_01v8 L=150000 W=650000
+ AS=87750000000 AD=123500000000 PS=920000 PD=1030000
* device instance $14 r0 *1 3.6,0.56 sky130_fd_pr__nfet_01v8
XM$14 \$5 B1 \$4 sky130_gnd sky130_fd_pr__nfet_01v8 L=150000 W=650000
+ AS=123500000000 AD=214500000000 PS=1030000 PD=1960000
.ENDS sky130_fd_sc_hd__o32a_2

* cell sky130_fd_sc_hd__and3b_2
* pin VPB
* pin VPWR
* pin B
* pin VGND
* pin C
* pin A_N
* pin X
* pin sky130_gnd
.SUBCKT sky130_fd_sc_hd__and3b_2 VPB VPWR B VGND C A_N X sky130_gnd
* device instance $1 r0 *1 2.305,1.695 sky130_fd_pr__pfet_01v8_hvt
XM$1 \$6 C VPWR VPB sky130_fd_pr__pfet_01v8_hvt L=150000 W=420000
+ AS=74375000000 AD=145750000000 PS=815000 PD=1335000
* device instance $2 r0 *1 1.41,1.765 sky130_fd_pr__pfet_01v8_hvt
XM$2 \$6 \$7 VPWR VPB sky130_fd_pr__pfet_01v8_hvt L=150000 W=420000
+ AS=109200000000 AD=56700000000 PS=1360000 PD=690000
* device instance $3 r0 *1 1.83,1.765 sky130_fd_pr__pfet_01v8_hvt
XM$3 \$6 B VPWR VPB sky130_fd_pr__pfet_01v8_hvt L=150000 W=420000
+ AS=74375000000 AD=56700000000 PS=815000 PD=690000
* device instance $4 r0 *1 2.79,1.985 sky130_fd_pr__pfet_01v8_hvt
XM$4 VPWR \$6 X VPB sky130_fd_pr__pfet_01v8_hvt L=150000 W=2000000
+ AS=280750000000 AD=395000000000 PS=2605000 PD=3790000
* device instance $6 r0 *1 0.47,1.765 sky130_fd_pr__pfet_01v8_hvt
XM$6 VPWR A_N \$7 VPB sky130_fd_pr__pfet_01v8_hvt L=150000 W=420000
+ AS=109200000000 AD=109200000000 PS=1360000 PD=1360000
* device instance $7 r0 *1 1.43,0.475 sky130_fd_pr__nfet_01v8
XM$7 \$6 \$7 \$12 sky130_gnd sky130_fd_pr__nfet_01v8 L=150000 W=420000
+ AS=109200000000 AD=44100000000 PS=1360000 PD=630000
* device instance $8 r0 *1 1.79,0.475 sky130_fd_pr__nfet_01v8
XM$8 \$12 B \$11 sky130_gnd sky130_fd_pr__nfet_01v8 L=150000 W=420000
+ AS=44100000000 AD=53550000000 PS=630000 PD=675000
* device instance $9 r0 *1 2.195,0.475 sky130_fd_pr__nfet_01v8
XM$9 VGND C \$11 sky130_gnd sky130_fd_pr__nfet_01v8 L=150000 W=420000
+ AS=127150000000 AD=53550000000 PS=1095000 PD=675000
* device instance $10 r0 *1 2.79,0.56 sky130_fd_pr__nfet_01v8
XM$10 VGND \$6 X sky130_gnd sky130_fd_pr__nfet_01v8 L=150000 W=1300000
+ AS=214900000000 AD=256750000000 PS=2015000 PD=2740000
* device instance $12 r0 *1 0.47,0.475 sky130_fd_pr__nfet_01v8
XM$12 VGND A_N \$7 sky130_gnd sky130_fd_pr__nfet_01v8 L=150000 W=420000
+ AS=109200000000 AD=117600000000 PS=1360000 PD=1400000
.ENDS sky130_fd_sc_hd__and3b_2

* cell sky130_fd_sc_hd__o22a_2
* pin VPB
* pin VGND
* pin VPWR
* pin X
* pin B1
* pin B2
* pin A2
* pin A1
* pin sky130_gnd
.SUBCKT sky130_fd_sc_hd__o22a_2 VPB VGND VPWR X B1 B2 A2 A1 sky130_gnd
* device instance $1 r0 *1 0.49,1.985 sky130_fd_pr__pfet_01v8_hvt
XM$1 VPWR \$5 X VPB sky130_fd_pr__pfet_01v8_hvt L=150000 W=2000000
+ AS=415000000000 AD=525000000000 PS=3830000 PD=3050000
* device instance $3 r0 *1 1.84,1.985 sky130_fd_pr__pfet_01v8_hvt
XM$3 VPWR B1 \$12 VPB sky130_fd_pr__pfet_01v8_hvt L=150000 W=1000000
+ AS=390000000000 AD=105000000000 PS=1780000 PD=1210000
* device instance $4 r0 *1 2.2,1.985 sky130_fd_pr__pfet_01v8_hvt
XM$4 \$12 B2 \$5 VPB sky130_fd_pr__pfet_01v8_hvt L=150000 W=1000000
+ AS=105000000000 AD=235000000000 PS=1210000 PD=1470000
* device instance $5 r0 *1 2.82,1.985 sky130_fd_pr__pfet_01v8_hvt
XM$5 \$5 A2 \$13 VPB sky130_fd_pr__pfet_01v8_hvt L=150000 W=1000000
+ AS=235000000000 AD=105000000000 PS=1470000 PD=1210000
* device instance $6 r0 *1 3.18,1.985 sky130_fd_pr__pfet_01v8_hvt
XM$6 \$13 A1 VPWR VPB sky130_fd_pr__pfet_01v8_hvt L=150000 W=1000000
+ AS=105000000000 AD=280000000000 PS=1210000 PD=2560000
* device instance $7 r0 *1 1.84,0.56 sky130_fd_pr__nfet_01v8
XM$7 \$7 B1 \$5 sky130_gnd sky130_fd_pr__nfet_01v8 L=150000 W=650000
+ AS=169000000000 AD=87750000000 PS=1820000 PD=920000
* device instance $8 r0 *1 2.26,0.56 sky130_fd_pr__nfet_01v8
XM$8 \$5 B2 \$7 sky130_gnd sky130_fd_pr__nfet_01v8 L=150000 W=650000
+ AS=87750000000 AD=123500000000 PS=920000 PD=1030000
* device instance $9 r0 *1 2.79,0.56 sky130_fd_pr__nfet_01v8
XM$9 \$7 A2 VGND sky130_gnd sky130_fd_pr__nfet_01v8 L=150000 W=650000
+ AS=123500000000 AD=87750000000 PS=1030000 PD=920000
* device instance $10 r0 *1 3.21,0.56 sky130_fd_pr__nfet_01v8
XM$10 VGND A1 \$7 sky130_gnd sky130_fd_pr__nfet_01v8 L=150000 W=650000
+ AS=87750000000 AD=169000000000 PS=920000 PD=1820000
* device instance $11 r0 *1 0.48,0.56 sky130_fd_pr__nfet_01v8
XM$11 VGND \$5 X sky130_gnd sky130_fd_pr__nfet_01v8 L=150000 W=1300000
+ AS=256750000000 AD=256750000000 PS=2740000 PD=2740000
.ENDS sky130_fd_sc_hd__o22a_2

* cell sky130_fd_sc_hd__a22oi_2
* pin VGND
* pin B2
* pin B1
* pin Y
* pin A1
* pin A2
* pin VPWR
* pin VPB
* pin sky130_gnd
.SUBCKT sky130_fd_sc_hd__a22oi_2 VGND B2 B1 Y A1 A2 VPWR VPB sky130_gnd
* device instance $1 r0 *1 2.67,1.985 sky130_fd_pr__pfet_01v8_hvt
XM$1 \$10 A1 VPWR VPB sky130_fd_pr__pfet_01v8_hvt L=150000 W=2000000
+ AS=395000000000 AD=270000000000 PS=3790000 PD=2540000
* device instance $3 r0 *1 3.51,1.985 sky130_fd_pr__pfet_01v8_hvt
XM$3 \$10 A2 VPWR VPB sky130_fd_pr__pfet_01v8_hvt L=150000 W=2000000
+ AS=270000000000 AD=395000000000 PS=2540000 PD=3790000
* device instance $5 r0 *1 0.47,1.985 sky130_fd_pr__pfet_01v8_hvt
XM$5 Y B2 \$10 VPB sky130_fd_pr__pfet_01v8_hvt L=150000 W=2000000
+ AS=395000000000 AD=270000000000 PS=3790000 PD=2540000
* device instance $7 r0 *1 1.31,1.985 sky130_fd_pr__pfet_01v8_hvt
XM$7 Y B1 \$10 VPB sky130_fd_pr__pfet_01v8_hvt L=150000 W=2000000
+ AS=270000000000 AD=395000000000 PS=2540000 PD=3790000
* device instance $9 r0 *1 2.67,0.56 sky130_fd_pr__nfet_01v8
XM$9 \$7 A1 Y sky130_gnd sky130_fd_pr__nfet_01v8 L=150000 W=1300000
+ AS=256750000000 AD=175500000000 PS=2740000 PD=1840000
* device instance $11 r0 *1 3.51,0.56 sky130_fd_pr__nfet_01v8
XM$11 \$7 A2 VGND sky130_gnd sky130_fd_pr__nfet_01v8 L=150000 W=1300000
+ AS=175500000000 AD=256750000000 PS=1840000 PD=2740000
* device instance $13 r0 *1 0.47,0.56 sky130_fd_pr__nfet_01v8
XM$13 \$3 B2 VGND sky130_gnd sky130_fd_pr__nfet_01v8 L=150000 W=1300000
+ AS=256750000000 AD=175500000000 PS=2740000 PD=1840000
* device instance $15 r0 *1 1.31,0.56 sky130_fd_pr__nfet_01v8
XM$15 \$3 B1 Y sky130_gnd sky130_fd_pr__nfet_01v8 L=150000 W=1300000
+ AS=175500000000 AD=256750000000 PS=1840000 PD=2740000
.ENDS sky130_fd_sc_hd__a22oi_2

* cell sky130_fd_sc_hd__a221o_2
* pin VGND
* pin C1
* pin B2
* pin B1
* pin A1
* pin A2
* pin X
* pin VPWR
* pin VPB
* pin sky130_gnd
.SUBCKT sky130_fd_sc_hd__a221o_2 VGND C1 B2 B1 A1 A2 X VPWR VPB sky130_gnd
* device instance $1 r0 *1 2.25,1.985 sky130_fd_pr__pfet_01v8_hvt
XM$1 VPWR A1 \$13 VPB sky130_fd_pr__pfet_01v8_hvt L=150000 W=1000000
+ AS=260000000000 AD=165000000000 PS=2520000 PD=1330000
* device instance $2 r0 *1 2.73,1.985 sky130_fd_pr__pfet_01v8_hvt
XM$2 \$13 A2 VPWR VPB sky130_fd_pr__pfet_01v8_hvt L=150000 W=1000000
+ AS=165000000000 AD=157500000000 PS=1330000 PD=1315000
* device instance $3 r0 *1 3.195,1.985 sky130_fd_pr__pfet_01v8_hvt
XM$3 VPWR \$3 X VPB sky130_fd_pr__pfet_01v8_hvt L=150000 W=2000000
+ AS=292500000000 AD=420000000000 PS=2585000 PD=3840000
* device instance $5 r0 *1 0.47,1.985 sky130_fd_pr__pfet_01v8_hvt
XM$5 \$3 C1 \$12 VPB sky130_fd_pr__pfet_01v8_hvt L=150000 W=1000000
+ AS=260000000000 AD=135000000000 PS=2520000 PD=1270000
* device instance $6 r0 *1 0.89,1.985 sky130_fd_pr__pfet_01v8_hvt
XM$6 \$12 B2 \$13 VPB sky130_fd_pr__pfet_01v8_hvt L=150000 W=1000000
+ AS=135000000000 AD=135000000000 PS=1270000 PD=1270000
* device instance $7 r0 *1 1.31,1.985 sky130_fd_pr__pfet_01v8_hvt
XM$7 \$13 B1 \$12 VPB sky130_fd_pr__pfet_01v8_hvt L=150000 W=1000000
+ AS=135000000000 AD=260000000000 PS=1270000 PD=2520000
* device instance $8 r0 *1 2.25,0.56 sky130_fd_pr__nfet_01v8
XM$8 \$3 A1 \$11 sky130_gnd sky130_fd_pr__nfet_01v8 L=150000 W=650000
+ AS=169000000000 AD=107250000000 PS=1820000 PD=980000
* device instance $9 r0 *1 2.73,0.56 sky130_fd_pr__nfet_01v8
XM$9 \$11 A2 VGND sky130_gnd sky130_fd_pr__nfet_01v8 L=150000 W=650000
+ AS=107250000000 AD=102375000000 PS=980000 PD=965000
* device instance $10 r0 *1 3.195,0.56 sky130_fd_pr__nfet_01v8
XM$10 VGND \$3 X sky130_gnd sky130_fd_pr__nfet_01v8 L=150000 W=1300000
+ AS=190125000000 AD=273000000000 PS=1885000 PD=2790000
* device instance $12 r0 *1 0.47,0.56 sky130_fd_pr__nfet_01v8
XM$12 \$3 C1 VGND sky130_gnd sky130_fd_pr__nfet_01v8 L=150000 W=650000
+ AS=169000000000 AD=107250000000 PS=1820000 PD=980000
* device instance $13 r0 *1 0.95,0.56 sky130_fd_pr__nfet_01v8
XM$13 VGND B2 \$10 sky130_gnd sky130_fd_pr__nfet_01v8 L=150000 W=650000
+ AS=107250000000 AD=68250000000 PS=980000 PD=860000
* device instance $14 r0 *1 1.31,0.56 sky130_fd_pr__nfet_01v8
XM$14 \$10 B1 \$3 sky130_gnd sky130_fd_pr__nfet_01v8 L=150000 W=650000
+ AS=68250000000 AD=169000000000 PS=860000 PD=1820000
.ENDS sky130_fd_sc_hd__a221o_2

* cell sky130_fd_sc_hd__dfstp_2
* pin VGND
* pin SET_B
* pin Q
* pin CLK
* pin D
* pin VPWR
* pin VPB
* pin sky130_gnd
.SUBCKT sky130_fd_sc_hd__dfstp_2 VGND SET_B Q CLK D VPWR VPB sky130_gnd
* device instance $1 r0 *1 1.83,2.065 sky130_fd_pr__pfet_01v8_hvt
XM$1 VPWR D \$6 VPB sky130_fd_pr__pfet_01v8_hvt L=150000 W=840000
+ AS=218400000000 AD=124950000000 PS=2200000 PD=1175000
* device instance $2 r0 *1 2.315,2.275 sky130_fd_pr__pfet_01v8_hvt
XM$2 \$6 \$5 \$7 VPB sky130_fd_pr__pfet_01v8_hvt L=150000 W=420000
+ AS=124950000000 AD=56700000000 PS=1175000 PD=690000
* device instance $3 r0 *1 2.735,2.275 sky130_fd_pr__pfet_01v8_hvt
XM$3 \$7 \$4 \$22 VPB sky130_fd_pr__pfet_01v8_hvt L=150000 W=420000
+ AS=56700000000 AD=94500000000 PS=690000 PD=870000
* device instance $4 r0 *1 3.335,2.275 sky130_fd_pr__pfet_01v8_hvt
XM$4 \$22 \$20 VPWR VPB sky130_fd_pr__pfet_01v8_hvt L=150000 W=420000
+ AS=94500000000 AD=79800000000 PS=870000 PD=800000
* device instance $5 r0 *1 3.865,2.275 sky130_fd_pr__pfet_01v8_hvt
XM$5 VPWR SET_B \$20 VPB sky130_fd_pr__pfet_01v8_hvt L=150000 W=420000
+ AS=79800000000 AD=56700000000 PS=800000 PD=690000
* device instance $6 r0 *1 4.285,2.275 sky130_fd_pr__pfet_01v8_hvt
XM$6 \$20 \$7 VPWR VPB sky130_fd_pr__pfet_01v8_hvt L=150000 W=420000
+ AS=56700000000 AD=56700000000 PS=690000 PD=690000
* device instance $7 r0 *1 4.705,2.275 sky130_fd_pr__pfet_01v8_hvt
XM$7 VPWR \$7 \$23 VPB sky130_fd_pr__pfet_01v8_hvt L=150000 W=420000
+ AS=56700000000 AD=44100000000 PS=690000 PD=630000
* device instance $8 r0 *1 5.065,2.275 sky130_fd_pr__pfet_01v8_hvt
XM$8 \$23 \$4 \$9 VPB sky130_fd_pr__pfet_01v8_hvt L=150000 W=420000
+ AS=44100000000 AD=81900000000 PS=630000 PD=810000
* device instance $9 r0 *1 5.605,2.275 sky130_fd_pr__pfet_01v8_hvt
XM$9 \$9 \$5 \$24 VPB sky130_fd_pr__pfet_01v8_hvt L=150000 W=420000
+ AS=81900000000 AD=44100000000 PS=810000 PD=630000
* device instance $10 r0 *1 5.965,2.275 sky130_fd_pr__pfet_01v8_hvt
XM$10 \$24 \$19 VPWR VPB sky130_fd_pr__pfet_01v8_hvt L=150000 W=420000
+ AS=44100000000 AD=109200000000 PS=630000 PD=1360000
* device instance $11 r0 *1 6.905,2.275 sky130_fd_pr__pfet_01v8_hvt
XM$11 VPWR SET_B \$9 VPB sky130_fd_pr__pfet_01v8_hvt L=150000 W=420000
+ AS=120750000000 AD=109200000000 PS=1165000 PD=1360000
* device instance $12 r0 *1 7.38,2.065 sky130_fd_pr__pfet_01v8_hvt
XM$12 VPWR \$9 \$19 VPB sky130_fd_pr__pfet_01v8_hvt L=150000 W=840000
+ AS=120750000000 AD=222600000000 PS=1165000 PD=2210000
* device instance $13 r0 *1 0.47,2.135 sky130_fd_pr__pfet_01v8_hvt
XM$13 \$4 CLK VPWR VPB sky130_fd_pr__pfet_01v8_hvt L=150000 W=640000
+ AS=166400000000 AD=86400000000 PS=1800000 PD=910000
* device instance $14 r0 *1 0.89,2.135 sky130_fd_pr__pfet_01v8_hvt
XM$14 VPWR \$4 \$5 VPB sky130_fd_pr__pfet_01v8_hvt L=150000 W=640000
+ AS=86400000000 AD=166400000000 PS=910000 PD=1800000
* device instance $15 r0 *1 8.345,1.985 sky130_fd_pr__pfet_01v8_hvt
XM$15 \$10 \$9 VPWR VPB sky130_fd_pr__pfet_01v8_hvt L=150000 W=1000000
+ AS=260000000000 AD=135000000000 PS=2520000 PD=1270000
* device instance $16 r0 *1 8.765,1.985 sky130_fd_pr__pfet_01v8_hvt
XM$16 VPWR \$10 Q VPB sky130_fd_pr__pfet_01v8_hvt L=150000 W=2000000
+ AS=270000000000 AD=395000000000 PS=2540000 PD=3790000
* device instance $18 r0 *1 5.205,0.445 sky130_fd_pr__nfet_01v8
XM$18 VGND \$7 \$15 sky130_gnd sky130_fd_pr__nfet_01v8 L=150000 W=420000
+ AS=109200000000 AD=44100000000 PS=1360000 PD=630000
* device instance $19 r0 *1 5.565,0.445 sky130_fd_pr__nfet_01v8
XM$19 \$15 \$5 \$9 sky130_gnd sky130_fd_pr__nfet_01v8 L=150000 W=420000
+ AS=44100000000 AD=73500000000 PS=630000 PD=770000
* device instance $20 r0 *1 6.065,0.445 sky130_fd_pr__nfet_01v8
XM$20 \$9 \$4 \$12 sky130_gnd sky130_fd_pr__nfet_01v8 L=150000 W=420000
+ AS=73500000000 AD=44100000000 PS=770000 PD=630000
* device instance $21 r0 *1 6.425,0.445 sky130_fd_pr__nfet_01v8
XM$21 \$12 \$19 \$14 sky130_gnd sky130_fd_pr__nfet_01v8 L=150000 W=420000
+ AS=44100000000 AD=44100000000 PS=630000 PD=630000
* device instance $22 r0 *1 6.785,0.445 sky130_fd_pr__nfet_01v8
XM$22 \$14 SET_B VGND sky130_gnd sky130_fd_pr__nfet_01v8 L=150000 W=420000
+ AS=44100000000 AD=113700000000 PS=630000 PD=1010000
* device instance $23 r0 *1 7.405,0.505 sky130_fd_pr__nfet_01v8
XM$23 VGND \$9 \$19 sky130_gnd sky130_fd_pr__nfet_01v8 L=150000 W=540000
+ AS=113700000000 AD=140400000000 PS=1010000 PD=1600000
* device instance $24 r0 *1 8.345,0.56 sky130_fd_pr__nfet_01v8
XM$24 \$10 \$9 VGND sky130_gnd sky130_fd_pr__nfet_01v8 L=150000 W=650000
+ AS=169000000000 AD=87750000000 PS=1820000 PD=920000
* device instance $25 r0 *1 8.765,0.56 sky130_fd_pr__nfet_01v8
XM$25 VGND \$10 Q sky130_gnd sky130_fd_pr__nfet_01v8 L=150000 W=1300000
+ AS=175500000000 AD=256750000000 PS=1840000 PD=2740000
* device instance $27 r0 *1 0.47,0.445 sky130_fd_pr__nfet_01v8
XM$27 \$4 CLK VGND sky130_gnd sky130_fd_pr__nfet_01v8 L=150000 W=420000
+ AS=109200000000 AD=56700000000 PS=1360000 PD=690000
* device instance $28 r0 *1 0.89,0.445 sky130_fd_pr__nfet_01v8
XM$28 VGND \$4 \$5 sky130_gnd sky130_fd_pr__nfet_01v8 L=150000 W=420000
+ AS=56700000000 AD=109200000000 PS=690000 PD=1360000
* device instance $29 r0 *1 2.305,0.415 sky130_fd_pr__nfet_01v8
XM$29 \$6 \$4 \$7 sky130_gnd sky130_fd_pr__nfet_01v8 L=150000 W=360000
+ AS=93500000000 AD=72000000000 PS=965000 PD=760000
* device instance $30 r0 *1 2.855,0.415 sky130_fd_pr__nfet_01v8
XM$30 \$7 \$5 \$13 sky130_gnd sky130_fd_pr__nfet_01v8 L=150000 W=360000
+ AS=72000000000 AD=67050000000 PS=760000 PD=750000
* device instance $31 r0 *1 3.335,0.445 sky130_fd_pr__nfet_01v8
XM$31 \$13 \$20 VGND sky130_gnd sky130_fd_pr__nfet_01v8 L=150000 W=420000
+ AS=67050000000 AD=88200000000 PS=750000 PD=840000
* device instance $32 r0 *1 3.905,0.445 sky130_fd_pr__nfet_01v8
XM$32 VGND SET_B \$16 sky130_gnd sky130_fd_pr__nfet_01v8 L=150000 W=420000
+ AS=88200000000 AD=44100000000 PS=840000 PD=630000
* device instance $33 r0 *1 4.265,0.445 sky130_fd_pr__nfet_01v8
XM$33 \$16 \$7 \$20 sky130_gnd sky130_fd_pr__nfet_01v8 L=150000 W=420000
+ AS=44100000000 AD=109200000000 PS=630000 PD=1360000
* device instance $34 r0 *1 1.83,0.555 sky130_fd_pr__nfet_01v8
XM$34 VGND D \$6 sky130_gnd sky130_fd_pr__nfet_01v8 L=150000 W=640000
+ AS=166400000000 AD=93500000000 PS=1800000 PD=965000
.ENDS sky130_fd_sc_hd__dfstp_2

* cell sky130_fd_sc_hd__o221a_2
* pin VGND
* pin X
* pin C1
* pin B1
* pin B2
* pin A2
* pin A1
* pin VPWR
* pin VPB
* pin sky130_gnd
.SUBCKT sky130_fd_sc_hd__o221a_2 VGND X C1 B1 B2 A2 A1 VPWR VPB sky130_gnd
* device instance $1 r0 *1 0.63,1.985 sky130_fd_pr__pfet_01v8_hvt
XM$1 \$3 C1 VPWR VPB sky130_fd_pr__pfet_01v8_hvt L=150000 W=1000000
+ AS=325000000000 AD=165000000000 PS=2650000 PD=1330000
* device instance $2 r0 *1 1.11,1.985 sky130_fd_pr__pfet_01v8_hvt
XM$2 VPWR B1 \$14 VPB sky130_fd_pr__pfet_01v8_hvt L=150000 W=1000000
+ AS=165000000000 AD=112500000000 PS=1330000 PD=1225000
* device instance $3 r0 *1 1.485,1.985 sky130_fd_pr__pfet_01v8_hvt
XM$3 \$14 B2 \$3 VPB sky130_fd_pr__pfet_01v8_hvt L=150000 W=1000000
+ AS=112500000000 AD=387500000000 PS=1225000 PD=1775000
* device instance $4 r0 *1 2.41,1.985 sky130_fd_pr__pfet_01v8_hvt
XM$4 \$3 A2 \$15 VPB sky130_fd_pr__pfet_01v8_hvt L=150000 W=1000000
+ AS=387500000000 AD=105000000000 PS=1775000 PD=1210000
* device instance $5 r0 *1 2.77,1.985 sky130_fd_pr__pfet_01v8_hvt
XM$5 \$15 A1 VPWR VPB sky130_fd_pr__pfet_01v8_hvt L=150000 W=1000000
+ AS=105000000000 AD=165000000000 PS=1210000 PD=1330000
* device instance $6 r0 *1 3.25,1.985 sky130_fd_pr__pfet_01v8_hvt
XM$6 VPWR \$3 X VPB sky130_fd_pr__pfet_01v8_hvt L=150000 W=2000000
+ AS=300000000000 AD=395000000000 PS=2600000 PD=3790000
* device instance $8 r0 *1 2.41,0.56 sky130_fd_pr__nfet_01v8
XM$8 VGND A2 \$5 sky130_gnd sky130_fd_pr__nfet_01v8 L=150000 W=650000
+ AS=169000000000 AD=87750000000 PS=1820000 PD=920000
* device instance $9 r0 *1 2.83,0.56 sky130_fd_pr__nfet_01v8
XM$9 \$5 A1 VGND sky130_gnd sky130_fd_pr__nfet_01v8 L=150000 W=650000
+ AS=87750000000 AD=87750000000 PS=920000 PD=920000
* device instance $10 r0 *1 3.25,0.56 sky130_fd_pr__nfet_01v8
XM$10 VGND \$3 X sky130_gnd sky130_fd_pr__nfet_01v8 L=150000 W=1300000
+ AS=175500000000 AD=256750000000 PS=1840000 PD=2740000
* device instance $12 r0 *1 0.63,0.56 sky130_fd_pr__nfet_01v8
XM$12 \$3 C1 \$4 sky130_gnd sky130_fd_pr__nfet_01v8 L=150000 W=650000
+ AS=237250000000 AD=87750000000 PS=2030000 PD=920000
* device instance $13 r0 *1 1.05,0.56 sky130_fd_pr__nfet_01v8
XM$13 \$4 B1 \$5 sky130_gnd sky130_fd_pr__nfet_01v8 L=150000 W=650000
+ AS=87750000000 AD=87750000000 PS=920000 PD=920000
* device instance $14 r0 *1 1.47,0.56 sky130_fd_pr__nfet_01v8
XM$14 \$5 B2 \$4 sky130_gnd sky130_fd_pr__nfet_01v8 L=150000 W=650000
+ AS=87750000000 AD=169000000000 PS=920000 PD=1820000
.ENDS sky130_fd_sc_hd__o221a_2

* cell sky130_fd_sc_hd__o21ai_2
* pin VPB
* pin VPWR
* pin A1
* pin VGND
* pin A2
* pin Y
* pin B1
* pin sky130_gnd
.SUBCKT sky130_fd_sc_hd__o21ai_2 VPB VPWR A1 VGND A2 Y B1 sky130_gnd
* device instance $1 r0 *1 0.485,1.985 sky130_fd_pr__pfet_01v8_hvt
XM$1 VPWR A1 \$5 VPB sky130_fd_pr__pfet_01v8_hvt L=150000 W=2000000
+ AS=440000000000 AD=300000000000 PS=3880000 PD=2600000
* device instance $2 r0 *1 0.915,1.985 sky130_fd_pr__pfet_01v8_hvt
XM$2 \$5 A2 Y VPB sky130_fd_pr__pfet_01v8_hvt L=150000 W=2000000
+ AS=280000000000 AD=315000000000 PS=2560000 PD=2630000
* device instance $5 r0 *1 2.315,1.985 sky130_fd_pr__pfet_01v8_hvt
XM$5 VPWR B1 Y VPB sky130_fd_pr__pfet_01v8_hvt L=150000 W=2000000
+ AS=300000000000 AD=405000000000 PS=2600000 PD=3810000
* device instance $7 r0 *1 0.485,0.56 sky130_fd_pr__nfet_01v8
XM$7 \$2 A1 VGND sky130_gnd sky130_fd_pr__nfet_01v8 L=150000 W=1300000
+ AS=299000000000 AD=182000000000 PS=2870000 PD=1860000
* device instance $8 r0 *1 0.915,0.56 sky130_fd_pr__nfet_01v8
XM$8 VGND A2 \$2 sky130_gnd sky130_fd_pr__nfet_01v8 L=150000 W=1300000
+ AS=182000000000 AD=217750000000 PS=1860000 PD=1970000
* device instance $11 r0 *1 2.315,0.56 sky130_fd_pr__nfet_01v8
XM$11 \$2 B1 Y sky130_gnd sky130_fd_pr__nfet_01v8 L=150000 W=1300000
+ AS=182000000000 AD=263250000000 PS=1860000 PD=2760000
.ENDS sky130_fd_sc_hd__o21ai_2

* cell sky130_fd_sc_hd__nor4_2
* pin VGND
* pin Y
* pin A
* pin B
* pin C
* pin D
* pin VPWR
* pin VPB
* pin sky130_gnd
.SUBCKT sky130_fd_sc_hd__nor4_2 VGND Y A B C D VPWR VPB sky130_gnd
* device instance $1 r0 *1 2.73,1.985 sky130_fd_pr__pfet_01v8_hvt
XM$1 \$11 C \$10 VPB sky130_fd_pr__pfet_01v8_hvt L=150000 W=2000000
+ AS=415000000000 AD=270000000000 PS=3830000 PD=2540000
* device instance $3 r0 *1 3.57,1.985 sky130_fd_pr__pfet_01v8_hvt
XM$3 \$11 D Y VPB sky130_fd_pr__pfet_01v8_hvt L=150000 W=2000000
+ AS=270000000000 AD=395000000000 PS=2540000 PD=3790000
* device instance $5 r0 *1 0.49,1.985 sky130_fd_pr__pfet_01v8_hvt
XM$5 \$8 A VPWR VPB sky130_fd_pr__pfet_01v8_hvt L=150000 W=2000000
+ AS=415000000000 AD=270000000000 PS=3830000 PD=2540000
* device instance $7 r0 *1 1.33,1.985 sky130_fd_pr__pfet_01v8_hvt
XM$7 \$8 B \$10 VPB sky130_fd_pr__pfet_01v8_hvt L=150000 W=2000000
+ AS=270000000000 AD=415000000000 PS=2540000 PD=3830000
* device instance $9 r0 *1 2.73,0.56 sky130_fd_pr__nfet_01v8
XM$9 VGND C Y sky130_gnd sky130_fd_pr__nfet_01v8 L=150000 W=1300000
+ AS=269750000000 AD=175500000000 PS=2780000 PD=1840000
* device instance $11 r0 *1 3.57,0.56 sky130_fd_pr__nfet_01v8
XM$11 VGND D Y sky130_gnd sky130_fd_pr__nfet_01v8 L=150000 W=1300000
+ AS=175500000000 AD=256750000000 PS=1840000 PD=2740000
* device instance $13 r0 *1 0.49,0.56 sky130_fd_pr__nfet_01v8
XM$13 VGND A Y sky130_gnd sky130_fd_pr__nfet_01v8 L=150000 W=1300000
+ AS=269750000000 AD=175500000000 PS=2780000 PD=1840000
* device instance $15 r0 *1 1.33,0.56 sky130_fd_pr__nfet_01v8
XM$15 VGND B Y sky130_gnd sky130_fd_pr__nfet_01v8 L=150000 W=1300000
+ AS=175500000000 AD=269750000000 PS=1840000 PD=2780000
.ENDS sky130_fd_sc_hd__nor4_2

* cell sky130_fd_sc_hd__clkbuf_16
* pin VGND
* pin A
* pin X
* pin VPWR
* pin VPB
* pin sky130_gnd
.SUBCKT sky130_fd_sc_hd__clkbuf_16 VGND A X VPWR VPB sky130_gnd
* device instance $1 r0 *1 0.475,1.985 sky130_fd_pr__pfet_01v8_hvt
XM$1 VPWR A \$3 VPB sky130_fd_pr__pfet_01v8_hvt L=150000 W=4000000
+ AS=685000000000 AD=560000000000 PS=6370000 PD=5120000
* device instance $5 r0 *1 2.195,1.985 sky130_fd_pr__pfet_01v8_hvt
XM$5 VPWR \$3 X VPB sky130_fd_pr__pfet_01v8_hvt L=150000 W=16000000
+ AS=2.2375e+12 AD=2.3625e+12 PS=20475000 PD=21725000
* device instance $21 r0 *1 0.475,0.445 sky130_fd_pr__nfet_01v8
XM$21 VGND A \$3 sky130_gnd sky130_fd_pr__nfet_01v8 L=150000 W=1680000
+ AS=287700000000 AD=235200000000 PS=3470000 PD=2800000
* device instance $25 r0 *1 2.195,0.445 sky130_fd_pr__nfet_01v8
XM$25 VGND \$3 X sky130_gnd sky130_fd_pr__nfet_01v8 L=150000 W=6720000
+ AS=939750000000 AD=992250000000 PS=11195000 PD=11865000
.ENDS sky130_fd_sc_hd__clkbuf_16

* cell sky130_fd_sc_hd__and2b_2
* pin VPB
* pin A_N
* pin VPWR
* pin B
* pin VGND
* pin X
* pin sky130_gnd
.SUBCKT sky130_fd_sc_hd__and2b_2 VPB A_N VPWR B VGND X sky130_gnd
* device instance $1 r0 *1 0.47,2.275 sky130_fd_pr__pfet_01v8_hvt
XM$1 \$4 A_N VPWR VPB sky130_fd_pr__pfet_01v8_hvt L=150000 W=420000
+ AS=109200000000 AD=76650000000 PS=1360000 PD=785000
* device instance $2 r0 *1 0.985,2.275 sky130_fd_pr__pfet_01v8_hvt
XM$2 VPWR \$4 \$5 VPB sky130_fd_pr__pfet_01v8_hvt L=150000 W=420000
+ AS=76650000000 AD=60900000000 PS=785000 PD=710000
* device instance $3 r0 *1 1.425,2.275 sky130_fd_pr__pfet_01v8_hvt
XM$3 VPWR B \$5 VPB sky130_fd_pr__pfet_01v8_hvt L=150000 W=420000
+ AS=228950000000 AD=60900000000 PS=1745000 PD=710000
* device instance $4 r0 *1 2.32,1.985 sky130_fd_pr__pfet_01v8_hvt
XM$4 VPWR \$5 X VPB sky130_fd_pr__pfet_01v8_hvt L=150000 W=2000000
+ AS=363950000000 AD=395000000000 PS=3015000 PD=3790000
* device instance $6 r0 *1 1.41,0.445 sky130_fd_pr__nfet_01v8
XM$6 \$5 \$4 \$10 sky130_gnd sky130_fd_pr__nfet_01v8 L=150000 W=420000
+ AS=109200000000 AD=56700000000 PS=1360000 PD=690000
* device instance $7 r0 *1 1.83,0.445 sky130_fd_pr__nfet_01v8
XM$7 \$10 B VGND sky130_gnd sky130_fd_pr__nfet_01v8 L=150000 W=420000
+ AS=56700000000 AD=101875000000 PS=690000 PD=990000
* device instance $8 r0 *1 2.32,0.56 sky130_fd_pr__nfet_01v8
XM$8 VGND \$5 X sky130_gnd sky130_fd_pr__nfet_01v8 L=150000 W=1300000
+ AS=189625000000 AD=263250000000 PS=1910000 PD=2760000
* device instance $10 r0 *1 0.47,0.445 sky130_fd_pr__nfet_01v8
XM$10 VGND A_N \$4 sky130_gnd sky130_fd_pr__nfet_01v8 L=150000 W=420000
+ AS=109200000000 AD=109200000000 PS=1360000 PD=1360000
.ENDS sky130_fd_sc_hd__and2b_2

* cell sky130_fd_sc_hd__and4bb_2
* pin VGND
* pin X
* pin C
* pin D
* pin B_N
* pin A_N
* pin VPWR
* pin VPB
* pin sky130_gnd
.SUBCKT sky130_fd_sc_hd__and4bb_2 VGND X C D B_N A_N VPWR VPB sky130_gnd
* device instance $1 r0 *1 0.47,2.275 sky130_fd_pr__pfet_01v8_hvt
XM$1 VPWR A_N \$3 VPB sky130_fd_pr__pfet_01v8_hvt L=150000 W=420000
+ AS=140750000000 AD=109200000000 PS=1325000 PD=1360000
* device instance $2 r0 *1 0.945,1.985 sky130_fd_pr__pfet_01v8_hvt
XM$2 VPWR \$5 X VPB sky130_fd_pr__pfet_01v8_hvt L=150000 W=2000000
+ AS=275750000000 AD=465750000000 PS=2595000 PD=2975000
* device instance $4 r0 *1 2.22,2.275 sky130_fd_pr__pfet_01v8_hvt
XM$4 VPWR \$3 \$5 VPB sky130_fd_pr__pfet_01v8_hvt L=150000 W=420000
+ AS=330750000000 AD=67200000000 PS=1705000 PD=740000
* device instance $5 r0 *1 2.69,2.275 sky130_fd_pr__pfet_01v8_hvt
XM$5 \$5 \$13 VPWR VPB sky130_fd_pr__pfet_01v8_hvt L=150000 W=420000
+ AS=67200000000 AD=58800000000 PS=740000 PD=700000
* device instance $6 r0 *1 3.12,2.275 sky130_fd_pr__pfet_01v8_hvt
XM$6 VPWR C \$5 VPB sky130_fd_pr__pfet_01v8_hvt L=150000 W=420000
+ AS=58800000000 AD=56700000000 PS=700000 PD=690000
* device instance $7 r0 *1 3.54,2.275 sky130_fd_pr__pfet_01v8_hvt
XM$7 \$5 D VPWR VPB sky130_fd_pr__pfet_01v8_hvt L=150000 W=420000
+ AS=56700000000 AD=92400000000 PS=690000 PD=860000
* device instance $8 r0 *1 4.13,2.275 sky130_fd_pr__pfet_01v8_hvt
XM$8 VPWR B_N \$13 VPB sky130_fd_pr__pfet_01v8_hvt L=150000 W=420000
+ AS=92400000000 AD=109200000000 PS=860000 PD=1360000
* device instance $9 r0 *1 0.47,0.445 sky130_fd_pr__nfet_01v8
XM$9 \$3 A_N VGND sky130_gnd sky130_fd_pr__nfet_01v8 L=150000 W=420000
+ AS=109200000000 AD=97000000000 PS=1360000 PD=975000
* device instance $10 r0 *1 0.945,0.56 sky130_fd_pr__nfet_01v8
XM$10 VGND \$5 X sky130_gnd sky130_fd_pr__nfet_01v8 L=150000 W=1300000
+ AS=184750000000 AD=256750000000 PS=1895000 PD=2740000
* device instance $12 r0 *1 2.305,0.445 sky130_fd_pr__nfet_01v8
XM$12 \$5 \$3 \$10 sky130_gnd sky130_fd_pr__nfet_01v8 L=150000 W=420000
+ AS=109200000000 AD=44100000000 PS=1360000 PD=630000
* device instance $13 r0 *1 2.665,0.445 sky130_fd_pr__nfet_01v8
XM$13 \$10 \$13 \$11 sky130_gnd sky130_fd_pr__nfet_01v8 L=150000 W=420000
+ AS=44100000000 AD=64050000000 PS=630000 PD=725000
* device instance $14 r0 *1 3.12,0.445 sky130_fd_pr__nfet_01v8
XM$14 \$11 C \$9 sky130_gnd sky130_fd_pr__nfet_01v8 L=150000 W=420000
+ AS=64050000000 AD=56700000000 PS=725000 PD=690000
* device instance $15 r0 *1 3.54,0.445 sky130_fd_pr__nfet_01v8
XM$15 \$9 D VGND sky130_gnd sky130_fd_pr__nfet_01v8 L=150000 W=420000
+ AS=56700000000 AD=92400000000 PS=690000 PD=860000
* device instance $16 r0 *1 4.13,0.445 sky130_fd_pr__nfet_01v8
XM$16 VGND B_N \$13 sky130_gnd sky130_fd_pr__nfet_01v8 L=150000 W=420000
+ AS=92400000000 AD=109200000000 PS=860000 PD=1360000
.ENDS sky130_fd_sc_hd__and4bb_2

* cell sky130_fd_sc_hd__nor3_2
* pin VPB
* pin C
* pin Y
* pin VGND
* pin A
* pin VPWR
* pin B
* pin sky130_gnd
.SUBCKT sky130_fd_sc_hd__nor3_2 VPB C Y VGND A VPWR B sky130_gnd
* device instance $1 r0 *1 2.71,1.985 sky130_fd_pr__pfet_01v8_hvt
XM$1 \$3 C Y VPB sky130_fd_pr__pfet_01v8_hvt L=150000 W=2000000 AS=395000000000
+ AD=395000000000 PS=3790000 PD=3790000
* device instance $3 r0 *1 0.49,1.985 sky130_fd_pr__pfet_01v8_hvt
XM$3 \$2 A VPWR VPB sky130_fd_pr__pfet_01v8_hvt L=150000 W=2000000
+ AS=415000000000 AD=270000000000 PS=3830000 PD=2540000
* device instance $5 r0 *1 1.33,1.985 sky130_fd_pr__pfet_01v8_hvt
XM$5 \$2 B \$3 VPB sky130_fd_pr__pfet_01v8_hvt L=150000 W=2000000
+ AS=270000000000 AD=415000000000 PS=2540000 PD=3830000
* device instance $7 r0 *1 2.71,0.56 sky130_fd_pr__nfet_01v8
XM$7 VGND C Y sky130_gnd sky130_fd_pr__nfet_01v8 L=150000 W=1300000
+ AS=256750000000 AD=256750000000 PS=2740000 PD=2740000
* device instance $9 r0 *1 0.49,0.56 sky130_fd_pr__nfet_01v8
XM$9 VGND A Y sky130_gnd sky130_fd_pr__nfet_01v8 L=150000 W=1300000
+ AS=266500000000 AD=175500000000 PS=2770000 PD=1840000
* device instance $11 r0 *1 1.33,0.56 sky130_fd_pr__nfet_01v8
XM$11 VGND B Y sky130_gnd sky130_fd_pr__nfet_01v8 L=150000 W=1300000
+ AS=175500000000 AD=256750000000 PS=1840000 PD=2740000
.ENDS sky130_fd_sc_hd__nor3_2

* cell sky130_fd_sc_hd__nor3b_2
* pin VGND
* pin Y
* pin A
* pin B
* pin C_N
* pin VPWR
* pin VPB
* pin sky130_gnd
.SUBCKT sky130_fd_sc_hd__nor3b_2 VGND Y A B C_N VPWR VPB sky130_gnd
* device instance $1 r0 *1 2.73,1.985 sky130_fd_pr__pfet_01v8_hvt
XM$1 \$10 \$6 Y VPB sky130_fd_pr__pfet_01v8_hvt L=150000 W=2000000
+ AS=415000000000 AD=415000000000 PS=3830000 PD=3830000
* device instance $3 r0 *1 0.49,1.985 sky130_fd_pr__pfet_01v8_hvt
XM$3 \$8 A VPWR VPB sky130_fd_pr__pfet_01v8_hvt L=150000 W=2000000
+ AS=415000000000 AD=270000000000 PS=3830000 PD=2540000
* device instance $5 r0 *1 1.33,1.985 sky130_fd_pr__pfet_01v8_hvt
XM$5 \$8 B \$10 VPB sky130_fd_pr__pfet_01v8_hvt L=150000 W=2000000
+ AS=270000000000 AD=415000000000 PS=2540000 PD=3830000
* device instance $7 r0 *1 4.13,1.695 sky130_fd_pr__pfet_01v8_hvt
XM$7 \$6 C_N VPWR VPB sky130_fd_pr__pfet_01v8_hvt L=150000 W=420000
+ AS=109200000000 AD=109200000000 PS=1360000 PD=1360000
* device instance $8 r0 *1 4.13,0.675 sky130_fd_pr__nfet_01v8
XM$8 \$6 C_N VGND sky130_gnd sky130_fd_pr__nfet_01v8 L=150000 W=420000
+ AS=109200000000 AD=109200000000 PS=1360000 PD=1360000
* device instance $9 r0 *1 2.73,0.56 sky130_fd_pr__nfet_01v8
XM$9 VGND \$6 Y sky130_gnd sky130_fd_pr__nfet_01v8 L=150000 W=1300000
+ AS=256750000000 AD=269750000000 PS=2740000 PD=2780000
* device instance $11 r0 *1 0.49,0.56 sky130_fd_pr__nfet_01v8
XM$11 VGND A Y sky130_gnd sky130_fd_pr__nfet_01v8 L=150000 W=1300000
+ AS=269750000000 AD=175500000000 PS=2780000 PD=1840000
* device instance $13 r0 *1 1.33,0.56 sky130_fd_pr__nfet_01v8
XM$13 VGND B Y sky130_gnd sky130_fd_pr__nfet_01v8 L=150000 W=1300000
+ AS=175500000000 AD=256750000000 PS=1840000 PD=2740000
.ENDS sky130_fd_sc_hd__nor3b_2

* cell sky130_fd_sc_hd__o211a_2
* pin VPB
* pin C1
* pin VPWR
* pin B1
* pin VGND
* pin A2
* pin A1
* pin X
* pin sky130_gnd
.SUBCKT sky130_fd_sc_hd__o211a_2 VPB C1 VPWR B1 VGND A2 A1 X sky130_gnd
* device instance $1 r0 *1 0.475,1.985 sky130_fd_pr__pfet_01v8_hvt
XM$1 \$2 C1 VPWR VPB sky130_fd_pr__pfet_01v8_hvt L=150000 W=1000000
+ AS=265000000000 AD=140000000000 PS=2530000 PD=1280000
* device instance $2 r0 *1 0.905,1.985 sky130_fd_pr__pfet_01v8_hvt
XM$2 VPWR B1 \$2 VPB sky130_fd_pr__pfet_01v8_hvt L=150000 W=1000000
+ AS=140000000000 AD=367500000000 PS=1280000 PD=1735000
* device instance $3 r0 *1 1.79,1.985 sky130_fd_pr__pfet_01v8_hvt
XM$3 \$2 A2 \$13 VPB sky130_fd_pr__pfet_01v8_hvt L=150000 W=1000000
+ AS=367500000000 AD=105000000000 PS=1735000 PD=1210000
* device instance $4 r0 *1 2.15,1.985 sky130_fd_pr__pfet_01v8_hvt
XM$4 \$13 A1 VPWR VPB sky130_fd_pr__pfet_01v8_hvt L=150000 W=1000000
+ AS=105000000000 AD=195000000000 PS=1210000 PD=1390000
* device instance $5 r0 *1 2.69,1.985 sky130_fd_pr__pfet_01v8_hvt
XM$5 VPWR \$2 X VPB sky130_fd_pr__pfet_01v8_hvt L=150000 W=2000000
+ AS=335000000000 AD=405000000000 PS=2670000 PD=3810000
* device instance $7 r0 *1 1.77,0.56 sky130_fd_pr__nfet_01v8
XM$7 VGND A2 \$6 sky130_gnd sky130_fd_pr__nfet_01v8 L=150000 W=650000
+ AS=165350000000 AD=91000000000 PS=1820000 PD=930000
* device instance $8 r0 *1 2.2,0.56 sky130_fd_pr__nfet_01v8
XM$8 \$6 A1 VGND sky130_gnd sky130_fd_pr__nfet_01v8 L=150000 W=650000
+ AS=91000000000 AD=104000000000 PS=930000 PD=970000
* device instance $9 r0 *1 2.67,0.56 sky130_fd_pr__nfet_01v8
XM$9 VGND \$2 X sky130_gnd sky130_fd_pr__nfet_01v8 L=150000 W=1300000
+ AS=195000000000 AD=321750000000 PS=1900000 PD=2940000
* device instance $11 r0 *1 0.475,0.56 sky130_fd_pr__nfet_01v8
XM$11 \$2 C1 \$12 sky130_gnd sky130_fd_pr__nfet_01v8 L=150000 W=650000
+ AS=172250000000 AD=68250000000 PS=1830000 PD=860000
* device instance $12 r0 *1 0.835,0.56 sky130_fd_pr__nfet_01v8
XM$12 \$12 B1 \$6 sky130_gnd sky130_fd_pr__nfet_01v8 L=150000 W=650000
+ AS=68250000000 AD=165350000000 PS=860000 PD=1820000
.ENDS sky130_fd_sc_hd__o211a_2

* cell sky130_fd_sc_hd__or3_2
* pin VPB
* pin C
* pin VPWR
* pin VGND
* pin X
* pin A
* pin B
* pin sky130_gnd
.SUBCKT sky130_fd_sc_hd__or3_2 VPB C VPWR VGND X A B sky130_gnd
* device instance $1 r0 *1 0.485,1.695 sky130_fd_pr__pfet_01v8_hvt
XM$1 \$7 C \$11 VPB sky130_fd_pr__pfet_01v8_hvt L=150000 W=420000
+ AS=109200000000 AD=44100000000 PS=1360000 PD=630000
* device instance $2 r0 *1 0.845,1.695 sky130_fd_pr__pfet_01v8_hvt
XM$2 \$11 B \$10 VPB sky130_fd_pr__pfet_01v8_hvt L=150000 W=420000
+ AS=44100000000 AD=69300000000 PS=630000 PD=750000
* device instance $3 r0 *1 1.325,1.695 sky130_fd_pr__pfet_01v8_hvt
XM$3 \$10 A VPWR VPB sky130_fd_pr__pfet_01v8_hvt L=150000 W=420000
+ AS=69300000000 AD=148250000000 PS=750000 PD=1340000
* device instance $4 r0 *1 1.815,1.985 sky130_fd_pr__pfet_01v8_hvt
XM$4 VPWR \$7 X VPB sky130_fd_pr__pfet_01v8_hvt L=150000 W=2000000
+ AS=283250000000 AD=450000000000 PS=2610000 PD=3900000
* device instance $6 r0 *1 0.485,0.475 sky130_fd_pr__nfet_01v8
XM$6 \$7 C VGND sky130_gnd sky130_fd_pr__nfet_01v8 L=150000 W=420000
+ AS=109200000000 AD=56700000000 PS=1360000 PD=690000
* device instance $7 r0 *1 0.905,0.475 sky130_fd_pr__nfet_01v8
XM$7 VGND B \$7 sky130_gnd sky130_fd_pr__nfet_01v8 L=150000 W=420000
+ AS=56700000000 AD=56700000000 PS=690000 PD=690000
* device instance $8 r0 *1 1.325,0.475 sky130_fd_pr__nfet_01v8
XM$8 VGND A \$7 sky130_gnd sky130_fd_pr__nfet_01v8 L=150000 W=420000
+ AS=101875000000 AD=56700000000 PS=990000 PD=690000
* device instance $9 r0 *1 1.815,0.56 sky130_fd_pr__nfet_01v8
XM$9 VGND \$7 X sky130_gnd sky130_fd_pr__nfet_01v8 L=150000 W=1300000
+ AS=189625000000 AD=273000000000 PS=1910000 PD=2790000
.ENDS sky130_fd_sc_hd__or3_2

* cell sky130_fd_sc_hd__nor2_2
* pin VPB
* pin VGND
* pin A
* pin Y
* pin B
* pin VPWR
* pin sky130_gnd
.SUBCKT sky130_fd_sc_hd__nor2_2 VPB VGND A Y B VPWR sky130_gnd
* device instance $1 r0 *1 0.49,1.985 sky130_fd_pr__pfet_01v8_hvt
XM$1 \$3 A VPWR VPB sky130_fd_pr__pfet_01v8_hvt L=150000 W=2000000
+ AS=415000000000 AD=270000000000 PS=3830000 PD=2540000
* device instance $3 r0 *1 1.33,1.985 sky130_fd_pr__pfet_01v8_hvt
XM$3 \$3 B Y VPB sky130_fd_pr__pfet_01v8_hvt L=150000 W=2000000 AS=270000000000
+ AD=395000000000 PS=2540000 PD=3790000
* device instance $5 r0 *1 0.49,0.56 sky130_fd_pr__nfet_01v8
XM$5 VGND A Y sky130_gnd sky130_fd_pr__nfet_01v8 L=150000 W=1300000
+ AS=269750000000 AD=175500000000 PS=2780000 PD=1840000
* device instance $7 r0 *1 1.33,0.56 sky130_fd_pr__nfet_01v8
XM$7 VGND B Y sky130_gnd sky130_fd_pr__nfet_01v8 L=150000 W=1300000
+ AS=175500000000 AD=256750000000 PS=1840000 PD=2740000
.ENDS sky130_fd_sc_hd__nor2_2

* cell sky130_fd_sc_hd__nand3_2
* pin VGND
* pin Y
* pin A
* pin B
* pin C
* pin VPWR
* pin VPB
* pin sky130_gnd
.SUBCKT sky130_fd_sc_hd__nand3_2 VGND Y A B C VPWR VPB sky130_gnd
* device instance $1 r0 *1 2.67,1.985 sky130_fd_pr__pfet_01v8_hvt
XM$1 VPWR C Y VPB sky130_fd_pr__pfet_01v8_hvt L=150000 W=2000000
+ AS=395000000000 AD=445000000000 PS=3790000 PD=3890000
* device instance $3 r0 *1 0.47,1.985 sky130_fd_pr__pfet_01v8_hvt
XM$3 VPWR A Y VPB sky130_fd_pr__pfet_01v8_hvt L=150000 W=2000000
+ AS=395000000000 AD=270000000000 PS=3790000 PD=2540000
* device instance $5 r0 *1 1.31,1.985 sky130_fd_pr__pfet_01v8_hvt
XM$5 VPWR B Y VPB sky130_fd_pr__pfet_01v8_hvt L=150000 W=2000000
+ AS=270000000000 AD=395000000000 PS=2540000 PD=3790000
* device instance $7 r0 *1 2.67,0.56 sky130_fd_pr__nfet_01v8
XM$7 VGND C \$5 sky130_gnd sky130_fd_pr__nfet_01v8 L=150000 W=1300000
+ AS=256750000000 AD=289250000000 PS=2740000 PD=2840000
* device instance $9 r0 *1 0.47,0.56 sky130_fd_pr__nfet_01v8
XM$9 \$3 A Y sky130_gnd sky130_fd_pr__nfet_01v8 L=150000 W=1300000
+ AS=256750000000 AD=175500000000 PS=2740000 PD=1840000
* device instance $11 r0 *1 1.31,0.56 sky130_fd_pr__nfet_01v8
XM$11 \$3 B \$5 sky130_gnd sky130_fd_pr__nfet_01v8 L=150000 W=1300000
+ AS=175500000000 AD=256750000000 PS=1840000 PD=2740000
.ENDS sky130_fd_sc_hd__nand3_2

* cell sky130_fd_sc_hd__and4b_2
* pin VGND
* pin B
* pin C
* pin X
* pin A_N
* pin D
* pin VPWR
* pin VPB
* pin sky130_gnd
.SUBCKT sky130_fd_sc_hd__and4b_2 VGND B C X A_N D VPWR VPB sky130_gnd
* device instance $1 r0 *1 0.47,2.275 sky130_fd_pr__pfet_01v8_hvt
XM$1 \$3 A_N VPWR VPB sky130_fd_pr__pfet_01v8_hvt L=150000 W=420000
+ AS=109200000000 AD=56700000000 PS=1360000 PD=690000
* device instance $2 r0 *1 0.89,2.275 sky130_fd_pr__pfet_01v8_hvt
XM$2 VPWR \$3 \$4 VPB sky130_fd_pr__pfet_01v8_hvt L=150000 W=420000
+ AS=56700000000 AD=98700000000 PS=690000 PD=890000
* device instance $3 r0 *1 1.51,2.275 sky130_fd_pr__pfet_01v8_hvt
XM$3 \$4 B VPWR VPB sky130_fd_pr__pfet_01v8_hvt L=150000 W=420000
+ AS=98700000000 AD=128100000000 PS=890000 PD=1030000
* device instance $4 r0 *1 2.27,2.275 sky130_fd_pr__pfet_01v8_hvt
XM$4 VPWR C \$4 VPB sky130_fd_pr__pfet_01v8_hvt L=150000 W=420000
+ AS=128100000000 AD=66150000000 PS=1030000 PD=735000
* device instance $5 r0 *1 2.735,2.275 sky130_fd_pr__pfet_01v8_hvt
XM$5 VPWR D \$4 VPB sky130_fd_pr__pfet_01v8_hvt L=150000 W=420000
+ AS=143250000000 AD=66150000000 PS=1330000 PD=735000
* device instance $6 r0 *1 3.215,1.985 sky130_fd_pr__pfet_01v8_hvt
XM$6 VPWR \$4 X VPB sky130_fd_pr__pfet_01v8_hvt L=150000 W=2000000
+ AS=295750000000 AD=412500000000 PS=2635000 PD=3825000
* device instance $8 r0 *1 1.41,0.445 sky130_fd_pr__nfet_01v8
XM$8 \$4 \$3 \$9 sky130_gnd sky130_fd_pr__nfet_01v8 L=150000 W=420000
+ AS=109200000000 AD=44100000000 PS=1360000 PD=630000
* device instance $9 r0 *1 1.77,0.445 sky130_fd_pr__nfet_01v8
XM$9 \$9 B \$10 sky130_gnd sky130_fd_pr__nfet_01v8 L=150000 W=420000
+ AS=44100000000 AD=73500000000 PS=630000 PD=770000
* device instance $10 r0 *1 2.27,0.445 sky130_fd_pr__nfet_01v8
XM$10 \$10 C \$8 sky130_gnd sky130_fd_pr__nfet_01v8 L=150000 W=420000
+ AS=73500000000 AD=61950000000 PS=770000 PD=715000
* device instance $11 r0 *1 2.715,0.445 sky130_fd_pr__nfet_01v8
XM$11 \$8 D VGND sky130_gnd sky130_fd_pr__nfet_01v8 L=150000 W=420000
+ AS=61950000000 AD=103975000000 PS=715000 PD=1000000
* device instance $12 r0 *1 3.215,0.56 sky130_fd_pr__nfet_01v8
XM$12 VGND \$4 X sky130_gnd sky130_fd_pr__nfet_01v8 L=150000 W=1300000
+ AS=203100000000 AD=268125000000 PS=1955000 PD=2775000
* device instance $14 r0 *1 0.47,0.445 sky130_fd_pr__nfet_01v8
XM$14 VGND A_N \$3 sky130_gnd sky130_fd_pr__nfet_01v8 L=150000 W=420000
+ AS=109200000000 AD=109200000000 PS=1360000 PD=1360000
.ENDS sky130_fd_sc_hd__and4b_2

* cell sky130_fd_sc_hd__nand2b_2
* pin VPB
* pin B
* pin VPWR
* pin VGND
* pin Y
* pin A_N
* pin sky130_gnd
.SUBCKT sky130_fd_sc_hd__nand2b_2 VPB B VPWR VGND Y A_N sky130_gnd
* device instance $1 r0 *1 0.47,1.695 sky130_fd_pr__pfet_01v8_hvt
XM$1 \$2 A_N VPWR VPB sky130_fd_pr__pfet_01v8_hvt L=150000 W=420000
+ AS=109200000000 AD=146800000000 PS=1360000 PD=1340000
* device instance $2 r0 *1 0.96,1.985 sky130_fd_pr__pfet_01v8_hvt
XM$2 VPWR \$2 Y VPB sky130_fd_pr__pfet_01v8_hvt L=150000 W=2000000
+ AS=311800000000 AD=500000000000 PS=2670000 PD=3000000
* device instance $4 r0 *1 2.26,1.985 sky130_fd_pr__pfet_01v8_hvt
XM$4 VPWR B Y VPB sky130_fd_pr__pfet_01v8_hvt L=150000 W=2000000
+ AS=470000000000 AD=410000000000 PS=2940000 PD=3820000
* device instance $6 r0 *1 1.48,0.56 sky130_fd_pr__nfet_01v8
XM$6 \$3 \$2 Y sky130_gnd sky130_fd_pr__nfet_01v8 L=150000 W=1300000
+ AS=256750000000 AD=175500000000 PS=2740000 PD=1840000
* device instance $8 r0 *1 2.32,0.56 sky130_fd_pr__nfet_01v8
XM$8 \$3 B VGND sky130_gnd sky130_fd_pr__nfet_01v8 L=150000 W=1300000
+ AS=175500000000 AD=256750000000 PS=1840000 PD=2740000
* device instance $10 r0 *1 0.47,0.675 sky130_fd_pr__nfet_01v8
XM$10 VGND A_N \$2 sky130_gnd sky130_fd_pr__nfet_01v8 L=150000 W=420000
+ AS=194000000000 AD=109200000000 PS=1950000 PD=1360000
.ENDS sky130_fd_sc_hd__nand2b_2

* cell sky130_fd_sc_hd__o21ba_2
* pin VPB
* pin VPWR
* pin B1_N
* pin VGND
* pin X
* pin A2
* pin A1
* pin sky130_gnd
.SUBCKT sky130_fd_sc_hd__o21ba_2 VPB VPWR B1_N VGND X A2 A1 sky130_gnd
* device instance $1 r0 *1 0.47,1.695 sky130_fd_pr__pfet_01v8_hvt
XM$1 \$3 B1_N VPWR VPB sky130_fd_pr__pfet_01v8_hvt L=150000 W=420000
+ AS=109200000000 AD=145750000000 PS=1360000 PD=1335000
* device instance $2 r0 *1 0.955,1.985 sky130_fd_pr__pfet_01v8_hvt
XM$2 VPWR \$2 X VPB sky130_fd_pr__pfet_01v8_hvt L=150000 W=2000000
+ AS=280750000000 AD=530000000000 PS=2605000 PD=3060000
* device instance $4 r0 *1 2.315,1.985 sky130_fd_pr__pfet_01v8_hvt
XM$4 VPWR \$3 \$2 VPB sky130_fd_pr__pfet_01v8_hvt L=150000 W=1000000
+ AS=395000000000 AD=165000000000 PS=1790000 PD=1330000
* device instance $5 r0 *1 2.795,1.985 sky130_fd_pr__pfet_01v8_hvt
XM$5 \$2 A2 \$12 VPB sky130_fd_pr__pfet_01v8_hvt L=150000 W=1000000
+ AS=165000000000 AD=105000000000 PS=1330000 PD=1210000
* device instance $6 r0 *1 3.155,1.985 sky130_fd_pr__pfet_01v8_hvt
XM$6 \$12 A1 VPWR VPB sky130_fd_pr__pfet_01v8_hvt L=150000 W=1000000
+ AS=105000000000 AD=280000000000 PS=1210000 PD=2560000
* device instance $7 r0 *1 2.315,0.56 sky130_fd_pr__nfet_01v8
XM$7 \$2 \$3 \$8 sky130_gnd sky130_fd_pr__nfet_01v8 L=150000 W=650000
+ AS=169000000000 AD=105625000000 PS=1820000 PD=975000
* device instance $8 r0 *1 2.79,0.56 sky130_fd_pr__nfet_01v8
XM$8 \$8 A2 VGND sky130_gnd sky130_fd_pr__nfet_01v8 L=150000 W=650000
+ AS=105625000000 AD=87750000000 PS=975000 PD=920000
* device instance $9 r0 *1 3.21,0.56 sky130_fd_pr__nfet_01v8
XM$9 VGND A1 \$8 sky130_gnd sky130_fd_pr__nfet_01v8 L=150000 W=650000
+ AS=87750000000 AD=169000000000 PS=920000 PD=1820000
* device instance $10 r0 *1 0.47,0.675 sky130_fd_pr__nfet_01v8
XM$10 VGND B1_N \$3 sky130_gnd sky130_fd_pr__nfet_01v8 L=150000 W=420000
+ AS=97000000000 AD=109200000000 PS=975000 PD=1360000
* device instance $11 r0 *1 0.945,0.56 sky130_fd_pr__nfet_01v8
XM$11 VGND \$2 X sky130_gnd sky130_fd_pr__nfet_01v8 L=150000 W=1300000
+ AS=184750000000 AD=256750000000 PS=1895000 PD=2740000
.ENDS sky130_fd_sc_hd__o21ba_2

* cell sky130_fd_sc_hd__nand4_2
* pin VGND
* pin D
* pin C
* pin B
* pin A
* pin VPWR
* pin Y
* pin VPB
* pin sky130_gnd
.SUBCKT sky130_fd_sc_hd__nand4_2 VGND D C B A VPWR Y VPB sky130_gnd
* device instance $1 r0 *1 0.47,1.985 sky130_fd_pr__pfet_01v8_hvt
XM$1 VPWR D Y VPB sky130_fd_pr__pfet_01v8_hvt L=150000 W=2000000
+ AS=395000000000 AD=270000000000 PS=3790000 PD=2540000
* device instance $3 r0 *1 1.31,1.985 sky130_fd_pr__pfet_01v8_hvt
XM$3 VPWR C Y VPB sky130_fd_pr__pfet_01v8_hvt L=150000 W=2000000
+ AS=270000000000 AD=350000000000 PS=2540000 PD=2700000
* device instance $5 r0 *1 2.31,1.985 sky130_fd_pr__pfet_01v8_hvt
XM$5 VPWR B Y VPB sky130_fd_pr__pfet_01v8_hvt L=150000 W=2000000
+ AS=350000000000 AD=470000000000 PS=2700000 PD=2940000
* device instance $7 r0 *1 3.55,1.985 sky130_fd_pr__pfet_01v8_hvt
XM$7 VPWR A Y VPB sky130_fd_pr__pfet_01v8_hvt L=150000 W=2000000
+ AS=470000000000 AD=555000000000 PS=2940000 PD=4110000
* device instance $9 r0 *1 2.71,0.56 sky130_fd_pr__nfet_01v8
XM$9 \$5 B \$4 sky130_gnd sky130_fd_pr__nfet_01v8 L=150000 W=1300000
+ AS=269750000000 AD=175500000000 PS=2780000 PD=1840000
* device instance $11 r0 *1 3.55,0.56 sky130_fd_pr__nfet_01v8
XM$11 \$5 A Y sky130_gnd sky130_fd_pr__nfet_01v8 L=150000 W=1300000
+ AS=175500000000 AD=321750000000 PS=1840000 PD=2940000
* device instance $13 r0 *1 0.47,0.56 sky130_fd_pr__nfet_01v8
XM$13 \$3 D VGND sky130_gnd sky130_fd_pr__nfet_01v8 L=150000 W=1300000
+ AS=256750000000 AD=175500000000 PS=2740000 PD=1840000
* device instance $15 r0 *1 1.31,0.56 sky130_fd_pr__nfet_01v8
XM$15 \$3 C \$4 sky130_gnd sky130_fd_pr__nfet_01v8 L=150000 W=1300000
+ AS=175500000000 AD=269750000000 PS=1840000 PD=2780000
.ENDS sky130_fd_sc_hd__nand4_2

* cell sky130_fd_sc_hd__dfxtp_2
* pin VGND
* pin Q
* pin CLK
* pin D
* pin VPWR
* pin VPB
* pin sky130_gnd
.SUBCKT sky130_fd_sc_hd__dfxtp_2 VGND Q CLK D VPWR VPB sky130_gnd
* device instance $1 r0 *1 1.83,2.275 sky130_fd_pr__pfet_01v8_hvt
XM$1 VPWR D \$6 VPB sky130_fd_pr__pfet_01v8_hvt L=150000 W=420000
+ AS=109200000000 AD=57750000000 PS=1360000 PD=695000
* device instance $2 r0 *1 2.255,2.275 sky130_fd_pr__pfet_01v8_hvt
XM$2 \$6 \$5 \$7 VPB sky130_fd_pr__pfet_01v8_hvt L=150000 W=420000
+ AS=57750000000 AD=68250000000 PS=695000 PD=745000
* device instance $3 r0 *1 2.73,2.275 sky130_fd_pr__pfet_01v8_hvt
XM$3 \$7 \$4 \$17 VPB sky130_fd_pr__pfet_01v8_hvt L=150000 W=420000
+ AS=68250000000 AD=76650000000 PS=745000 PD=785000
* device instance $4 r0 *1 3.245,2.275 sky130_fd_pr__pfet_01v8_hvt
XM$4 VPWR \$8 \$17 VPB sky130_fd_pr__pfet_01v8_hvt L=150000 W=420000
+ AS=178875000000 AD=76650000000 PS=1260000 PD=785000
* device instance $5 r0 *1 3.905,2.11 sky130_fd_pr__pfet_01v8_hvt
XM$5 VPWR \$7 \$8 VPB sky130_fd_pr__pfet_01v8_hvt L=150000 W=750000
+ AS=178875000000 AD=109500000000 PS=1260000 PD=1075000
* device instance $6 r0 *1 4.38,2.275 sky130_fd_pr__pfet_01v8_hvt
XM$6 \$8 \$4 \$9 VPB sky130_fd_pr__pfet_01v8_hvt L=150000 W=420000
+ AS=109500000000 AD=56700000000 PS=1075000 PD=690000
* device instance $7 r0 *1 4.8,2.275 sky130_fd_pr__pfet_01v8_hvt
XM$7 \$9 \$5 \$18 VPB sky130_fd_pr__pfet_01v8_hvt L=150000 W=420000
+ AS=56700000000 AD=88200000000 PS=690000 PD=840000
* device instance $8 r0 *1 5.37,2.275 sky130_fd_pr__pfet_01v8_hvt
XM$8 \$18 \$10 VPWR VPB sky130_fd_pr__pfet_01v8_hvt L=150000 W=420000
+ AS=88200000000 AD=111300000000 PS=840000 PD=1370000
* device instance $9 r0 *1 0.47,2.135 sky130_fd_pr__pfet_01v8_hvt
XM$9 \$4 CLK VPWR VPB sky130_fd_pr__pfet_01v8_hvt L=150000 W=640000
+ AS=166400000000 AD=86400000000 PS=1800000 PD=910000
* device instance $10 r0 *1 0.89,2.135 sky130_fd_pr__pfet_01v8_hvt
XM$10 VPWR \$4 \$5 VPB sky130_fd_pr__pfet_01v8_hvt L=150000 W=640000
+ AS=86400000000 AD=166400000000 PS=910000 PD=1800000
* device instance $11 r0 *1 6.42,1.985 sky130_fd_pr__pfet_01v8_hvt
XM$11 \$10 \$9 VPWR VPB sky130_fd_pr__pfet_01v8_hvt L=150000 W=1000000
+ AS=270000000000 AD=135000000000 PS=2540000 PD=1270000
* device instance $12 r0 *1 6.84,1.985 sky130_fd_pr__pfet_01v8_hvt
XM$12 VPWR \$10 Q VPB sky130_fd_pr__pfet_01v8_hvt L=150000 W=2000000
+ AS=270000000000 AD=395000000000 PS=2540000 PD=3790000
* device instance $14 r0 *1 6.43,0.56 sky130_fd_pr__nfet_01v8
XM$14 \$10 \$9 VGND sky130_gnd sky130_fd_pr__nfet_01v8 L=150000 W=650000
+ AS=169000000000 AD=87750000000 PS=1820000 PD=920000
* device instance $15 r0 *1 6.85,0.56 sky130_fd_pr__nfet_01v8
XM$15 VGND \$10 Q sky130_gnd sky130_fd_pr__nfet_01v8 L=150000 W=1300000
+ AS=175500000000 AD=256750000000 PS=1840000 PD=2740000
* device instance $17 r0 *1 2.39,0.415 sky130_fd_pr__nfet_01v8
XM$17 \$6 \$4 \$7 sky130_gnd sky130_fd_pr__nfet_01v8 L=150000 W=360000
+ AS=81300000000 AD=62100000000 PS=830000 PD=705000
* device instance $18 r0 *1 2.885,0.415 sky130_fd_pr__nfet_01v8
XM$18 \$7 \$5 \$13 sky130_gnd sky130_fd_pr__nfet_01v8 L=150000 W=360000
+ AS=62100000000 AD=69600000000 PS=705000 PD=765000
* device instance $19 r0 *1 4.48,0.415 sky130_fd_pr__nfet_01v8
XM$19 \$8 \$5 \$9 sky130_gnd sky130_fd_pr__nfet_01v8 L=150000 W=360000
+ AS=98900000000 AD=68400000000 PS=995000 PD=740000
* device instance $20 r0 *1 5.01,0.415 sky130_fd_pr__nfet_01v8
XM$20 \$9 \$4 \$12 sky130_gnd sky130_fd_pr__nfet_01v8 L=150000 W=360000
+ AS=68400000000 AD=66000000000 PS=740000 PD=745000
* device instance $21 r0 *1 1.83,0.445 sky130_fd_pr__nfet_01v8
XM$21 VGND D \$6 sky130_gnd sky130_fd_pr__nfet_01v8 L=150000 W=420000
+ AS=109200000000 AD=81300000000 PS=1360000 PD=830000
* device instance $22 r0 *1 3.38,0.445 sky130_fd_pr__nfet_01v8
XM$22 \$13 \$8 VGND sky130_gnd sky130_fd_pr__nfet_01v8 L=150000 W=420000
+ AS=69600000000 AD=120950000000 PS=765000 PD=1085000
* device instance $23 r0 *1 5.485,0.445 sky130_fd_pr__nfet_01v8
XM$23 \$12 \$10 VGND sky130_gnd sky130_fd_pr__nfet_01v8 L=150000 W=420000
+ AS=66000000000 AD=109200000000 PS=745000 PD=1360000
* device instance $24 r0 *1 3.975,0.555 sky130_fd_pr__nfet_01v8
XM$24 VGND \$7 \$8 sky130_gnd sky130_fd_pr__nfet_01v8 L=150000 W=640000
+ AS=120950000000 AD=98900000000 PS=1085000 PD=995000
* device instance $25 r0 *1 0.47,0.445 sky130_fd_pr__nfet_01v8
XM$25 \$4 CLK VGND sky130_gnd sky130_fd_pr__nfet_01v8 L=150000 W=420000
+ AS=109200000000 AD=56700000000 PS=1360000 PD=690000
* device instance $26 r0 *1 0.89,0.445 sky130_fd_pr__nfet_01v8
XM$26 VGND \$4 \$5 sky130_gnd sky130_fd_pr__nfet_01v8 L=150000 W=420000
+ AS=56700000000 AD=109200000000 PS=690000 PD=1360000
.ENDS sky130_fd_sc_hd__dfxtp_2

* cell sky130_fd_sc_hd__a32o_2
* pin VGND
* pin X
* pin B2
* pin A1
* pin A2
* pin B1
* pin A3
* pin VPWR
* pin VPB
* pin sky130_gnd
.SUBCKT sky130_fd_sc_hd__a32o_2 VGND X B2 A1 A2 B1 A3 VPWR VPB sky130_gnd
* device instance $1 r0 *1 1.83,1.985 sky130_fd_pr__pfet_01v8_hvt
XM$1 \$14 B2 \$5 VPB sky130_fd_pr__pfet_01v8_hvt L=150000 W=1000000
+ AS=260000000000 AD=135000000000 PS=2520000 PD=1270000
* device instance $2 r0 *1 2.25,1.985 sky130_fd_pr__pfet_01v8_hvt
XM$2 \$5 B1 \$14 VPB sky130_fd_pr__pfet_01v8_hvt L=150000 W=1000000
+ AS=135000000000 AD=135000000000 PS=1270000 PD=1270000
* device instance $3 r0 *1 2.67,1.985 sky130_fd_pr__pfet_01v8_hvt
XM$3 \$14 A1 VPWR VPB sky130_fd_pr__pfet_01v8_hvt L=150000 W=1000000
+ AS=135000000000 AD=215000000000 PS=1270000 PD=1430000
* device instance $4 r0 *1 3.25,1.985 sky130_fd_pr__pfet_01v8_hvt
XM$4 VPWR A2 \$14 VPB sky130_fd_pr__pfet_01v8_hvt L=150000 W=1000000
+ AS=215000000000 AD=135000000000 PS=1430000 PD=1270000
* device instance $5 r0 *1 3.67,1.985 sky130_fd_pr__pfet_01v8_hvt
XM$5 \$14 A3 VPWR VPB sky130_fd_pr__pfet_01v8_hvt L=150000 W=1000000
+ AS=135000000000 AD=260000000000 PS=1270000 PD=2520000
* device instance $6 r0 *1 0.47,1.985 sky130_fd_pr__pfet_01v8_hvt
XM$6 X \$5 VPWR VPB sky130_fd_pr__pfet_01v8_hvt L=150000 W=2000000
+ AS=395000000000 AD=395000000000 PS=3790000 PD=3790000
* device instance $8 r0 *1 0.47,0.56 sky130_fd_pr__nfet_01v8
XM$8 VGND \$5 X sky130_gnd sky130_fd_pr__nfet_01v8 L=150000 W=1300000
+ AS=256750000000 AD=297375000000 PS=2740000 PD=2215000
* device instance $10 r0 *1 1.685,0.56 sky130_fd_pr__nfet_01v8
XM$10 VGND B2 \$10 sky130_gnd sky130_fd_pr__nfet_01v8 L=150000 W=650000
+ AS=209625000000 AD=115375000000 PS=1295000 PD=1005000
* device instance $11 r0 *1 2.19,0.56 sky130_fd_pr__nfet_01v8
XM$11 \$10 B1 \$5 sky130_gnd sky130_fd_pr__nfet_01v8 L=150000 W=650000
+ AS=115375000000 AD=107250000000 PS=1005000 PD=980000
* device instance $12 r0 *1 2.67,0.56 sky130_fd_pr__nfet_01v8
XM$12 \$5 A1 \$12 sky130_gnd sky130_fd_pr__nfet_01v8 L=150000 W=650000
+ AS=107250000000 AD=139750000000 PS=980000 PD=1080000
* device instance $13 r0 *1 3.25,0.56 sky130_fd_pr__nfet_01v8
XM$13 \$12 A2 \$11 sky130_gnd sky130_fd_pr__nfet_01v8 L=150000 W=650000
+ AS=139750000000 AD=87750000000 PS=1080000 PD=920000
* device instance $14 r0 *1 3.67,0.56 sky130_fd_pr__nfet_01v8
XM$14 \$11 A3 VGND sky130_gnd sky130_fd_pr__nfet_01v8 L=150000 W=650000
+ AS=87750000000 AD=169000000000 PS=920000 PD=1820000
.ENDS sky130_fd_sc_hd__a32o_2

* cell sky130_fd_sc_hd__dfrtp_2
* pin VGND
* pin RESET_B
* pin Q
* pin CLK
* pin D
* pin VPWR
* pin VPB
* pin sky130_gnd
.SUBCKT sky130_fd_sc_hd__dfrtp_2 VGND RESET_B Q CLK D VPWR VPB sky130_gnd
* device instance $1 r0 *1 5.35,2.065 sky130_fd_pr__pfet_01v8_hvt
XM$1 VPWR \$6 \$17 VPB sky130_fd_pr__pfet_01v8_hvt L=150000 W=840000
+ AS=218400000000 AD=129150000000 PS=2200000 PD=1185000
* device instance $2 r0 *1 5.845,2.275 sky130_fd_pr__pfet_01v8_hvt
XM$2 \$17 \$3 \$8 VPB sky130_fd_pr__pfet_01v8_hvt L=150000 W=420000
+ AS=129150000000 AD=58800000000 PS=1185000 PD=700000
* device instance $3 r0 *1 6.275,2.275 sky130_fd_pr__pfet_01v8_hvt
XM$3 \$8 \$4 \$20 VPB sky130_fd_pr__pfet_01v8_hvt L=150000 W=420000
+ AS=58800000000 AD=56700000000 PS=700000 PD=690000
* device instance $4 r0 *1 6.695,2.275 sky130_fd_pr__pfet_01v8_hvt
XM$4 \$20 \$9 VPWR VPB sky130_fd_pr__pfet_01v8_hvt L=150000 W=420000
+ AS=56700000000 AD=81900000000 PS=690000 PD=810000
* device instance $5 r0 *1 7.235,2.275 sky130_fd_pr__pfet_01v8_hvt
XM$5 VPWR RESET_B \$9 VPB sky130_fd_pr__pfet_01v8_hvt L=150000 W=420000
+ AS=81900000000 AD=56700000000 PS=810000 PD=690000
* device instance $6 r0 *1 7.655,2.275 sky130_fd_pr__pfet_01v8_hvt
XM$6 \$9 \$8 VPWR VPB sky130_fd_pr__pfet_01v8_hvt L=150000 W=420000
+ AS=56700000000 AD=113400000000 PS=690000 PD=1380000
* device instance $7 r0 *1 0.47,2.135 sky130_fd_pr__pfet_01v8_hvt
XM$7 \$3 CLK VPWR VPB sky130_fd_pr__pfet_01v8_hvt L=150000 W=640000
+ AS=166400000000 AD=86400000000 PS=1800000 PD=910000
* device instance $8 r0 *1 0.89,2.135 sky130_fd_pr__pfet_01v8_hvt
XM$8 VPWR \$3 \$4 VPB sky130_fd_pr__pfet_01v8_hvt L=150000 W=640000
+ AS=86400000000 AD=166400000000 PS=910000 PD=1800000
* device instance $9 r0 *1 2.225,2.275 sky130_fd_pr__pfet_01v8_hvt
XM$9 VPWR D \$5 VPB sky130_fd_pr__pfet_01v8_hvt L=150000 W=420000
+ AS=109200000000 AD=65100000000 PS=1360000 PD=730000
* device instance $10 r0 *1 2.685,2.275 sky130_fd_pr__pfet_01v8_hvt
XM$10 \$5 \$4 \$6 VPB sky130_fd_pr__pfet_01v8_hvt L=150000 W=420000
+ AS=65100000000 AD=72450000000 PS=730000 PD=765000
* device instance $11 r0 *1 3.18,2.275 sky130_fd_pr__pfet_01v8_hvt
XM$11 \$6 \$3 \$19 VPB sky130_fd_pr__pfet_01v8_hvt L=150000 W=420000
+ AS=72450000000 AD=115500000000 PS=765000 PD=970000
* device instance $12 r0 *1 3.88,2.275 sky130_fd_pr__pfet_01v8_hvt
XM$12 \$19 \$17 VPWR VPB sky130_fd_pr__pfet_01v8_hvt L=150000 W=420000
+ AS=115500000000 AD=70350000000 PS=970000 PD=755000
* device instance $13 r0 *1 4.365,2.275 sky130_fd_pr__pfet_01v8_hvt
XM$13 VPWR RESET_B \$19 VPB sky130_fd_pr__pfet_01v8_hvt L=150000 W=420000
+ AS=70350000000 AD=109200000000 PS=755000 PD=1360000
* device instance $14 r0 *1 8.73,1.985 sky130_fd_pr__pfet_01v8_hvt
XM$14 VPWR \$9 Q VPB sky130_fd_pr__pfet_01v8_hvt L=150000 W=2000000
+ AS=436200000000 AD=395000000000 PS=3930000 PD=3790000
* device instance $16 r0 *1 8.73,0.56 sky130_fd_pr__nfet_01v8
XM$16 VGND \$9 Q sky130_gnd sky130_fd_pr__nfet_01v8 L=150000 W=1300000
+ AS=296450000000 AD=256750000000 PS=2940000 PD=2740000
* device instance $18 r0 *1 2.64,0.415 sky130_fd_pr__nfet_01v8
XM$18 \$5 \$3 \$6 sky130_gnd sky130_fd_pr__nfet_01v8 L=150000 W=360000
+ AS=66000000000 AD=59400000000 PS=745000 PD=690000
* device instance $19 r0 *1 3.12,0.415 sky130_fd_pr__nfet_01v8
XM$19 \$6 \$4 \$13 sky130_gnd sky130_fd_pr__nfet_01v8 L=150000 W=360000
+ AS=59400000000 AD=140100000000 PS=690000 PD=1100000
* device instance $20 r0 *1 5.465,0.415 sky130_fd_pr__nfet_01v8
XM$20 \$17 \$4 \$8 sky130_gnd sky130_fd_pr__nfet_01v8 L=150000 W=360000
+ AS=99900000000 AD=71100000000 PS=985000 PD=755000
* device instance $21 r0 *1 6.01,0.415 sky130_fd_pr__nfet_01v8
XM$21 \$8 \$3 \$12 sky130_gnd sky130_fd_pr__nfet_01v8 L=150000 W=360000
+ AS=71100000000 AD=66900000000 PS=755000 PD=750000
* device instance $22 r0 *1 2.165,0.445 sky130_fd_pr__nfet_01v8
XM$22 VGND D \$5 sky130_gnd sky130_fd_pr__nfet_01v8 L=150000 W=420000
+ AS=220500000000 AD=66000000000 PS=1890000 PD=745000
* device instance $23 r0 *1 3.95,0.445 sky130_fd_pr__nfet_01v8
XM$23 \$13 \$17 \$14 sky130_gnd sky130_fd_pr__nfet_01v8 L=150000 W=420000
+ AS=140100000000 AD=44100000000 PS=1100000 PD=630000
* device instance $24 r0 *1 4.31,0.445 sky130_fd_pr__nfet_01v8
XM$24 \$14 RESET_B VGND sky130_gnd sky130_fd_pr__nfet_01v8 L=150000 W=420000
+ AS=44100000000 AD=134600000000 PS=630000 PD=1150000
* device instance $25 r0 *1 6.49,0.445 sky130_fd_pr__nfet_01v8
XM$25 \$12 \$9 VGND sky130_gnd sky130_fd_pr__nfet_01v8 L=150000 W=420000
+ AS=66900000000 AD=124950000000 PS=750000 PD=1015000
* device instance $26 r0 *1 7.235,0.445 sky130_fd_pr__nfet_01v8
XM$26 VGND RESET_B \$11 sky130_gnd sky130_fd_pr__nfet_01v8 L=150000 W=420000
+ AS=124950000000 AD=64050000000 PS=1015000 PD=725000
* device instance $27 r0 *1 7.69,0.445 sky130_fd_pr__nfet_01v8
XM$27 \$11 \$8 \$9 sky130_gnd sky130_fd_pr__nfet_01v8 L=150000 W=420000
+ AS=64050000000 AD=109200000000 PS=725000 PD=1360000
* device instance $28 r0 *1 4.97,0.555 sky130_fd_pr__nfet_01v8
XM$28 VGND \$6 \$17 sky130_gnd sky130_fd_pr__nfet_01v8 L=150000 W=640000
+ AS=134600000000 AD=99900000000 PS=1150000 PD=985000
* device instance $29 r0 *1 0.47,0.445 sky130_fd_pr__nfet_01v8
XM$29 \$3 CLK VGND sky130_gnd sky130_fd_pr__nfet_01v8 L=150000 W=420000
+ AS=109200000000 AD=56700000000 PS=1360000 PD=690000
* device instance $30 r0 *1 0.89,0.445 sky130_fd_pr__nfet_01v8
XM$30 VGND \$3 \$4 sky130_gnd sky130_fd_pr__nfet_01v8 L=150000 W=420000
+ AS=56700000000 AD=109200000000 PS=690000 PD=1360000
.ENDS sky130_fd_sc_hd__dfrtp_2

* cell sky130_fd_sc_hd__and3_2
* pin VPB
* pin A
* pin VPWR
* pin B
* pin C
* pin VGND
* pin X
* pin sky130_gnd
.SUBCKT sky130_fd_sc_hd__and3_2 VPB A VPWR B C VGND X sky130_gnd
* device instance $1 r0 *1 1.375,1.695 sky130_fd_pr__pfet_01v8_hvt
XM$1 \$5 C VPWR VPB sky130_fd_pr__pfet_01v8_hvt L=150000 W=420000
+ AS=74375000000 AD=150750000000 PS=815000 PD=1345000
* device instance $2 r0 *1 0.48,1.765 sky130_fd_pr__pfet_01v8_hvt
XM$2 \$5 A VPWR VPB sky130_fd_pr__pfet_01v8_hvt L=150000 W=420000
+ AS=109200000000 AD=56700000000 PS=1360000 PD=690000
* device instance $3 r0 *1 0.9,1.765 sky130_fd_pr__pfet_01v8_hvt
XM$3 \$5 B VPWR VPB sky130_fd_pr__pfet_01v8_hvt L=150000 W=420000
+ AS=74375000000 AD=56700000000 PS=815000 PD=690000
* device instance $4 r0 *1 1.87,1.985 sky130_fd_pr__pfet_01v8_hvt
XM$4 VPWR \$5 X VPB sky130_fd_pr__pfet_01v8_hvt L=150000 W=2000000
+ AS=285750000000 AD=395000000000 PS=2615000 PD=3790000
* device instance $6 r0 *1 0.485,0.475 sky130_fd_pr__nfet_01v8
XM$6 \$5 A \$11 sky130_gnd sky130_fd_pr__nfet_01v8 L=150000 W=420000
+ AS=109200000000 AD=44100000000 PS=1360000 PD=630000
* device instance $7 r0 *1 0.845,0.475 sky130_fd_pr__nfet_01v8
XM$7 \$11 B \$10 sky130_gnd sky130_fd_pr__nfet_01v8 L=150000 W=420000
+ AS=44100000000 AD=53550000000 PS=630000 PD=675000
* device instance $8 r0 *1 1.25,0.475 sky130_fd_pr__nfet_01v8
XM$8 VGND C \$10 sky130_gnd sky130_fd_pr__nfet_01v8 L=150000 W=420000
+ AS=130400000000 AD=53550000000 PS=1105000 PD=675000
* device instance $9 r0 *1 1.855,0.56 sky130_fd_pr__nfet_01v8
XM$9 VGND \$5 X sky130_gnd sky130_fd_pr__nfet_01v8 L=150000 W=1300000
+ AS=218150000000 AD=266500000000 PS=2025000 PD=2770000
.ENDS sky130_fd_sc_hd__and3_2

* cell sky130_fd_sc_hd__o31a_2
* pin VGND
* pin X
* pin A1
* pin A2
* pin A3
* pin B1
* pin VPWR
* pin VPB
* pin sky130_gnd
.SUBCKT sky130_fd_sc_hd__o31a_2 VGND X A1 A2 A3 B1 VPWR VPB sky130_gnd
* device instance $1 r0 *1 0.615,1.985 sky130_fd_pr__pfet_01v8_hvt
XM$1 VPWR \$5 X VPB sky130_fd_pr__pfet_01v8_hvt L=150000 W=2000000
+ AS=580000000000 AD=370000000000 PS=4160000 PD=2740000
* device instance $3 r0 *1 1.655,1.985 sky130_fd_pr__pfet_01v8_hvt
XM$3 VPWR A1 \$12 VPB sky130_fd_pr__pfet_01v8_hvt L=150000 W=1000000
+ AS=195000000000 AD=135000000000 PS=1390000 PD=1270000
* device instance $4 r0 *1 2.075,1.985 sky130_fd_pr__pfet_01v8_hvt
XM$4 \$12 A2 \$13 VPB sky130_fd_pr__pfet_01v8_hvt L=150000 W=1000000
+ AS=135000000000 AD=165000000000 PS=1270000 PD=1330000
* device instance $5 r0 *1 2.555,1.985 sky130_fd_pr__pfet_01v8_hvt
XM$5 \$13 A3 \$5 VPB sky130_fd_pr__pfet_01v8_hvt L=150000 W=1000000
+ AS=165000000000 AD=212500000000 PS=1330000 PD=1425000
* device instance $6 r0 *1 3.13,1.985 sky130_fd_pr__pfet_01v8_hvt
XM$6 \$5 B1 VPWR VPB sky130_fd_pr__pfet_01v8_hvt L=150000 W=1000000
+ AS=212500000000 AD=340000000000 PS=1425000 PD=2680000
* device instance $7 r0 *1 0.615,0.56 sky130_fd_pr__nfet_01v8
XM$7 VGND \$5 X sky130_gnd sky130_fd_pr__nfet_01v8 L=150000 W=1300000
+ AS=377000000000 AD=240500000000 PS=3110000 PD=2040000
* device instance $9 r0 *1 1.655,0.56 sky130_fd_pr__nfet_01v8
XM$9 VGND A1 \$4 sky130_gnd sky130_fd_pr__nfet_01v8 L=150000 W=650000
+ AS=126750000000 AD=87750000000 PS=1040000 PD=920000
* device instance $10 r0 *1 2.075,0.56 sky130_fd_pr__nfet_01v8
XM$10 \$4 A2 VGND sky130_gnd sky130_fd_pr__nfet_01v8 L=150000 W=650000
+ AS=87750000000 AD=107250000000 PS=920000 PD=980000
* device instance $11 r0 *1 2.555,0.56 sky130_fd_pr__nfet_01v8
XM$11 VGND A3 \$4 sky130_gnd sky130_fd_pr__nfet_01v8 L=150000 W=650000
+ AS=107250000000 AD=107250000000 PS=980000 PD=980000
* device instance $12 r0 *1 3.035,0.56 sky130_fd_pr__nfet_01v8
XM$12 \$4 B1 \$5 sky130_gnd sky130_fd_pr__nfet_01v8 L=150000 W=650000
+ AS=107250000000 AD=201500000000 PS=980000 PD=1920000
.ENDS sky130_fd_sc_hd__o31a_2

* cell sky130_fd_sc_hd__xnor2_2
* pin VGND
* pin Y
* pin B
* pin A
* pin VPWR
* pin VPB
* pin sky130_gnd
.SUBCKT sky130_fd_sc_hd__xnor2_2 VGND Y B A VPWR VPB sky130_gnd
* device instance $1 r0 *1 4.96,1.985 sky130_fd_pr__pfet_01v8_hvt
XM$1 VPWR \$4 Y VPB sky130_fd_pr__pfet_01v8_hvt L=150000 W=2000000
+ AS=395000000000 AD=415000000000 PS=3790000 PD=3830000
* device instance $3 r0 *1 2.725,1.985 sky130_fd_pr__pfet_01v8_hvt
XM$3 \$10 A VPWR VPB sky130_fd_pr__pfet_01v8_hvt L=150000 W=2000000
+ AS=415000000000 AD=270000000000 PS=3830000 PD=2540000
* device instance $5 r0 *1 3.565,1.985 sky130_fd_pr__pfet_01v8_hvt
XM$5 \$10 B Y VPB sky130_fd_pr__pfet_01v8_hvt L=150000 W=2000000
+ AS=287500000000 AD=412500000000 PS=2575000 PD=3825000
* device instance $7 r0 *1 0.485,1.985 sky130_fd_pr__pfet_01v8_hvt
XM$7 \$4 B VPWR VPB sky130_fd_pr__pfet_01v8_hvt L=150000 W=2000000
+ AS=410000000000 AD=270000000000 PS=3820000 PD=2540000
* device instance $9 r0 *1 1.325,1.985 sky130_fd_pr__pfet_01v8_hvt
XM$9 \$4 A VPWR VPB sky130_fd_pr__pfet_01v8_hvt L=150000 W=2000000
+ AS=270000000000 AD=415000000000 PS=2540000 PD=3830000
* device instance $11 r0 *1 4.96,0.56 sky130_fd_pr__nfet_01v8
XM$11 Y \$4 \$5 sky130_gnd sky130_fd_pr__nfet_01v8 L=150000 W=1300000
+ AS=256750000000 AD=256750000000 PS=2740000 PD=2740000
* device instance $13 r0 *1 2.725,0.56 sky130_fd_pr__nfet_01v8
XM$13 VGND A \$5 sky130_gnd sky130_fd_pr__nfet_01v8 L=150000 W=1300000
+ AS=269750000000 AD=175500000000 PS=2780000 PD=1840000
* device instance $15 r0 *1 3.565,0.56 sky130_fd_pr__nfet_01v8
XM$15 VGND B \$5 sky130_gnd sky130_fd_pr__nfet_01v8 L=150000 W=1300000
+ AS=186875000000 AD=268125000000 PS=1875000 PD=2775000
* device instance $17 r0 *1 0.485,0.56 sky130_fd_pr__nfet_01v8
XM$17 \$3 B \$4 sky130_gnd sky130_fd_pr__nfet_01v8 L=150000 W=1300000
+ AS=266500000000 AD=175500000000 PS=2770000 PD=1840000
* device instance $19 r0 *1 1.325,0.56 sky130_fd_pr__nfet_01v8
XM$19 \$3 A VGND sky130_gnd sky130_fd_pr__nfet_01v8 L=150000 W=1300000
+ AS=175500000000 AD=269750000000 PS=1840000 PD=2780000
.ENDS sky130_fd_sc_hd__xnor2_2

* cell sky130_fd_sc_hd__inv_2
* pin VPB
* pin VGND
* pin VPWR
* pin Y
* pin A
* pin sky130_gnd
.SUBCKT sky130_fd_sc_hd__inv_2 VPB VGND VPWR Y A sky130_gnd
* device instance $1 r0 *1 0.48,1.985 sky130_fd_pr__pfet_01v8_hvt
XM$1 VPWR A Y VPB sky130_fd_pr__pfet_01v8_hvt L=150000 W=2000000
+ AS=395000000000 AD=395000000000 PS=3790000 PD=3790000
* device instance $3 r0 *1 0.48,0.56 sky130_fd_pr__nfet_01v8
XM$3 VGND A Y sky130_gnd sky130_fd_pr__nfet_01v8 L=150000 W=1300000
+ AS=256750000000 AD=256750000000 PS=2740000 PD=2740000
.ENDS sky130_fd_sc_hd__inv_2

* cell sky130_fd_sc_hd__and2_2
* pin VPB
* pin VPWR
* pin A
* pin B
* pin X
* pin VGND
* pin sky130_gnd
.SUBCKT sky130_fd_sc_hd__and2_2 VPB VPWR A B X VGND sky130_gnd
* device instance $1 r0 *1 0.66,2.065 sky130_fd_pr__pfet_01v8_hvt
XM$1 VPWR A \$2 VPB sky130_fd_pr__pfet_01v8_hvt L=150000 W=420000
+ AS=117600000000 AD=56700000000 PS=1400000 PD=690000
* device instance $2 r0 *1 1.08,2.065 sky130_fd_pr__pfet_01v8_hvt
XM$2 VPWR B \$2 VPB sky130_fd_pr__pfet_01v8_hvt L=150000 W=420000
+ AS=166550000000 AD=56700000000 PS=1390000 PD=690000
* device instance $3 r0 *1 1.62,1.985 sky130_fd_pr__pfet_01v8_hvt
XM$3 VPWR \$2 X VPB sky130_fd_pr__pfet_01v8_hvt L=150000 W=2000000
+ AS=361550000000 AD=575000000000 PS=2780000 PD=4150000
* device instance $5 r0 *1 0.66,0.585 sky130_fd_pr__nfet_01v8
XM$5 \$2 A \$9 sky130_gnd sky130_fd_pr__nfet_01v8 L=150000 W=420000
+ AS=117600000000 AD=56700000000 PS=1400000 PD=690000
* device instance $6 r0 *1 1.08,0.585 sky130_fd_pr__nfet_01v8
XM$6 VGND B \$9 sky130_gnd sky130_fd_pr__nfet_01v8 L=150000 W=420000
+ AS=111800000000 AD=56700000000 PS=1040000 PD=690000
* device instance $7 r0 *1 1.62,0.56 sky130_fd_pr__nfet_01v8
XM$7 VGND \$2 X sky130_gnd sky130_fd_pr__nfet_01v8 L=150000 W=1300000
+ AS=238550000000 AD=373750000000 PS=2080000 PD=3100000
.ENDS sky130_fd_sc_hd__and2_2

* cell sky130_fd_sc_hd__a22o_2
* pin VGND
* pin B2
* pin B1
* pin A1
* pin A2
* pin X
* pin VPWR
* pin VPB
* pin sky130_gnd
.SUBCKT sky130_fd_sc_hd__a22o_2 VGND B2 B1 A1 A2 X VPWR VPB sky130_gnd
* device instance $1 r0 *1 1.83,1.985 sky130_fd_pr__pfet_01v8_hvt
XM$1 VPWR A1 \$11 VPB sky130_fd_pr__pfet_01v8_hvt L=150000 W=1000000
+ AS=260000000000 AD=165000000000 PS=2520000 PD=1330000
* device instance $2 r0 *1 2.31,1.985 sky130_fd_pr__pfet_01v8_hvt
XM$2 \$11 A2 VPWR VPB sky130_fd_pr__pfet_01v8_hvt L=150000 W=1000000
+ AS=165000000000 AD=157500000000 PS=1330000 PD=1315000
* device instance $3 r0 *1 2.775,1.985 sky130_fd_pr__pfet_01v8_hvt
XM$3 VPWR \$5 X VPB sky130_fd_pr__pfet_01v8_hvt L=150000 W=2000000
+ AS=292500000000 AD=405000000000 PS=2585000 PD=3810000
* device instance $5 r0 *1 0.47,1.985 sky130_fd_pr__pfet_01v8_hvt
XM$5 \$5 B2 \$11 VPB sky130_fd_pr__pfet_01v8_hvt L=150000 W=1000000
+ AS=260000000000 AD=135000000000 PS=2520000 PD=1270000
* device instance $6 r0 *1 0.89,1.985 sky130_fd_pr__pfet_01v8_hvt
XM$6 \$11 B1 \$5 VPB sky130_fd_pr__pfet_01v8_hvt L=150000 W=1000000
+ AS=135000000000 AD=260000000000 PS=1270000 PD=2520000
* device instance $7 r0 *1 1.83,0.56 sky130_fd_pr__nfet_01v8
XM$7 \$5 A1 \$10 sky130_gnd sky130_fd_pr__nfet_01v8 L=150000 W=650000
+ AS=169000000000 AD=107250000000 PS=1820000 PD=980000
* device instance $8 r0 *1 2.31,0.56 sky130_fd_pr__nfet_01v8
XM$8 \$10 A2 VGND sky130_gnd sky130_fd_pr__nfet_01v8 L=150000 W=650000
+ AS=107250000000 AD=102375000000 PS=980000 PD=965000
* device instance $9 r0 *1 2.775,0.56 sky130_fd_pr__nfet_01v8
XM$9 VGND \$5 X sky130_gnd sky130_fd_pr__nfet_01v8 L=150000 W=1300000
+ AS=190125000000 AD=263250000000 PS=1885000 PD=2760000
* device instance $11 r0 *1 0.47,0.56 sky130_fd_pr__nfet_01v8
XM$11 VGND B2 \$9 sky130_gnd sky130_fd_pr__nfet_01v8 L=150000 W=650000
+ AS=169000000000 AD=74750000000 PS=1820000 PD=880000
* device instance $12 r0 *1 0.85,0.56 sky130_fd_pr__nfet_01v8
XM$12 \$9 B1 \$5 sky130_gnd sky130_fd_pr__nfet_01v8 L=150000 W=650000
+ AS=74750000000 AD=169000000000 PS=880000 PD=1820000
.ENDS sky130_fd_sc_hd__a22o_2

* cell sky130_fd_sc_hd__nand2_2
* pin VPB
* pin VPWR
* pin Y
* pin B
* pin VGND
* pin A
* pin sky130_gnd
.SUBCKT sky130_fd_sc_hd__nand2_2 VPB VPWR Y B VGND A sky130_gnd
* device instance $1 r0 *1 0.47,1.985 sky130_fd_pr__pfet_01v8_hvt
XM$1 VPWR B Y VPB sky130_fd_pr__pfet_01v8_hvt L=150000 W=2000000
+ AS=395000000000 AD=270000000000 PS=3790000 PD=2540000
* device instance $3 r0 *1 1.31,1.985 sky130_fd_pr__pfet_01v8_hvt
XM$3 VPWR A Y VPB sky130_fd_pr__pfet_01v8_hvt L=150000 W=2000000
+ AS=270000000000 AD=395000000000 PS=2540000 PD=3790000
* device instance $5 r0 *1 0.47,0.56 sky130_fd_pr__nfet_01v8
XM$5 \$3 B VGND sky130_gnd sky130_fd_pr__nfet_01v8 L=150000 W=1300000
+ AS=256750000000 AD=175500000000 PS=2740000 PD=1840000
* device instance $7 r0 *1 1.31,0.56 sky130_fd_pr__nfet_01v8
XM$7 \$3 A Y sky130_gnd sky130_fd_pr__nfet_01v8 L=150000 W=1300000
+ AS=175500000000 AD=256750000000 PS=1840000 PD=2740000
.ENDS sky130_fd_sc_hd__nand2_2

* cell sky130_fd_sc_hd__xor2_2
* pin VGND
* pin A
* pin B
* pin X
* pin VPWR
* pin VPB
* pin sky130_gnd
.SUBCKT sky130_fd_sc_hd__xor2_2 VGND A B X VPWR VPB sky130_gnd
* device instance $1 r0 *1 4.94,1.985 sky130_fd_pr__pfet_01v8_hvt
XM$1 \$8 \$3 X VPB sky130_fd_pr__pfet_01v8_hvt L=150000 W=2000000
+ AS=395000000000 AD=415000000000 PS=3790000 PD=3830000
* device instance $3 r0 *1 2.685,1.985 sky130_fd_pr__pfet_01v8_hvt
XM$3 \$8 A VPWR VPB sky130_fd_pr__pfet_01v8_hvt L=150000 W=2000000
+ AS=395000000000 AD=270000000000 PS=3790000 PD=2540000
* device instance $5 r0 *1 3.525,1.985 sky130_fd_pr__pfet_01v8_hvt
XM$5 \$8 B VPWR VPB sky130_fd_pr__pfet_01v8_hvt L=150000 W=2000000
+ AS=297500000000 AD=422500000000 PS=2595000 PD=3845000
* device instance $7 r0 *1 0.485,1.985 sky130_fd_pr__pfet_01v8_hvt
XM$7 \$9 A VPWR VPB sky130_fd_pr__pfet_01v8_hvt L=150000 W=2000000
+ AS=410000000000 AD=270000000000 PS=3820000 PD=2540000
* device instance $9 r0 *1 1.325,1.985 sky130_fd_pr__pfet_01v8_hvt
XM$9 \$9 B \$3 VPB sky130_fd_pr__pfet_01v8_hvt L=150000 W=2000000
+ AS=270000000000 AD=395000000000 PS=2540000 PD=3790000
* device instance $11 r0 *1 4.94,0.56 sky130_fd_pr__nfet_01v8
XM$11 VGND \$3 X sky130_gnd sky130_fd_pr__nfet_01v8 L=150000 W=1300000
+ AS=256750000000 AD=256750000000 PS=2740000 PD=2740000
* device instance $13 r0 *1 2.685,0.56 sky130_fd_pr__nfet_01v8
XM$13 \$6 A VGND sky130_gnd sky130_fd_pr__nfet_01v8 L=150000 W=1300000
+ AS=256750000000 AD=175500000000 PS=2740000 PD=1840000
* device instance $15 r0 *1 3.525,0.56 sky130_fd_pr__nfet_01v8
XM$15 \$6 B X sky130_gnd sky130_fd_pr__nfet_01v8 L=150000 W=1300000
+ AS=193375000000 AD=274625000000 PS=1895000 PD=2795000
* device instance $17 r0 *1 0.485,0.56 sky130_fd_pr__nfet_01v8
XM$17 VGND A \$3 sky130_gnd sky130_fd_pr__nfet_01v8 L=150000 W=1300000
+ AS=266500000000 AD=175500000000 PS=2770000 PD=1840000
* device instance $19 r0 *1 1.325,0.56 sky130_fd_pr__nfet_01v8
XM$19 VGND B \$3 sky130_gnd sky130_fd_pr__nfet_01v8 L=150000 W=1300000
+ AS=175500000000 AD=256750000000 PS=1840000 PD=2740000
.ENDS sky130_fd_sc_hd__xor2_2

* cell sky130_fd_sc_hd__a21o_2
* pin VPB
* pin VPWR
* pin VGND
* pin X
* pin B1
* pin A1
* pin A2
* pin sky130_gnd
.SUBCKT sky130_fd_sc_hd__a21o_2 VPB VPWR VGND X B1 A1 A2 sky130_gnd
* device instance $1 r0 *1 1.855,1.985 sky130_fd_pr__pfet_01v8_hvt
XM$1 \$6 B1 \$2 VPB sky130_fd_pr__pfet_01v8_hvt L=150000 W=1000000
+ AS=265000000000 AD=140000000000 PS=2530000 PD=1280000
* device instance $2 r0 *1 2.285,1.985 sky130_fd_pr__pfet_01v8_hvt
XM$2 \$2 A1 VPWR VPB sky130_fd_pr__pfet_01v8_hvt L=150000 W=1000000
+ AS=140000000000 AD=157500000000 PS=1280000 PD=1315000
* device instance $3 r0 *1 2.75,1.985 sky130_fd_pr__pfet_01v8_hvt
XM$3 VPWR A2 \$2 VPB sky130_fd_pr__pfet_01v8_hvt L=150000 W=1000000
+ AS=157500000000 AD=260000000000 PS=1315000 PD=2520000
* device instance $4 r0 *1 0.475,1.985 sky130_fd_pr__pfet_01v8_hvt
XM$4 VPWR \$6 X VPB sky130_fd_pr__pfet_01v8_hvt L=150000 W=2000000
+ AS=405000000000 AD=405000000000 PS=3810000 PD=3810000
* device instance $6 r0 *1 0.645,0.56 sky130_fd_pr__nfet_01v8
XM$6 VGND \$6 X sky130_gnd sky130_fd_pr__nfet_01v8 L=150000 W=1300000
+ AS=263250000000 AD=201500000000 PS=2760000 PD=1920000
* device instance $8 r0 *1 1.565,0.56 sky130_fd_pr__nfet_01v8
XM$8 VGND B1 \$6 sky130_gnd sky130_fd_pr__nfet_01v8 L=150000 W=650000
+ AS=110500000000 AD=162500000000 PS=990000 PD=1150000
* device instance $9 r0 *1 2.215,0.56 sky130_fd_pr__nfet_01v8
XM$9 \$6 A1 \$11 sky130_gnd sky130_fd_pr__nfet_01v8 L=150000 W=650000
+ AS=162500000000 AD=123500000000 PS=1150000 PD=1030000
* device instance $10 r0 *1 2.745,0.56 sky130_fd_pr__nfet_01v8
XM$10 \$11 A2 VGND sky130_gnd sky130_fd_pr__nfet_01v8 L=150000 W=650000
+ AS=123500000000 AD=172250000000 PS=1030000 PD=1830000
.ENDS sky130_fd_sc_hd__a21o_2

* cell sky130_fd_sc_hd__or4_2
* pin VPB
* pin VGND
* pin C
* pin B
* pin A
* pin VPWR
* pin X
* pin D
* pin sky130_gnd
.SUBCKT sky130_fd_sc_hd__or4_2 VPB VGND C B A VPWR X D sky130_gnd
* device instance $1 r0 *1 0.47,1.695 sky130_fd_pr__pfet_01v8_hvt
XM$1 \$5 D \$13 VPB sky130_fd_pr__pfet_01v8_hvt L=150000 W=420000
+ AS=109200000000 AD=69300000000 PS=1360000 PD=750000
* device instance $2 r0 *1 0.95,1.695 sky130_fd_pr__pfet_01v8_hvt
XM$2 \$13 C \$12 VPB sky130_fd_pr__pfet_01v8_hvt L=150000 W=420000
+ AS=69300000000 AD=44100000000 PS=750000 PD=630000
* device instance $3 r0 *1 1.31,1.695 sky130_fd_pr__pfet_01v8_hvt
XM$3 \$12 B \$11 VPB sky130_fd_pr__pfet_01v8_hvt L=150000 W=420000
+ AS=44100000000 AD=69300000000 PS=630000 PD=750000
* device instance $4 r0 *1 1.79,1.695 sky130_fd_pr__pfet_01v8_hvt
XM$4 \$11 A VPWR VPB sky130_fd_pr__pfet_01v8_hvt L=150000 W=420000
+ AS=69300000000 AD=148250000000 PS=750000 PD=1340000
* device instance $5 r0 *1 2.28,1.985 sky130_fd_pr__pfet_01v8_hvt
XM$5 VPWR \$5 X VPB sky130_fd_pr__pfet_01v8_hvt L=150000 W=2000000
+ AS=283250000000 AD=440000000000 PS=2610000 PD=3880000
* device instance $7 r0 *1 0.47,0.475 sky130_fd_pr__nfet_01v8
XM$7 VGND D \$5 sky130_gnd sky130_fd_pr__nfet_01v8 L=150000 W=420000
+ AS=109200000000 AD=69300000000 PS=1360000 PD=750000
* device instance $8 r0 *1 0.95,0.475 sky130_fd_pr__nfet_01v8
XM$8 \$5 C VGND sky130_gnd sky130_fd_pr__nfet_01v8 L=150000 W=420000
+ AS=69300000000 AD=56700000000 PS=750000 PD=690000
* device instance $9 r0 *1 1.37,0.475 sky130_fd_pr__nfet_01v8
XM$9 VGND B \$5 sky130_gnd sky130_fd_pr__nfet_01v8 L=150000 W=420000
+ AS=56700000000 AD=56700000000 PS=690000 PD=690000
* device instance $10 r0 *1 1.79,0.475 sky130_fd_pr__nfet_01v8
XM$10 VGND A \$5 sky130_gnd sky130_fd_pr__nfet_01v8 L=150000 W=420000
+ AS=101875000000 AD=56700000000 PS=990000 PD=690000
* device instance $11 r0 *1 2.28,0.56 sky130_fd_pr__nfet_01v8
XM$11 VGND \$5 X sky130_gnd sky130_fd_pr__nfet_01v8 L=150000 W=1300000
+ AS=189625000000 AD=286000000000 PS=1910000 PD=2830000
.ENDS sky130_fd_sc_hd__or4_2

* cell sky130_fd_sc_hd__or2_2
* pin VPB
* pin X
* pin VPWR
* pin VGND
* pin B
* pin A
* pin sky130_gnd
.SUBCKT sky130_fd_sc_hd__or2_2 VPB X VPWR VGND B A sky130_gnd
* device instance $1 r0 *1 0.53,1.695 sky130_fd_pr__pfet_01v8_hvt
XM$1 \$3 B \$9 VPB sky130_fd_pr__pfet_01v8_hvt L=150000 W=420000
+ AS=109200000000 AD=44100000000 PS=1360000 PD=630000
* device instance $2 r0 *1 0.89,1.695 sky130_fd_pr__pfet_01v8_hvt
XM$2 \$9 A VPWR VPB sky130_fd_pr__pfet_01v8_hvt L=150000 W=420000
+ AS=44100000000 AD=155750000000 PS=630000 PD=1355000
* device instance $3 r0 *1 1.395,1.985 sky130_fd_pr__pfet_01v8_hvt
XM$3 VPWR \$3 X VPB sky130_fd_pr__pfet_01v8_hvt L=150000 W=2000000
+ AS=290750000000 AD=395000000000 PS=2625000 PD=3790000
* device instance $5 r0 *1 0.47,0.445 sky130_fd_pr__nfet_01v8
XM$5 VGND B \$3 sky130_gnd sky130_fd_pr__nfet_01v8 L=150000 W=420000
+ AS=109200000000 AD=56700000000 PS=1360000 PD=690000
* device instance $6 r0 *1 0.89,0.445 sky130_fd_pr__nfet_01v8
XM$6 \$3 A VGND sky130_gnd sky130_fd_pr__nfet_01v8 L=150000 W=420000
+ AS=56700000000 AD=106750000000 PS=690000 PD=1005000
* device instance $7 r0 *1 1.395,0.56 sky130_fd_pr__nfet_01v8
XM$7 VGND \$3 X sky130_gnd sky130_fd_pr__nfet_01v8 L=150000 W=1300000
+ AS=194500000000 AD=256750000000 PS=1925000 PD=2740000
.ENDS sky130_fd_sc_hd__or2_2

* cell sky130_fd_sc_hd__o21a_2
* pin VPB
* pin VGND
* pin VPWR
* pin X
* pin B1
* pin A2
* pin A1
* pin sky130_gnd
.SUBCKT sky130_fd_sc_hd__o21a_2 VPB VGND VPWR X B1 A2 A1 sky130_gnd
* device instance $1 r0 *1 0.47,1.985 sky130_fd_pr__pfet_01v8_hvt
XM$1 VPWR \$5 X VPB sky130_fd_pr__pfet_01v8_hvt L=150000 W=2000000
+ AS=397500000000 AD=537500000000 PS=3795000 PD=3075000
* device instance $3 r0 *1 1.845,1.985 sky130_fd_pr__pfet_01v8_hvt
XM$3 VPWR B1 \$5 VPB sky130_fd_pr__pfet_01v8_hvt L=150000 W=1000000
+ AS=400000000000 AD=140000000000 PS=1800000 PD=1280000
* device instance $4 r0 *1 2.275,1.985 sky130_fd_pr__pfet_01v8_hvt
XM$4 \$5 A2 \$11 VPB sky130_fd_pr__pfet_01v8_hvt L=150000 W=1000000
+ AS=140000000000 AD=160000000000 PS=1280000 PD=1320000
* device instance $5 r0 *1 2.745,1.985 sky130_fd_pr__pfet_01v8_hvt
XM$5 \$11 A1 VPWR VPB sky130_fd_pr__pfet_01v8_hvt L=150000 W=1000000
+ AS=160000000000 AD=265000000000 PS=1320000 PD=2530000
* device instance $6 r0 *1 1.845,0.56 sky130_fd_pr__nfet_01v8
XM$6 \$5 B1 \$7 sky130_gnd sky130_fd_pr__nfet_01v8 L=150000 W=650000
+ AS=172250000000 AD=91000000000 PS=1830000 PD=930000
* device instance $7 r0 *1 2.275,0.56 sky130_fd_pr__nfet_01v8
XM$7 \$7 A2 VGND sky130_gnd sky130_fd_pr__nfet_01v8 L=150000 W=650000
+ AS=91000000000 AD=104000000000 PS=930000 PD=970000
* device instance $8 r0 *1 2.745,0.56 sky130_fd_pr__nfet_01v8
XM$8 VGND A1 \$7 sky130_gnd sky130_fd_pr__nfet_01v8 L=150000 W=650000
+ AS=104000000000 AD=172250000000 PS=970000 PD=1830000
* device instance $9 r0 *1 0.47,0.56 sky130_fd_pr__nfet_01v8
XM$9 VGND \$5 X sky130_gnd sky130_fd_pr__nfet_01v8 L=150000 W=1300000
+ AS=258375000000 AD=261625000000 PS=2745000 PD=2755000
.ENDS sky130_fd_sc_hd__o21a_2

* cell sky130_fd_sc_hd__a31o_2
* pin VPB
* pin X
* pin A3
* pin A2
* pin VPWR
* pin A1
* pin VGND
* pin B1
* pin sky130_gnd
.SUBCKT sky130_fd_sc_hd__a31o_2 VPB X A3 A2 VPWR A1 VGND B1 sky130_gnd
* device instance $1 r0 *1 0.47,1.985 sky130_fd_pr__pfet_01v8_hvt
XM$1 VPWR \$8 X VPB sky130_fd_pr__pfet_01v8_hvt L=150000 W=2000000
+ AS=395000000000 AD=270000000000 PS=3790000 PD=2540000
* device instance $3 r0 *1 1.31,1.985 sky130_fd_pr__pfet_01v8_hvt
XM$3 VPWR A3 \$4 VPB sky130_fd_pr__pfet_01v8_hvt L=150000 W=1000000
+ AS=135000000000 AD=135000000000 PS=1270000 PD=1270000
* device instance $4 r0 *1 1.73,1.985 sky130_fd_pr__pfet_01v8_hvt
XM$4 \$4 A2 VPWR VPB sky130_fd_pr__pfet_01v8_hvt L=150000 W=1000000
+ AS=135000000000 AD=165000000000 PS=1270000 PD=1330000
* device instance $5 r0 *1 2.21,1.985 sky130_fd_pr__pfet_01v8_hvt
XM$5 VPWR A1 \$4 VPB sky130_fd_pr__pfet_01v8_hvt L=150000 W=1000000
+ AS=165000000000 AD=165000000000 PS=1330000 PD=1330000
* device instance $6 r0 *1 2.69,1.985 sky130_fd_pr__pfet_01v8_hvt
XM$6 \$4 B1 \$8 VPB sky130_fd_pr__pfet_01v8_hvt L=150000 W=1000000
+ AS=165000000000 AD=320000000000 PS=1330000 PD=2640000
* device instance $7 r0 *1 0.47,0.56 sky130_fd_pr__nfet_01v8
XM$7 VGND \$8 X sky130_gnd sky130_fd_pr__nfet_01v8 L=150000 W=1300000
+ AS=256750000000 AD=175500000000 PS=2740000 PD=1840000
* device instance $9 r0 *1 1.31,0.56 sky130_fd_pr__nfet_01v8
XM$9 VGND A3 \$13 sky130_gnd sky130_fd_pr__nfet_01v8 L=150000 W=650000
+ AS=87750000000 AD=87750000000 PS=920000 PD=920000
* device instance $10 r0 *1 1.73,0.56 sky130_fd_pr__nfet_01v8
XM$10 \$13 A2 \$12 sky130_gnd sky130_fd_pr__nfet_01v8 L=150000 W=650000
+ AS=87750000000 AD=107250000000 PS=920000 PD=980000
* device instance $11 r0 *1 2.21,0.56 sky130_fd_pr__nfet_01v8
XM$11 \$12 A1 \$8 sky130_gnd sky130_fd_pr__nfet_01v8 L=150000 W=650000
+ AS=107250000000 AD=126750000000 PS=980000 PD=1040000
* device instance $12 r0 *1 2.75,0.56 sky130_fd_pr__nfet_01v8
XM$12 \$8 B1 VGND sky130_gnd sky130_fd_pr__nfet_01v8 L=150000 W=650000
+ AS=126750000000 AD=169000000000 PS=1040000 PD=1820000
.ENDS sky130_fd_sc_hd__a31o_2

* cell sky130_fd_sc_hd__a211oi_2
* pin VGND
* pin Y
* pin C1
* pin B1
* pin A1
* pin A2
* pin VPWR
* pin VPB
* pin sky130_gnd
.SUBCKT sky130_fd_sc_hd__a211oi_2 VGND Y C1 B1 A1 A2 VPWR VPB sky130_gnd
* device instance $1 r0 *1 2.765,1.985 sky130_fd_pr__pfet_01v8_hvt
XM$1 VPWR A1 \$10 VPB sky130_fd_pr__pfet_01v8_hvt L=150000 W=2000000
+ AS=405000000000 AD=280000000000 PS=3810000 PD=2560000
* device instance $3 r0 *1 3.625,1.985 sky130_fd_pr__pfet_01v8_hvt
XM$3 VPWR A2 \$10 VPB sky130_fd_pr__pfet_01v8_hvt L=150000 W=2000000
+ AS=280000000000 AD=405000000000 PS=2560000 PD=3810000
* device instance $5 r0 *1 0.525,1.985 sky130_fd_pr__pfet_01v8_hvt
XM$5 \$9 C1 Y VPB sky130_fd_pr__pfet_01v8_hvt L=150000 W=2000000
+ AS=405000000000 AD=280000000000 PS=3810000 PD=2560000
* device instance $7 r0 *1 1.385,1.985 sky130_fd_pr__pfet_01v8_hvt
XM$7 \$9 B1 \$10 VPB sky130_fd_pr__pfet_01v8_hvt L=150000 W=2000000
+ AS=280000000000 AD=405000000000 PS=2560000 PD=3810000
* device instance $9 r0 *1 2.765,0.56 sky130_fd_pr__nfet_01v8
XM$9 \$4 A1 Y sky130_gnd sky130_fd_pr__nfet_01v8 L=150000 W=1300000
+ AS=263250000000 AD=182000000000 PS=2760000 PD=1860000
* device instance $11 r0 *1 3.625,0.56 sky130_fd_pr__nfet_01v8
XM$11 \$4 A2 VGND sky130_gnd sky130_fd_pr__nfet_01v8 L=150000 W=1300000
+ AS=182000000000 AD=263250000000 PS=1860000 PD=2760000
* device instance $13 r0 *1 0.525,0.56 sky130_fd_pr__nfet_01v8
XM$13 VGND C1 Y sky130_gnd sky130_fd_pr__nfet_01v8 L=150000 W=1300000
+ AS=263250000000 AD=182000000000 PS=2760000 PD=1860000
* device instance $15 r0 *1 1.385,0.56 sky130_fd_pr__nfet_01v8
XM$15 VGND B1 Y sky130_gnd sky130_fd_pr__nfet_01v8 L=150000 W=1300000
+ AS=182000000000 AD=263250000000 PS=1860000 PD=2760000
.ENDS sky130_fd_sc_hd__a211oi_2

* cell sky130_fd_sc_hd__a211o_2
* pin VPB
* pin VPWR
* pin VGND
* pin X
* pin A2
* pin C1
* pin A1
* pin B1
* pin sky130_gnd
.SUBCKT sky130_fd_sc_hd__a211o_2 VPB VPWR VGND X A2 C1 A1 B1 sky130_gnd
* device instance $1 r0 *1 1.83,1.985 sky130_fd_pr__pfet_01v8_hvt
XM$1 \$7 A2 VPWR VPB sky130_fd_pr__pfet_01v8_hvt L=150000 W=1000000
+ AS=260000000000 AD=195000000000 PS=2520000 PD=1390000
* device instance $2 r0 *1 2.37,1.985 sky130_fd_pr__pfet_01v8_hvt
XM$2 VPWR A1 \$7 VPB sky130_fd_pr__pfet_01v8_hvt L=150000 W=1000000
+ AS=195000000000 AD=165000000000 PS=1390000 PD=1330000
* device instance $3 r0 *1 2.85,1.985 sky130_fd_pr__pfet_01v8_hvt
XM$3 \$7 B1 \$13 VPB sky130_fd_pr__pfet_01v8_hvt L=150000 W=1000000
+ AS=165000000000 AD=105000000000 PS=1330000 PD=1210000
* device instance $4 r0 *1 3.21,1.985 sky130_fd_pr__pfet_01v8_hvt
XM$4 \$13 C1 \$9 VPB sky130_fd_pr__pfet_01v8_hvt L=150000 W=1000000
+ AS=105000000000 AD=260000000000 PS=1210000 PD=2520000
* device instance $5 r0 *1 0.47,1.985 sky130_fd_pr__pfet_01v8_hvt
XM$5 VPWR \$9 X VPB sky130_fd_pr__pfet_01v8_hvt L=150000 W=2000000
+ AS=395000000000 AD=395000000000 PS=3790000 PD=3790000
* device instance $7 r0 *1 0.47,0.56 sky130_fd_pr__nfet_01v8
XM$7 VGND \$9 X sky130_gnd sky130_fd_pr__nfet_01v8 L=150000 W=1300000
+ AS=260000000000 AD=290875000000 PS=2750000 PD=2195000
* device instance $9 r0 *1 1.665,0.56 sky130_fd_pr__nfet_01v8
XM$9 VGND A2 \$12 sky130_gnd sky130_fd_pr__nfet_01v8 L=150000 W=650000
+ AS=199875000000 AD=133250000000 PS=1265000 PD=1060000
* device instance $10 r0 *1 2.225,0.56 sky130_fd_pr__nfet_01v8
XM$10 \$12 A1 \$9 sky130_gnd sky130_fd_pr__nfet_01v8 L=150000 W=650000
+ AS=133250000000 AD=115375000000 PS=1060000 PD=1005000
* device instance $11 r0 *1 2.73,0.56 sky130_fd_pr__nfet_01v8
XM$11 \$9 B1 VGND sky130_gnd sky130_fd_pr__nfet_01v8 L=150000 W=650000
+ AS=115375000000 AD=107250000000 PS=1005000 PD=980000
* device instance $12 r0 *1 3.21,0.56 sky130_fd_pr__nfet_01v8
XM$12 VGND C1 \$9 sky130_gnd sky130_fd_pr__nfet_01v8 L=150000 W=650000
+ AS=107250000000 AD=169000000000 PS=980000 PD=1820000
.ENDS sky130_fd_sc_hd__a211o_2

* cell sky130_fd_sc_hd__clkbuf_8
* pin VGND
* pin A
* pin X
* pin VPWR
* pin VPB
* pin sky130_gnd
.SUBCKT sky130_fd_sc_hd__clkbuf_8 VGND A X VPWR VPB sky130_gnd
* device instance $1 r0 *1 0.475,1.985 sky130_fd_pr__pfet_01v8_hvt
XM$1 VPWR A \$2 VPB sky130_fd_pr__pfet_01v8_hvt L=150000 W=2000000
+ AS=405000000000 AD=280000000000 PS=3810000 PD=2560000
* device instance $3 r0 *1 1.335,1.985 sky130_fd_pr__pfet_01v8_hvt
XM$3 VPWR \$2 X VPB sky130_fd_pr__pfet_01v8_hvt L=150000 W=8000000 AS=1.12e+12
+ AD=1.245e+12 PS=10240000 PD=11490000
* device instance $11 r0 *1 0.475,0.445 sky130_fd_pr__nfet_01v8
XM$11 VGND A \$2 sky130_gnd sky130_fd_pr__nfet_01v8 L=150000 W=840000
+ AS=170100000000 AD=117600000000 PS=2070000 PD=1400000
* device instance $13 r0 *1 1.335,0.445 sky130_fd_pr__nfet_01v8
XM$13 VGND \$2 X sky130_gnd sky130_fd_pr__nfet_01v8 L=150000 W=3360000
+ AS=470400000000 AD=525000000000 PS=5600000 PD=6280000
.ENDS sky130_fd_sc_hd__clkbuf_8

* cell sky130_fd_sc_hd__clkbuf_4
* pin VPB
* pin VGND
* pin VPWR
* pin A
* pin sky130_gnd
.SUBCKT sky130_fd_sc_hd__clkbuf_4 VPB VGND VPWR A sky130_gnd
* device instance $1 r0 *1 0.475,1.985 sky130_fd_pr__pfet_01v8_hvt
XM$1 \$3 A VPWR VPB sky130_fd_pr__pfet_01v8_hvt L=150000 W=1000000
+ AS=265000000000 AD=165000000000 PS=2530000 PD=1330000
* device instance $2 r0 *1 0.955,1.985 sky130_fd_pr__pfet_01v8_hvt
XM$2 VPWR \$3 X VPB sky130_fd_pr__pfet_01v8_hvt L=150000 W=4000000
+ AS=585000000000 AD=720000000000 PS=5170000 PD=6440000
* device instance $6 r0 *1 0.475,0.445 sky130_fd_pr__nfet_01v8
XM$6 \$3 A VGND sky130_gnd sky130_fd_pr__nfet_01v8 L=150000 W=420000
+ AS=111300000000 AD=70350000000 PS=1370000 PD=755000
* device instance $7 r0 *1 0.96,0.445 sky130_fd_pr__nfet_01v8
XM$7 VGND \$3 X sky130_gnd sky130_fd_pr__nfet_01v8 L=150000 W=1680000
+ AS=246750000000 AD=298200000000 PS=2855000 PD=3520000
.ENDS sky130_fd_sc_hd__clkbuf_4

* cell sky130_fd_sc_hd__decap_3
* pin VPB
* pin VGND
* pin VPWR
* pin sky130_gnd
.SUBCKT sky130_fd_sc_hd__decap_3 VPB VGND VPWR sky130_gnd
* device instance $1 r0 *1 0.69,2.05 sky130_fd_pr__pfet_01v8_hvt
XM$1 VPWR VGND VPWR VPB sky130_fd_pr__pfet_01v8_hvt L=590000 W=870000
+ AS=226200000000 AD=226200000000 PS=2260000 PD=2260000
* device instance $2 r0 *1 0.69,0.51 sky130_fd_pr__nfet_01v8
XM$2 VGND VPWR VGND sky130_gnd sky130_fd_pr__nfet_01v8 L=590000 W=550000
+ AS=143000000000 AD=143000000000 PS=1620000 PD=1620000
.ENDS sky130_fd_sc_hd__decap_3

* cell sky130_fd_sc_hd__tapvpwrvgnd_1
* pin VPWR
* pin VGND
.SUBCKT sky130_fd_sc_hd__tapvpwrvgnd_1 VPWR VGND
.ENDS sky130_fd_sc_hd__tapvpwrvgnd_1
