* Handwritten netlist for puzzle
*.include "C:/Users/mwern/KLayout/salt/Efabless_sky130/tech/sky130/lvs/standard_cells/include_hd.cdl"
*.include "include_hd.cdl"
.include "subckts.spice"
*.include "layout_only.renamed.spice"

.SUBCKT puzzle I O[0] O[1] O[2] O[3] O[4] O[5] O[6] O[7] VGND VPWR clk enable rst_n success

*clkbuf sch: A VGND VNB VPB VPWR X
*clkbuf_16 lay: VGND A X VPWR VPB sky130_gnd
Xclkd VGND clk clkd VPWR VPWR VGND sky130_fd_sc_hd__clkbuf_16

* clkbuf_8 sch: A VGND VNB VPB VPWR X
* clkbuf_8 lay:  VGND A X VPWR VPB sky130_gnd

X$46 VGND clkd \$1875 VPWR VPWR VGND sky130_fd_sc_hd__clkbuf_8
X$47 VGND clkd \$3876 VPWR VPWR VGND sky130_fd_sc_hd__clkbuf_8
X$48 VGND clkd \$784 VPWR VPWR VGND sky130_fd_sc_hd__clkbuf_8
X$49 VGND clkd \$2217 VPWR VPWR VGND sky130_fd_sc_hd__clkbuf_8
X$50 VGND clkd \$3881 VPWR VPWR VGND sky130_fd_sc_hd__clkbuf_8
X$51 VGND clkd \$2289 VPWR VPWR VGND sky130_fd_sc_hd__clkbuf_8
X$52 VGND clkd \$3272 VPWR VPWR VGND sky130_fd_sc_hd__clkbuf_8
X$53 VGND clkd \$2295 VPWR VPWR VGND sky130_fd_sc_hd__clkbuf_8
X$54 VGND clkd \$983 VPWR VPWR VGND sky130_fd_sc_hd__clkbuf_8
X$55 VGND clkd \$1649 VPWR VPWR VGND sky130_fd_sc_hd__clkbuf_8
X$56 VGND clkd \$1460 VPWR VPWR VGND sky130_fd_sc_hd__clkbuf_8
X$57 VGND clkd \$2734 VPWR VPWR VGND sky130_fd_sc_hd__clkbuf_8
X$59 VGND clkd \$3673 VPWR \$I13875 VGND sky130_fd_sc_hd__clkbuf_8
X$60 VGND clkd \$2156 VPWR \$I13868 VGND sky130_fd_sc_hd__clkbuf_8
X$61 VGND clkd \$3182 VPWR \$I13866 VGND sky130_fd_sc_hd__clkbuf_8
X$2135 VGND clkd \$729 VPWR VPWR VGND sky130_fd_sc_hd__clkbuf_8

* cell sky130_fd_sc_hd__dfrtp_2: d flop with reset_b
*.SUBCKT sky130_fd_sc_hd__dfrtp_2 VGND RESET_B Q CLK D VPWR VPB sky130_gnd
X$185 VGND rst_n Q00 \$2295 D00 VPWR VPWR VGND sky130_fd_sc_hd__dfrtp_2
X$211 VGND rst_n Q01 \$2217 D01 VPWR VPWR VGND sky130_fd_sc_hd__dfrtp_2
X$247 VGND rst_n Q02 \$2295 D02 VPWR \$I12667 VGND sky130_fd_sc_hd__dfrtp_2
X$220 VGND rst_n Q03 \$2289 D03 VPWR VPWR VGND sky130_fd_sc_hd__dfrtp_2
X$193 VGND rst_n Q04 \$2217 D04 VPWR VPWR VGND sky130_fd_sc_hd__dfrtp_2
X$229 VGND rst_n Q05 \$1875 D05 VPWR VPWR VGND sky130_fd_sc_hd__dfrtp_2
X$184 VGND rst_n Q06 \$2289 D06 VPWR VPWR VGND sky130_fd_sc_hd__dfrtp_2
X$226 VGND rst_n Q07 \$1875 D07 VPWR VPWR VGND sky130_fd_sc_hd__dfrtp_2
X$190 VGND rst_n Q08 \$1875 D08 VPWR VPWR VGND sky130_fd_sc_hd__dfrtp_2
X$246 VGND rst_n Q09 \$1875 D09 VPWR VPWR VGND sky130_fd_sc_hd__dfrtp_2
X$243 VGND rst_n Q10 \$2289 D10 VPWR VPWR VGND sky130_fd_sc_hd__dfrtp_2
X$244 VGND rst_n Q11 \$2289 D11 VPWR VPWR VGND sky130_fd_sc_hd__dfrtp_2

*.SUBCKT sky130_fd_sc_hd__a31o_2 VPB X A3 A2 VPWR A1 VGND B1 sky130_gnd
X$499 VPWR \$3200 select \$1507 VPWR \$1558 VGND \$3143 VGND sky130_fd_sc_hd__a31o_2

*.SUBCKT sky130_fd_sc_hd__mux2_1 VGND X A1 A0 S VPWR VPB sky130_gnd
X$586 VGND D00 I Q00 select VPWR VPWR VGND sky130_fd_sc_hd__mux2_1
X$595 VGND D01 Q00 Q01 select VPWR VPWR VGND sky130_fd_sc_hd__mux2_1
X$583 VGND D02 Q01 Q02 select VPWR VPWR VGND sky130_fd_sc_hd__mux2_1
X$591 VGND D03 Q02 Q03 select VPWR VPWR VGND sky130_fd_sc_hd__mux2_1
X$593 VGND D04 Q03 Q04 select VPWR VPWR VGND sky130_fd_sc_hd__mux2_1
X$579 VGND D05 Q04 Q05 select VPWR VPWR VGND sky130_fd_sc_hd__mux2_1
X$587 VGND D06 Q05 Q06 select VPWR VPWR VGND sky130_fd_sc_hd__mux2_1
X$580 VGND D07 Q06 Q07 select VPWR VPWR VGND sky130_fd_sc_hd__mux2_1
X$578 VGND D08 Q07 Q08 select VPWR VPWR VGND sky130_fd_sc_hd__mux2_1
X$574 VGND D09 Q08 Q09 select VPWR VPWR VGND sky130_fd_sc_hd__mux2_1
X$581 VGND D10 Q09 Q10 select VPWR VPWR VGND sky130_fd_sc_hd__mux2_1
X$575 VGND D11 Q10 Q11 select VPWR VPWR VGND sky130_fd_sc_hd__mux2_1

X$576 VGND \$430 \$306 \$58 \$31 VPWR VPWR VGND sky130_fd_sc_hd__mux2_1

X$582 VGND \$1695 \$1773 \$1558 \$1700 VPWR VPWR VGND sky130_fd_sc_hd__mux2_1
X$584 VGND \$1702 \$1783 \$1650 \$1652 VPWR VPWR VGND sky130_fd_sc_hd__mux2_1
X$588 VGND \$1538 \$1566 \$1564 \$347 VPWR VPWR VGND sky130_fd_sc_hd__mux2_1
X$589 VGND \$627 \$317 \$631 \$49 VPWR VPWR VGND sky130_fd_sc_hd__mux2_1
X$592 VGND \$856 \$83 \$811 \$572 VPWR VPWR VGND sky130_fd_sc_hd__mux2_1
X$594 VGND \$558 \$35 \$30 \$51 VPWR VPWR VGND sky130_fd_sc_hd__mux2_1
X$596 VGND \$2048 rand3 rand0 rand2 VPWR \$I13343 VGND sky130_fd_sc_hd__mux2_1
X$2596 VGND \$83 \$120 \$72 \$49 VPWR VPWR VGND sky130_fd_sc_hd__mux2_1

*** trace Q bus **
*.SUBCKT sky130_fd_sc_hd__a22o_2 VGND B2 B1 A1 A2 X VPWR VPB sky130_gnd A1A2+B1B2
X$354 VGND Q11 \$1787 \$1705 Q00 \$2286 VPWR VPWR VGND sky130_fd_sc_hd__a22o_2
X$585 VPWR VGND \$1787 VPWR \$1705 VGND sky130_fd_sc_hd__buf_2
*.SUBCKT sky130_fd_sc_hd__or4_2 VPB VGND C B A VPWR X D sky130_gnd
X$436 VPWR VGND \$425 \$27 \$340 VPWR \$1705 combi864 VGND sky130_fd_sc_hd__or4_2
*.SUBCKT sky130_fd_sc_hd__or4bb_2 VGND X C_N D_N A VPWR B VPB sky130_gnd
X$360 VGND \$1733 combi864 \$27 \$340 VPWR \$425 VPWR VGND sky130_fd_sc_hd__or4bb_2

*.SUBCKT sky130_fd_sc_hd__a221o_2 VGND C1 B2 B1 A1 A2 X VPWR VPB sky130_gnd
X$169 VGND \$2286 Q10 VPWR \$1733 Q09 \$2419 VPWR VPWR VGND sky130_fd_sc_hd__a221o_2

X$205 VGND rst_n \$340 \$2217 \$2491 VPWR VPWR VGND sky130_fd_sc_hd__dfrtp_2
*.SUBCKT sky130_fd_sc_hd__nor2_2 VPB VGND A Y B VPWR sky130_gnd
X$2548 VPWR VGND \$1558 \$2492 \$2441 VPWR VGND sky130_fd_sc_hd__nor2_2

X$218 VGND rst_n \$425 \$2217 \$2247 VPWR VPWR VGND sky130_fd_sc_hd__dfrtp_2
*.SUBCKT sky130_fd_sc_hd__xor2_2 VGND A B X VPWR VPB sky130_gnd
X$481 VGND \$425 \$2173 \$2247 VPWR VPWR VGND sky130_fd_sc_hd__xor2_2

X$238 VGND rst_n \$27 \$2217 \$2324 VPWR VPWR VGND sky130_fd_sc_hd__dfrtp_2
*.SUBCKT sky130_fd_sc_hd__a211oi_2 VGND Y C1 B1 A1 A2 VPWR VPB sky130_gnd
X$23 VGND \$2324 \$2173 \$2406 select \$1558 VPWR VPWR VGND ky130_fd_sc_hd__a221oi_2

X$234 VGND rst_n combi864 \$2217 \$2537 VPWR VPWR VGND sky130_fd_sc_hd__dfrtp_2
*.SUBCKT sky130_fd_sc_hd__a221oi_2 VGND C1 Y B2 B1 A2 A1 VPWR VPB sky130_gnd
X$235 VGND \$2577 \$2537 combi864 \$2321 \$1558 select VPWR VPWR VGND

*.SUBCKT sky130_fd_sc_hd__a31o_2 VPB X VPWR A3 A2 A1 VGND B1 sky130_gnd
*X$496 VPWR \$2438 VPWR \$2419 select I VGND \$2266 VGND sky130_fd_sc_hd__a31o_2
*.SUBCKT sky130_fd_sc_hd__a31o_2 VPB X A3 A2 VPWR A1 VGND B1 sky130_gnd
X$496 VPWR \$2438 \$2420 select VPWR I VGND \$2266 VGND sky130_fd_sc_hd__a31o_2

*.SUBCKT sky130_fd_sc_hd__a32o_2 VGND X B2 A1 A2 B1 A3 VPWR VPB sky130_gnd
X$397 VGND \$4214 \$4255 \$4211 \$4203 \$3967 \$4252 VPWR VPWR VGND sky130_fd_sc_hd__a32o_2
* $4214 is D for flop $261, Q is $3967
* .SUBCKT sky130_fd_sc_hd__and4bb_2 VGND X C D B_N A_N VPWR VPB sky130_gnd
X$301 VGND \$1558 combi864 \$27 \$425 \$340 VPWR VPWR VGND sky130_fd_sc_hd__and4bb_2

*.SUBCKT sky130_fd_sc_hd__dfxtp_2 VGND Q CLK D VPWR VPB sky130_gnd
X$9 VGND rand0 \$3588 \$3994 VPWR VPWR VGND sky130_fd_sc_hd__dfxtp_2
X$10 VGND rand1 \$3588 \$3919 VPWR VPWR VGND sky130_fd_sc_hd__dfxtp_2
X$11 VGND rand2 \$3066 \$4002 VPWR VPWR VGND sky130_fd_sc_hd__dfxtp_2
X$539 VGND rand3 \$3066 \$3882 VPWR VPWR VGND sky130_fd_sc_hd__dfxtp_2

*.SUBCKT sky130_fd_sc_hd__dfstp_2 VGND SET_B Q CLK D VPWR VPB sky130_gnd
X$12 VGND rst_n \$2651 \$3066 \$3068 VPWR VPWR VGND sky130_fd_sc_hd__dfstp_2
X$13 VGND rst_n \$2906 \$2728 \$2987 VPWR VPWR VGND sky130_fd_sc_hd__dfstp_2
X$14 VGND rst_n \$2753 \$2728 \$2921 VPWR VPWR VGND sky130_fd_sc_hd__dfstp_2
X$404 VGND rst_n \$2815 \$2728 \$2743 VPWR VPWR VGND sky130_fd_sc_hd__dfstp_2

* clkbuf_4: drives nothing
*.SUBCKT sky130_fd_sc_hd__clkbuf_4 VPB VGND VPWR A sky130_gnd

X$62 VPWR VGND VPWR \$2289 VGND sky130_fd_sc_hd__clkbuf_4
X$63 \$I13875 VGND VPWR \$3673 VGND sky130_fd_sc_hd__clkbuf_4
X$64 VPWR VGND VPWR \$3272 VGND sky130_fd_sc_hd__clkbuf_4
X$65 VPWR VGND VPWR \$1875 VGND sky130_fd_sc_hd__clkbuf_4
X$66 VPWR VGND VPWR \$1460 VGND sky130_fd_sc_hd__clkbuf_4
X$67 VPWR VGND VPWR \$3881 VGND sky130_fd_sc_hd__clkbuf_4
X$68 VPWR VGND VPWR \$983 VGND sky130_fd_sc_hd__clkbuf_4
X$69 VPWR VGND VPWR \$1649 VGND sky130_fd_sc_hd__clkbuf_4
X$70 VPWR VGND VPWR \$2734 VGND sky130_fd_sc_hd__clkbuf_4
X$71 VPWR VGND VPWR \$784 VGND sky130_fd_sc_hd__clkbuf_4
X$72 \$I13868 VGND VPWR \$2155 VGND sky130_fd_sc_hd__clkbuf_4
X$73 VPWR VGND VPWR \$3876 VGND sky130_fd_sc_hd__clkbuf_4
X$74 VPWR VGND VPWR \$2217 VGND sky130_fd_sc_hd__clkbuf_4
X$75 VPWR VGND VPWR \$2295 VGND sky130_fd_sc_hd__clkbuf_4
X$2134 VPWR VGND VPWR \$729 VGND sky130_fd_sc_hd__clkbuf_4

*** select ***
*.SUBCKT sky130_fd_sc_hd__and2b_2 VPB A_N VPWR B VGND X sky130_gnd
X$386 VPWR \$3143 VPWR enable VGND select VGND sky130_fd_sc_hd__and2b_2
*.SUBCKT sky130_fd_sc_hd__o21a_2 VPB VGND VPWR X B1 A2 A1 sky130_gnd
X$1734 VPWR VGND VPWR \$3159 \$3156 \$3155 \$3151 VGND sky130_fd_sc_hd__o21a_2
*.SUBCKT sky130_fd_sc_hd__or4_2 VPB VGND C B A VPWR X D sky130_gnd
X$441 VPWR VGND \$3158 \$3227 \$3162 VPWR \$3156 \$3157 VGND sky130_fd_sc_hd__or4_2
*.SUBCKT sky130_fd_sc_hd__a21o_2 VPB VPWR VGND X B1 A1 A2 sky130_gnd
X$271 VPWR VPWR VGND \$3245 \$3162 \$3151 \$3155 VGND sky130_fd_sc_hd__a21o_2
X$2558 VPWR VGND \$3158 \$3155 \$3157 VPWR VGND sky130_fd_sc_hd__nor2_2
X$242 VGND rst_n \$3151 \$3182 \$3159 VPWR VPWR VGND sky130_fd_sc_hd__dfrtp_2

* nand4_2 sch: inst A B C D VGND VNB VPB VPWR Y
* nand4_2 lay: inst VGND D C B A VPWR Y VPB sky130_gnd

X$147 VGND \$1288 \$1287 select I VPWR \$1261 VPWR VGND sky130_fd_sc_hd__nand4_2
X$148 VGND \$3767 \$3765 select I VPWR \$3805 VPWR VGND sky130_fd_sc_hd__nand4_2
X$149 VGND \$4034 \$4033 select I VPWR \$4124 VPWR VGND sky130_fd_sc_hd__nand4_2
X$150 VGND \$4242 \$4197 select I VPWR \$4238 VPWR VGND sky130_fd_sc_hd__nand4_2
X$151 VGND \$1439 \$1454 select I VPWR \$1582 VPWR VGND sky130_fd_sc_hd__nand4_2
X$152 VGND \$2018 \$2016 select I VPWR \$2076 VPWR VGND sky130_fd_sc_hd__nand4_2
X$153 VGND \$2145 \$2210 select I VPWR \$2294 VPWR VGND sky130_fd_sc_hd__nand4_2
X$154 VGND \$1740 \$1742 select I VPWR \$1743 VPWR VGND sky130_fd_sc_hd__nand4_2
X$155 VGND \$3568 \$3481 select I VPWR \$3529 VPWR VGND sky130_fd_sc_hd__nand4_2
X$156 VGND \$3960 \$3896 select I VPWR \$3898 VPWR VGND sky130_fd_sc_hd__nand4_2
X$157 VGND \$4294 \$4285 select I VPWR \$4352 VPWR VGND sky130_fd_sc_hd__nand4_2

X$1758 VPWR VGND VPWR \$3490 or4b_85_x VGND sky130_fd_sc_hd__inv_2

*.SUBCKT sky130_fd_sc_hd__and3_2 VPB A VPWR B C VGND X sky130_gnd
X$552 \$I10290 out_en1 VPWR \$3623 out_en2 VGND O[5] VGND sky130_fd_sc_hd__and3_2
X$554 VPWR out_en1 VPWR \$3620 out_en2 VGND O[3] VGND sky130_fd_sc_hd__and3_2
X$556 VPWR out_en1 VPWR \$3628 out_en2 VGND O[4] VGND sky130_fd_sc_hd__and3_2
X$557 VPWR out_en1 VPWR \$3504 out_en2 VGND O[6] VGND sky130_fd_sc_hd__and3_2
X$558 VPWR out_en1 VPWR \$3874 out_en2 VGND O[1] VGND sky130_fd_sc_hd__and3_2
X$569 VPWR out_en1 VPWR \$3515 out_en2 VGND O[7] VGND sky130_fd_sc_hd__and3_2
X$572 VPWR out_en1 VPWR \$3734 out_en2 VGND O[0] VGND sky130_fd_sc_hd__and3_2
X$573 VPWR out_en1 VPWR \$3497 out_en2 VGND O[2] VGND sky130_fd_sc_hd__and3_2

*** success output pin  ***
X$209 VGND rst_n success \$3673 success_stage VPWR VPWR VGND sky130_fd_sc_hd__dfrtp_2
*.SUBCKT sky130_fd_sc_hd__o21ba_2 VPB VPWR B1_N VGND X A2 A1 sky130_gnd
X$291 VPWR VPWR or4b_85_c VGND \$4041 \$3981 success VGND sky130_fd_sc_hd__o21ba_2
*** success staged $4257 ***
*.SUBCKT sky130_fd_sc_hd__a32o_2 VGND X B2 A1 A2 B1 A3 VPWR VPB sky130_gnd
X$396 VGND success_stage \$4255 \$2270 \$4203 success \$4252 VPWR VPWR VGND sky130_fd_sc_hd__a32o_2
*.SUBCKT sky130_fd_sc_hd__nand2b_2 VPB B VPWR VGND Y A_N sky130_gnd
X$331 VPWR \$3143 VPWR VGND \$4255 \$3846 VGND sky130_fd_sc_hd__nand2b_2
X$187 VGND rst_n \$3143 \$2295 \$3200 VPWR VPWR VGND sky130_fd_sc_hd__dfrtp_2
X$25 VGND \$3143 \$374 \$4252 \$3846 \$2454 VPWR VPWR VGND sky130_fd_sc_hd__and4b_2
X$2534 VPWR \$4316 VPWR VGND \$3846 \$3143 VGND sky130_fd_sc_hd__or2_2

*.SUBCKT sky130_fd_sc_hd__inv_2 VPB VGND VPWR Y A sky130_gnd
X$1770 VPWR VGND VPWR success_b success VGND sky130_fd_sc_hd__inv_2
*.SUBCKT sky130_fd_sc_hd__or4b_2 VPB \$2 VGND C B A VPWR X \$9 D_N \$12 \$13 \$14 sky130_gnd
*X$85 VPWR \$I13766 VGND \$1103 success \$737 VPWR \$3913 \$I13783 \$3981 \$I13713 \$I13721 \$I13745 VGND sky130_fd_sc_hd__or4b_2
*.SUBCKT sky130_fd_sc_hd__or4b_2_ref A B C D_N VGND VNB VPB VPWR X
Xref85 or4b_85_a success or4b_85_c  or4b_86_db VGND VGND VPWR VPWR or4b_85_x sky130_fd_sc_hd__or4b_2_ref

*XM$31 \$I13721 success \$I13745 VPWR sky130_fd_pr__pfet_01v8_hvt L=.150000 W=.420000
*XM$86 \$I13766 success VGND VGND sky130_fd_pr__nfet_01v8 L=.150000 W=.420000
X$182 VGND or4b_85_a \$689 \$688 \$609 \$730 VPWR VPWR VGND sky130_fd_sc_hd__nor4b_2
X$2587 VPWR VGND or4b_85_a \$3385 \$4042 VPWR VGND sky130_fd_sc_hd__nor2_2

*** success_b ***
*.SUBCKT sky130_fd_sc_hd__a211oi_2 VGND Y C1 B1 A1 A2 VPWR VPB sky130_gnd
X$22 VGND \$3437 or4b_85_a or4b_85_c success_b \$3981 VPWR VPWR VGND sky130_fd_sc_hd__a211oi_2

*.SUBCKT sky130_fd_sc_hd__and3_2 VPB A VPWR B C VGND X sky130_gnd
X$555 VPWR \$1038 \$1096 \$880 VGND VPWR or4b_85_c VGND sky130_fd_sc_hd__and3_2

*** gated inputs **
*.SUBCKT sky130_fd_sc_hd__nand2_2 VPB VPWR Y B VGND A sky130_gnd
X$2494 VPWR VPWR Ib_2494 select VGND I VGND sky130_fd_sc_hd__nand2_2
X$2495 VPWR VPWR Ib_2495 select VGND I VGND sky130_fd_sc_hd__nand2_2
X$2500 VPWR VPWR Ib_2500 select VGND I VGND sky130_fd_sc_hd__nand2_2
X$2505 VPWR VPWR Ib_2505 select VGND I VGND sky130_fd_sc_hd__nand2_2
X$2511 VPWR VPWR Ib_2511 select VGND I VGND sky130_fd_sc_hd__nand2_2
X$2512 VPWR VPWR Ib_2512 select VGND I VGND sky130_fd_sc_hd__nand2_2
X$2514 VPWR VPWR Ib_2514 select VGND I VGND sky130_fd_sc_hd__nand2_2
X$2520 VPWR VPWR Ib_2520 select VGND I VGND sky130_fd_sc_hd__nand2_2

X$2526 \$I280 VPWR \$1650 I VGND \$1730 VGND sky130_fd_sc_hd__nand2_2

.ENDS puzzle

*** Std Cells that need special definition
* cell sky130_fd_sc_hd__conb_1
* pin VPB
* pin HI,VPWR
* pin LO,VGND
*.SUBCKT sky130_fd_sc_hd__conb_1 VPB HI LO
*.ENDS sky130_fd_sc_hd__conb_1
