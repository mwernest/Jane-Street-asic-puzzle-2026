* Extracted by KLayout with SKY130 LVS runset on : 28/08/2026 14:29

* cell sky130_fd_sc_hd__or4b_2
* pin A
* pin B
* pin C
* pin D_N
* pin VGND
* pin VPB
* pin VPWR
* pin X
* pin sky130_gnd
.SUBCKT sky130_fd_sc_hd__or4b_2 A B C D_N VGND VPB VPWR X sky130_gnd
* device instance $1 r0 *1 0.47,1.695 sky130_fd_pr__pfet_01v8_hvt
XM$1 \$9 D_N VPWR VPB sky130_fd_pr__pfet_01v8_hvt L=0.15 W=0.42 AS=0.1092
+ AD=0.1693 PS=1.36 PD=1.5
* device instance $2 r0 *1 1.86,1.695 sky130_fd_pr__pfet_01v8_hvt
XM$2 VPWR A \$14 VPB sky130_fd_pr__pfet_01v8_hvt L=0.15 W=0.42 AS=0.16835
+ AD=0.0693 PS=1.495 PD=0.75
* device instance $3 r0 *1 2.34,1.695 sky130_fd_pr__pfet_01v8_hvt
XM$3 \$14 B \$13 VPB sky130_fd_pr__pfet_01v8_hvt L=0.15 W=0.42 AS=0.0693
+ AD=0.0441 PS=0.75 PD=0.63
* device instance $4 r0 *1 2.7,1.695 sky130_fd_pr__pfet_01v8_hvt
XM$4 \$13 C \$12 VPB sky130_fd_pr__pfet_01v8_hvt L=0.15 W=0.42 AS=0.0441
+ AD=0.0693 PS=0.63 PD=0.75
* device instance $5 r0 *1 3.18,1.695 sky130_fd_pr__pfet_01v8_hvt
XM$5 \$12 \$9 \$2 VPB sky130_fd_pr__pfet_01v8_hvt L=0.15 W=0.42 AS=0.0693
+ AD=0.1092 PS=0.75 PD=1.36
* device instance $6 r0 *1 0.955,1.985 sky130_fd_pr__pfet_01v8_hvt
XM$6 VPWR \$2 X VPB sky130_fd_pr__pfet_01v8_hvt L=0.15 W=2 AS=0.3043 AD=0.30335
+ PS=2.77 PD=2.765
* device instance $8 r0 *1 0.47,0.475 sky130_fd_pr__nfet_01v8
XM$8 VGND D_N \$9 sky130_gnd sky130_fd_pr__nfet_01v8 L=0.15 W=0.42 AS=0.10025
+ AD=0.1092 PS=0.985 PD=1.36
* device instance $9 r0 *1 1.86,0.475 sky130_fd_pr__nfet_01v8
XM$9 VGND A \$2 sky130_gnd sky130_fd_pr__nfet_01v8 L=0.15 W=0.42 AS=0.10025
+ AD=0.0693 PS=0.985 PD=0.75
* device instance $10 r0 *1 2.34,0.475 sky130_fd_pr__nfet_01v8
XM$10 \$2 B VGND sky130_gnd sky130_fd_pr__nfet_01v8 L=0.15 W=0.42 AS=0.0693
+ AD=0.0567 PS=0.75 PD=0.69
* device instance $11 r0 *1 2.76,0.475 sky130_fd_pr__nfet_01v8
XM$11 VGND C \$2 sky130_gnd sky130_fd_pr__nfet_01v8 L=0.15 W=0.42 AS=0.0567
+ AD=0.0567 PS=0.69 PD=0.69
* device instance $12 r0 *1 3.18,0.475 sky130_fd_pr__nfet_01v8
XM$12 \$2 \$9 VGND sky130_gnd sky130_fd_pr__nfet_01v8 L=0.15 W=0.42 AS=0.0567
+ AD=0.1092 PS=0.69 PD=1.36
* device instance $13 r0 *1 0.955,0.56 sky130_fd_pr__nfet_01v8
XM$13 VGND \$2 X sky130_gnd sky130_fd_pr__nfet_01v8 L=0.15 W=1.3 AS=0.188
+ AD=0.188 PS=1.905 PD=1.905
.ENDS sky130_fd_sc_hd__or4b_2
